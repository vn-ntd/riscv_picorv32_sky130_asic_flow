* NGSPICE file created from picorv32.ext - technology: sky130A

* Black-box entry subcircuit for sky130_fd_sc_hd__fill_2 abstract view
.subckt sky130_fd_sc_hd__fill_2 VGND VNB VPB VPWR
.ends

* Black-box entry subcircuit for sky130_fd_sc_hd__a21o_1 abstract view
.subckt sky130_fd_sc_hd__a21o_1 A1 A2 B1 VGND VNB VPB VPWR X
.ends

* Black-box entry subcircuit for sky130_fd_sc_hd__fill_1 abstract view
.subckt sky130_fd_sc_hd__fill_1 VGND VNB VPB VPWR
.ends

* Black-box entry subcircuit for sky130_fd_sc_hd__nor2_1 abstract view
.subckt sky130_fd_sc_hd__nor2_1 A B VGND VNB VPB VPWR Y
.ends

* Black-box entry subcircuit for sky130_fd_sc_hd__decap_4 abstract view
.subckt sky130_fd_sc_hd__decap_4 VGND VNB VPB VPWR
.ends

* Black-box entry subcircuit for sky130_fd_sc_hd__decap_8 abstract view
.subckt sky130_fd_sc_hd__decap_8 VGND VNB VPB VPWR
.ends

* Black-box entry subcircuit for sky130_fd_sc_hd__decap_3 abstract view
.subckt sky130_fd_sc_hd__decap_3 VGND VNB VPB VPWR
.ends

* Black-box entry subcircuit for sky130_fd_sc_hd__mux2_1 abstract view
.subckt sky130_fd_sc_hd__mux2_1 A0 A1 S VGND VNB VPB VPWR X
.ends

* Black-box entry subcircuit for sky130_fd_sc_hd__buf_4 abstract view
.subckt sky130_fd_sc_hd__buf_4 A VGND VNB VPB VPWR X
.ends

* Black-box entry subcircuit for sky130_fd_sc_hd__dlygate4sd3_1 abstract view
.subckt sky130_fd_sc_hd__dlygate4sd3_1 A VGND VNB VPB VPWR X
.ends

* Black-box entry subcircuit for sky130_ef_sc_hd__decap_12 abstract view
.subckt sky130_ef_sc_hd__decap_12 VPWR VGND VPB VNB
.ends

* Black-box entry subcircuit for sky130_fd_sc_hd__mux4_1 abstract view
.subckt sky130_fd_sc_hd__mux4_1 A0 A1 A2 A3 S0 S1 VGND VNB VPB VPWR X
.ends

* Black-box entry subcircuit for sky130_fd_sc_hd__or3_4 abstract view
.subckt sky130_fd_sc_hd__or3_4 A B C VGND VNB VPB VPWR X
.ends

* Black-box entry subcircuit for sky130_fd_sc_hd__clkbuf_1 abstract view
.subckt sky130_fd_sc_hd__clkbuf_1 A VGND VNB VPB VPWR X
.ends

* Black-box entry subcircuit for sky130_fd_sc_hd__tapvpwrvgnd_1 abstract view
.subckt sky130_fd_sc_hd__tapvpwrvgnd_1 VGND VPWR
.ends

* Black-box entry subcircuit for sky130_fd_sc_hd__and2_1 abstract view
.subckt sky130_fd_sc_hd__and2_1 A B VGND VNB VPB VPWR X
.ends

* Black-box entry subcircuit for sky130_fd_sc_hd__or3_2 abstract view
.subckt sky130_fd_sc_hd__or3_2 A B C VGND VNB VPB VPWR X
.ends

* Black-box entry subcircuit for sky130_fd_sc_hd__dfxtp_4 abstract view
.subckt sky130_fd_sc_hd__dfxtp_4 CLK D VGND VNB VPB VPWR Q
.ends

* Black-box entry subcircuit for sky130_fd_sc_hd__dfxtp_1 abstract view
.subckt sky130_fd_sc_hd__dfxtp_1 CLK D VGND VNB VPB VPWR Q
.ends

* Black-box entry subcircuit for sky130_fd_sc_hd__a22o_1 abstract view
.subckt sky130_fd_sc_hd__a22o_1 A1 A2 B1 B2 VGND VNB VPB VPWR X
.ends

* Black-box entry subcircuit for sky130_fd_sc_hd__a21oi_1 abstract view
.subckt sky130_fd_sc_hd__a21oi_1 A1 A2 B1 VGND VNB VPB VPWR Y
.ends

* Black-box entry subcircuit for sky130_fd_sc_hd__o311a_1 abstract view
.subckt sky130_fd_sc_hd__o311a_1 A1 A2 A3 B1 C1 VGND VNB VPB VPWR X
.ends

* Black-box entry subcircuit for sky130_fd_sc_hd__o211a_1 abstract view
.subckt sky130_fd_sc_hd__o211a_1 A1 A2 B1 C1 VGND VNB VPB VPWR X
.ends

* Black-box entry subcircuit for sky130_fd_sc_hd__clkbuf_4 abstract view
.subckt sky130_fd_sc_hd__clkbuf_4 A VGND VNB VPB VPWR X
.ends

* Black-box entry subcircuit for sky130_fd_sc_hd__decap_6 abstract view
.subckt sky130_fd_sc_hd__decap_6 VGND VNB VPB VPWR
.ends

* Black-box entry subcircuit for sky130_fd_sc_hd__or2_1 abstract view
.subckt sky130_fd_sc_hd__or2_1 A B VGND VNB VPB VPWR X
.ends

* Black-box entry subcircuit for sky130_fd_sc_hd__buf_6 abstract view
.subckt sky130_fd_sc_hd__buf_6 A VGND VNB VPB VPWR X
.ends

* Black-box entry subcircuit for sky130_fd_sc_hd__o2bb2a_1 abstract view
.subckt sky130_fd_sc_hd__o2bb2a_1 A1_N A2_N B1 B2 VGND VNB VPB VPWR X
.ends

* Black-box entry subcircuit for sky130_fd_sc_hd__inv_2 abstract view
.subckt sky130_fd_sc_hd__inv_2 A VGND VNB VPB VPWR Y
.ends

* Black-box entry subcircuit for sky130_fd_sc_hd__o21ai_1 abstract view
.subckt sky130_fd_sc_hd__o21ai_1 A1 A2 B1 VGND VNB VPB VPWR Y
.ends

* Black-box entry subcircuit for sky130_fd_sc_hd__buf_2 abstract view
.subckt sky130_fd_sc_hd__buf_2 A VGND VNB VPB VPWR X
.ends

* Black-box entry subcircuit for sky130_fd_sc_hd__nand2_1 abstract view
.subckt sky130_fd_sc_hd__nand2_1 A B VGND VNB VPB VPWR Y
.ends

* Black-box entry subcircuit for sky130_fd_sc_hd__conb_1 abstract view
.subckt sky130_fd_sc_hd__conb_1 VGND VNB VPB VPWR HI LO
.ends

* Black-box entry subcircuit for sky130_fd_sc_hd__a211o_1 abstract view
.subckt sky130_fd_sc_hd__a211o_1 A1 A2 B1 C1 VGND VNB VPB VPWR X
.ends

* Black-box entry subcircuit for sky130_fd_sc_hd__a32o_1 abstract view
.subckt sky130_fd_sc_hd__a32o_1 A1 A2 A3 B1 B2 VGND VNB VPB VPWR X
.ends

* Black-box entry subcircuit for sky130_fd_sc_hd__o21a_1 abstract view
.subckt sky130_fd_sc_hd__o21a_1 A1 A2 B1 VGND VNB VPB VPWR X
.ends

* Black-box entry subcircuit for sky130_fd_sc_hd__clkbuf_8 abstract view
.subckt sky130_fd_sc_hd__clkbuf_8 A VGND VNB VPB VPWR X
.ends

* Black-box entry subcircuit for sky130_fd_sc_hd__a221o_1 abstract view
.subckt sky130_fd_sc_hd__a221o_1 A1 A2 B1 B2 C1 VGND VNB VPB VPWR X
.ends

* Black-box entry subcircuit for sky130_fd_sc_hd__buf_8 abstract view
.subckt sky130_fd_sc_hd__buf_8 A VGND VNB VPB VPWR X
.ends

* Black-box entry subcircuit for sky130_fd_sc_hd__a211oi_1 abstract view
.subckt sky130_fd_sc_hd__a211oi_1 A1 A2 B1 C1 VGND VNB VPB VPWR Y
.ends

* Black-box entry subcircuit for sky130_fd_sc_hd__or3_1 abstract view
.subckt sky130_fd_sc_hd__or3_1 A B C VGND VNB VPB VPWR X
.ends

* Black-box entry subcircuit for sky130_fd_sc_hd__a21o_4 abstract view
.subckt sky130_fd_sc_hd__a21o_4 A1 A2 B1 VGND VNB VPB VPWR X
.ends

* Black-box entry subcircuit for sky130_fd_sc_hd__nor2_4 abstract view
.subckt sky130_fd_sc_hd__nor2_4 A B VGND VNB VPB VPWR Y
.ends

* Black-box entry subcircuit for sky130_fd_sc_hd__inv_4 abstract view
.subckt sky130_fd_sc_hd__inv_4 A VGND VNB VPB VPWR Y
.ends

* Black-box entry subcircuit for sky130_fd_sc_hd__a211o_2 abstract view
.subckt sky130_fd_sc_hd__a211o_2 A1 A2 B1 C1 VGND VNB VPB VPWR X
.ends

* Black-box entry subcircuit for sky130_fd_sc_hd__a31oi_1 abstract view
.subckt sky130_fd_sc_hd__a31oi_1 A1 A2 A3 B1 VGND VNB VPB VPWR Y
.ends

* Black-box entry subcircuit for sky130_fd_sc_hd__buf_12 abstract view
.subckt sky130_fd_sc_hd__buf_12 A VGND VNB VPB VPWR X
.ends

* Black-box entry subcircuit for sky130_fd_sc_hd__clkbuf_16 abstract view
.subckt sky130_fd_sc_hd__clkbuf_16 A VGND VNB VPB VPWR X
.ends

* Black-box entry subcircuit for sky130_fd_sc_hd__nor2_2 abstract view
.subckt sky130_fd_sc_hd__nor2_2 A B VGND VNB VPB VPWR Y
.ends

* Black-box entry subcircuit for sky130_fd_sc_hd__and3b_1 abstract view
.subckt sky130_fd_sc_hd__and3b_1 A_N B C VGND VNB VPB VPWR X
.ends

* Black-box entry subcircuit for sky130_fd_sc_hd__a22o_2 abstract view
.subckt sky130_fd_sc_hd__a22o_2 A1 A2 B1 B2 VGND VNB VPB VPWR X
.ends

* Black-box entry subcircuit for sky130_fd_sc_hd__clkdlybuf4s25_1 abstract view
.subckt sky130_fd_sc_hd__clkdlybuf4s25_1 A VGND VNB VPB VPWR X
.ends

* Black-box entry subcircuit for sky130_fd_sc_hd__and4_2 abstract view
.subckt sky130_fd_sc_hd__and4_2 A B C D VGND VNB VPB VPWR X
.ends

* Black-box entry subcircuit for sky130_fd_sc_hd__o21ba_1 abstract view
.subckt sky130_fd_sc_hd__o21ba_1 A1 A2 B1_N VGND VNB VPB VPWR X
.ends

* Black-box entry subcircuit for sky130_fd_sc_hd__xor2_1 abstract view
.subckt sky130_fd_sc_hd__xor2_1 A B VGND VNB VPB VPWR X
.ends

* Black-box entry subcircuit for sky130_fd_sc_hd__diode_2 abstract view
.subckt sky130_fd_sc_hd__diode_2 DIODE VGND VNB VPB VPWR
.ends

* Black-box entry subcircuit for sky130_fd_sc_hd__a31o_1 abstract view
.subckt sky130_fd_sc_hd__a31o_1 A1 A2 A3 B1 VGND VNB VPB VPWR X
.ends

* Black-box entry subcircuit for sky130_fd_sc_hd__and3_1 abstract view
.subckt sky130_fd_sc_hd__and3_1 A B C VGND VNB VPB VPWR X
.ends

* Black-box entry subcircuit for sky130_fd_sc_hd__xnor2_1 abstract view
.subckt sky130_fd_sc_hd__xnor2_1 A B VGND VNB VPB VPWR Y
.ends

* Black-box entry subcircuit for sky130_fd_sc_hd__a21boi_1 abstract view
.subckt sky130_fd_sc_hd__a21boi_1 A1 A2 B1_N VGND VNB VPB VPWR Y
.ends

* Black-box entry subcircuit for sky130_fd_sc_hd__and4bb_1 abstract view
.subckt sky130_fd_sc_hd__and4bb_1 A_N B_N C D VGND VNB VPB VPWR X
.ends

* Black-box entry subcircuit for sky130_fd_sc_hd__dfxtp_2 abstract view
.subckt sky130_fd_sc_hd__dfxtp_2 CLK D VGND VNB VPB VPWR Q
.ends

* Black-box entry subcircuit for sky130_fd_sc_hd__o311a_2 abstract view
.subckt sky130_fd_sc_hd__o311a_2 A1 A2 A3 B1 C1 VGND VNB VPB VPWR X
.ends

* Black-box entry subcircuit for sky130_fd_sc_hd__nor4_4 abstract view
.subckt sky130_fd_sc_hd__nor4_4 A B C D VGND VNB VPB VPWR Y
.ends

* Black-box entry subcircuit for sky130_fd_sc_hd__o221ai_2 abstract view
.subckt sky130_fd_sc_hd__o221ai_2 A1 A2 B1 B2 C1 VGND VNB VPB VPWR Y
.ends

* Black-box entry subcircuit for sky130_fd_sc_hd__a22oi_1 abstract view
.subckt sky130_fd_sc_hd__a22oi_1 A1 A2 B1 B2 VGND VNB VPB VPWR Y
.ends

* Black-box entry subcircuit for sky130_fd_sc_hd__mux2_2 abstract view
.subckt sky130_fd_sc_hd__mux2_2 A0 A1 S VGND VNB VPB VPWR X
.ends

* Black-box entry subcircuit for sky130_fd_sc_hd__nand2_2 abstract view
.subckt sky130_fd_sc_hd__nand2_2 A B VGND VNB VPB VPWR Y
.ends

* Black-box entry subcircuit for sky130_fd_sc_hd__o211ai_1 abstract view
.subckt sky130_fd_sc_hd__o211ai_1 A1 A2 B1 C1 VGND VNB VPB VPWR Y
.ends

* Black-box entry subcircuit for sky130_fd_sc_hd__and4_1 abstract view
.subckt sky130_fd_sc_hd__and4_1 A B C D VGND VNB VPB VPWR X
.ends

* Black-box entry subcircuit for sky130_fd_sc_hd__or2_4 abstract view
.subckt sky130_fd_sc_hd__or2_4 A B VGND VNB VPB VPWR X
.ends

* Black-box entry subcircuit for sky130_fd_sc_hd__a21bo_1 abstract view
.subckt sky130_fd_sc_hd__a21bo_1 A1 A2 B1_N VGND VNB VPB VPWR X
.ends

* Black-box entry subcircuit for sky130_fd_sc_hd__a2bb2o_2 abstract view
.subckt sky130_fd_sc_hd__a2bb2o_2 A1_N A2_N B1 B2 VGND VNB VPB VPWR X
.ends

* Black-box entry subcircuit for sky130_fd_sc_hd__o32a_1 abstract view
.subckt sky130_fd_sc_hd__o32a_1 A1 A2 A3 B1 B2 VGND VNB VPB VPWR X
.ends

* Black-box entry subcircuit for sky130_fd_sc_hd__and2b_1 abstract view
.subckt sky130_fd_sc_hd__and2b_1 A_N B VGND VNB VPB VPWR X
.ends

* Black-box entry subcircuit for sky130_fd_sc_hd__o21a_2 abstract view
.subckt sky130_fd_sc_hd__o21a_2 A1 A2 B1 VGND VNB VPB VPWR X
.ends

* Black-box entry subcircuit for sky130_fd_sc_hd__buf_1 abstract view
.subckt sky130_fd_sc_hd__buf_1 A VGND VNB VPB VPWR X
.ends

* Black-box entry subcircuit for sky130_fd_sc_hd__o41a_1 abstract view
.subckt sky130_fd_sc_hd__o41a_1 A1 A2 A3 A4 B1 VGND VNB VPB VPWR X
.ends

* Black-box entry subcircuit for sky130_fd_sc_hd__o21ai_2 abstract view
.subckt sky130_fd_sc_hd__o21ai_2 A1 A2 B1 VGND VNB VPB VPWR Y
.ends

* Black-box entry subcircuit for sky130_fd_sc_hd__nand3_1 abstract view
.subckt sky130_fd_sc_hd__nand3_1 A B C VGND VNB VPB VPWR Y
.ends

* Black-box entry subcircuit for sky130_fd_sc_hd__a221o_4 abstract view
.subckt sky130_fd_sc_hd__a221o_4 A1 A2 B1 B2 C1 VGND VNB VPB VPWR X
.ends

* Black-box entry subcircuit for sky130_fd_sc_hd__and4b_4 abstract view
.subckt sky130_fd_sc_hd__and4b_4 A_N B C D VGND VNB VPB VPWR X
.ends

* Black-box entry subcircuit for sky130_fd_sc_hd__nor4b_1 abstract view
.subckt sky130_fd_sc_hd__nor4b_1 A B C D_N VGND VNB VPB VPWR Y
.ends

* Black-box entry subcircuit for sky130_fd_sc_hd__nand2_4 abstract view
.subckt sky130_fd_sc_hd__nand2_4 A B VGND VNB VPB VPWR Y
.ends

* Black-box entry subcircuit for sky130_fd_sc_hd__o21ba_2 abstract view
.subckt sky130_fd_sc_hd__o21ba_2 A1 A2 B1_N VGND VNB VPB VPWR X
.ends

* Black-box entry subcircuit for sky130_fd_sc_hd__nor3_1 abstract view
.subckt sky130_fd_sc_hd__nor3_1 A B C VGND VNB VPB VPWR Y
.ends

* Black-box entry subcircuit for sky130_fd_sc_hd__xnor2_2 abstract view
.subckt sky130_fd_sc_hd__xnor2_2 A B VGND VNB VPB VPWR Y
.ends

* Black-box entry subcircuit for sky130_fd_sc_hd__a211o_4 abstract view
.subckt sky130_fd_sc_hd__a211o_4 A1 A2 B1 C1 VGND VNB VPB VPWR X
.ends

* Black-box entry subcircuit for sky130_fd_sc_hd__or4_4 abstract view
.subckt sky130_fd_sc_hd__or4_4 A B C D VGND VNB VPB VPWR X
.ends

* Black-box entry subcircuit for sky130_fd_sc_hd__or2b_1 abstract view
.subckt sky130_fd_sc_hd__or2b_1 A B_N VGND VNB VPB VPWR X
.ends

* Black-box entry subcircuit for sky130_fd_sc_hd__o31a_1 abstract view
.subckt sky130_fd_sc_hd__o31a_1 A1 A2 A3 B1 VGND VNB VPB VPWR X
.ends

* Black-box entry subcircuit for sky130_fd_sc_hd__or4_1 abstract view
.subckt sky130_fd_sc_hd__or4_1 A B C D VGND VNB VPB VPWR X
.ends

* Black-box entry subcircuit for sky130_fd_sc_hd__or2_2 abstract view
.subckt sky130_fd_sc_hd__or2_2 A B VGND VNB VPB VPWR X
.ends

* Black-box entry subcircuit for sky130_fd_sc_hd__a21boi_2 abstract view
.subckt sky130_fd_sc_hd__a21boi_2 A1 A2 B1_N VGND VNB VPB VPWR Y
.ends

* Black-box entry subcircuit for sky130_fd_sc_hd__a311o_1 abstract view
.subckt sky130_fd_sc_hd__a311o_1 A1 A2 A3 B1 C1 VGND VNB VPB VPWR X
.ends

* Black-box entry subcircuit for sky130_fd_sc_hd__a21oi_2 abstract view
.subckt sky130_fd_sc_hd__a21oi_2 A1 A2 B1 VGND VNB VPB VPWR Y
.ends

* Black-box entry subcircuit for sky130_fd_sc_hd__clkinv_4 abstract view
.subckt sky130_fd_sc_hd__clkinv_4 A VGND VNB VPB VPWR Y
.ends

* Black-box entry subcircuit for sky130_fd_sc_hd__mux2_4 abstract view
.subckt sky130_fd_sc_hd__mux2_4 A0 A1 S VGND VNB VPB VPWR X
.ends

* Black-box entry subcircuit for sky130_fd_sc_hd__a31oi_2 abstract view
.subckt sky130_fd_sc_hd__a31oi_2 A1 A2 A3 B1 VGND VNB VPB VPWR Y
.ends

* Black-box entry subcircuit for sky130_fd_sc_hd__o211ai_2 abstract view
.subckt sky130_fd_sc_hd__o211ai_2 A1 A2 B1 C1 VGND VNB VPB VPWR Y
.ends

* Black-box entry subcircuit for sky130_fd_sc_hd__nand3_2 abstract view
.subckt sky130_fd_sc_hd__nand3_2 A B C VGND VNB VPB VPWR Y
.ends

* Black-box entry subcircuit for sky130_fd_sc_hd__o221a_1 abstract view
.subckt sky130_fd_sc_hd__o221a_1 A1 A2 B1 B2 C1 VGND VNB VPB VPWR X
.ends

* Black-box entry subcircuit for sky130_fd_sc_hd__o22a_1 abstract view
.subckt sky130_fd_sc_hd__o22a_1 A1 A2 B1 B2 VGND VNB VPB VPWR X
.ends

* Black-box entry subcircuit for sky130_fd_sc_hd__a21o_2 abstract view
.subckt sky130_fd_sc_hd__a21o_2 A1 A2 B1 VGND VNB VPB VPWR X
.ends

* Black-box entry subcircuit for sky130_fd_sc_hd__a311o_4 abstract view
.subckt sky130_fd_sc_hd__a311o_4 A1 A2 A3 B1 C1 VGND VNB VPB VPWR X
.ends

* Black-box entry subcircuit for sky130_fd_sc_hd__nand2b_4 abstract view
.subckt sky130_fd_sc_hd__nand2b_4 A_N B VGND VNB VPB VPWR Y
.ends

* Black-box entry subcircuit for sky130_fd_sc_hd__or3b_2 abstract view
.subckt sky130_fd_sc_hd__or3b_2 A B C_N VGND VNB VPB VPWR X
.ends

* Black-box entry subcircuit for sky130_fd_sc_hd__dlymetal6s2s_1 abstract view
.subckt sky130_fd_sc_hd__dlymetal6s2s_1 A VGND VNB VPB VPWR X
.ends

* Black-box entry subcircuit for sky130_fd_sc_hd__nand3_4 abstract view
.subckt sky130_fd_sc_hd__nand3_4 A B C VGND VNB VPB VPWR Y
.ends

* Black-box entry subcircuit for sky130_fd_sc_hd__o2111a_1 abstract view
.subckt sky130_fd_sc_hd__o2111a_1 A1 A2 B1 C1 D1 VGND VNB VPB VPWR X
.ends

* Black-box entry subcircuit for sky130_fd_sc_hd__nand3b_4 abstract view
.subckt sky130_fd_sc_hd__nand3b_4 A_N B C VGND VNB VPB VPWR Y
.ends

* Black-box entry subcircuit for sky130_fd_sc_hd__and4b_1 abstract view
.subckt sky130_fd_sc_hd__and4b_1 A_N B C D VGND VNB VPB VPWR X
.ends

* Black-box entry subcircuit for sky130_fd_sc_hd__clkbuf_2 abstract view
.subckt sky130_fd_sc_hd__clkbuf_2 A VGND VNB VPB VPWR X
.ends

* Black-box entry subcircuit for sky130_fd_sc_hd__a41o_1 abstract view
.subckt sky130_fd_sc_hd__a41o_1 A1 A2 A3 A4 B1 VGND VNB VPB VPWR X
.ends

* Black-box entry subcircuit for sky130_fd_sc_hd__mux4_2 abstract view
.subckt sky130_fd_sc_hd__mux4_2 A0 A1 A2 A3 S0 S1 VGND VNB VPB VPWR X
.ends

* Black-box entry subcircuit for sky130_fd_sc_hd__nor3b_1 abstract view
.subckt sky130_fd_sc_hd__nor3b_1 A B C_N VGND VNB VPB VPWR Y
.ends

* Black-box entry subcircuit for sky130_fd_sc_hd__o21ai_4 abstract view
.subckt sky130_fd_sc_hd__o21ai_4 A1 A2 B1 VGND VNB VPB VPWR Y
.ends

* Black-box entry subcircuit for sky130_fd_sc_hd__nor4_1 abstract view
.subckt sky130_fd_sc_hd__nor4_1 A B C D VGND VNB VPB VPWR Y
.ends

* Black-box entry subcircuit for sky130_fd_sc_hd__or3b_4 abstract view
.subckt sky130_fd_sc_hd__or3b_4 A B C_N VGND VNB VPB VPWR X
.ends

* Black-box entry subcircuit for sky130_fd_sc_hd__a2111o_1 abstract view
.subckt sky130_fd_sc_hd__a2111o_1 A1 A2 B1 C1 D1 VGND VNB VPB VPWR X
.ends

* Black-box entry subcircuit for sky130_fd_sc_hd__nor3_4 abstract view
.subckt sky130_fd_sc_hd__nor3_4 A B C VGND VNB VPB VPWR Y
.ends

* Black-box entry subcircuit for sky130_fd_sc_hd__o21bai_1 abstract view
.subckt sky130_fd_sc_hd__o21bai_1 A1 A2 B1_N VGND VNB VPB VPWR Y
.ends

* Black-box entry subcircuit for sky130_fd_sc_hd__a22o_4 abstract view
.subckt sky130_fd_sc_hd__a22o_4 A1 A2 B1 B2 VGND VNB VPB VPWR X
.ends

* Black-box entry subcircuit for sky130_fd_sc_hd__xor2_2 abstract view
.subckt sky130_fd_sc_hd__xor2_2 A B VGND VNB VPB VPWR X
.ends

* Black-box entry subcircuit for sky130_fd_sc_hd__a2bb2o_1 abstract view
.subckt sky130_fd_sc_hd__a2bb2o_1 A1_N A2_N B1 B2 VGND VNB VPB VPWR X
.ends

* Black-box entry subcircuit for sky130_fd_sc_hd__and2_2 abstract view
.subckt sky130_fd_sc_hd__and2_2 A B VGND VNB VPB VPWR X
.ends

* Black-box entry subcircuit for sky130_fd_sc_hd__a221o_2 abstract view
.subckt sky130_fd_sc_hd__a221o_2 A1 A2 B1 B2 C1 VGND VNB VPB VPWR X
.ends

* Black-box entry subcircuit for sky130_fd_sc_hd__o22ai_4 abstract view
.subckt sky130_fd_sc_hd__o22ai_4 A1 A2 B1 B2 VGND VNB VPB VPWR Y
.ends

* Black-box entry subcircuit for sky130_fd_sc_hd__or4_2 abstract view
.subckt sky130_fd_sc_hd__or4_2 A B C D VGND VNB VPB VPWR X
.ends

* Black-box entry subcircuit for sky130_fd_sc_hd__or4b_1 abstract view
.subckt sky130_fd_sc_hd__or4b_1 A B C D_N VGND VNB VPB VPWR X
.ends

* Black-box entry subcircuit for sky130_fd_sc_hd__a311o_2 abstract view
.subckt sky130_fd_sc_hd__a311o_2 A1 A2 A3 B1 C1 VGND VNB VPB VPWR X
.ends

* Black-box entry subcircuit for sky130_fd_sc_hd__nor4b_2 abstract view
.subckt sky130_fd_sc_hd__nor4b_2 A B C D_N VGND VNB VPB VPWR Y
.ends

* Black-box entry subcircuit for sky130_fd_sc_hd__or3b_1 abstract view
.subckt sky130_fd_sc_hd__or3b_1 A B C_N VGND VNB VPB VPWR X
.ends

* Black-box entry subcircuit for sky130_fd_sc_hd__nand4_1 abstract view
.subckt sky130_fd_sc_hd__nand4_1 A B C D VGND VNB VPB VPWR Y
.ends

* Black-box entry subcircuit for sky130_fd_sc_hd__and3_2 abstract view
.subckt sky130_fd_sc_hd__and3_2 A B C VGND VNB VPB VPWR X
.ends

* Black-box entry subcircuit for sky130_fd_sc_hd__o311ai_4 abstract view
.subckt sky130_fd_sc_hd__o311ai_4 A1 A2 A3 B1 C1 VGND VNB VPB VPWR Y
.ends

* Black-box entry subcircuit for sky130_fd_sc_hd__and2b_2 abstract view
.subckt sky130_fd_sc_hd__and2b_2 A_N B VGND VNB VPB VPWR X
.ends

* Black-box entry subcircuit for sky130_fd_sc_hd__a21oi_4 abstract view
.subckt sky130_fd_sc_hd__a21oi_4 A1 A2 B1 VGND VNB VPB VPWR Y
.ends

* Black-box entry subcircuit for sky130_fd_sc_hd__nor2_8 abstract view
.subckt sky130_fd_sc_hd__nor2_8 A B VGND VNB VPB VPWR Y
.ends

* Black-box entry subcircuit for sky130_fd_sc_hd__o32a_2 abstract view
.subckt sky130_fd_sc_hd__o32a_2 A1 A2 A3 B1 B2 VGND VNB VPB VPWR X
.ends

* Black-box entry subcircuit for sky130_fd_sc_hd__or2b_2 abstract view
.subckt sky130_fd_sc_hd__or2b_2 A B_N VGND VNB VPB VPWR X
.ends

* Black-box entry subcircuit for sky130_fd_sc_hd__o31ai_2 abstract view
.subckt sky130_fd_sc_hd__o31ai_2 A1 A2 A3 B1 VGND VNB VPB VPWR Y
.ends

* Black-box entry subcircuit for sky130_fd_sc_hd__o31ai_1 abstract view
.subckt sky130_fd_sc_hd__o31ai_1 A1 A2 A3 B1 VGND VNB VPB VPWR Y
.ends

* Black-box entry subcircuit for sky130_fd_sc_hd__a221oi_1 abstract view
.subckt sky130_fd_sc_hd__a221oi_1 A1 A2 B1 B2 C1 VGND VNB VPB VPWR Y
.ends

.subckt picorv32 VGND VPWR clk eoi[0] eoi[15] eoi[16] eoi[1] eoi[2] eoi[3] eoi[4]
+ eoi[5] irq[0] irq[10] irq[11] irq[12] irq[13] irq[14] irq[15] irq[16] irq[17] irq[18]
+ irq[19] irq[1] irq[20] irq[21] irq[22] irq[23] irq[24] irq[25] irq[26] irq[27] irq[28]
+ irq[29] irq[2] irq[30] irq[31] irq[3] irq[4] irq[5] irq[6] irq[7] irq[8] irq[9]
+ mem_addr[10] mem_addr[11] mem_addr[12] mem_addr[13] mem_addr[14] mem_addr[15] mem_addr[16]
+ mem_addr[17] mem_addr[18] mem_addr[19] mem_addr[20] mem_addr[21] mem_addr[22] mem_addr[23]
+ mem_addr[24] mem_addr[25] mem_addr[26] mem_addr[27] mem_addr[28] mem_addr[29] mem_addr[2]
+ mem_addr[30] mem_addr[31] mem_addr[3] mem_addr[4] mem_addr[5] mem_addr[6] mem_addr[7]
+ mem_addr[8] mem_addr[9] mem_instr mem_la_addr[0] mem_la_addr[10] mem_la_addr[11]
+ mem_la_addr[12] mem_la_addr[13] mem_la_addr[14] mem_la_addr[15] mem_la_addr[16]
+ mem_la_addr[17] mem_la_addr[18] mem_la_addr[19] mem_la_addr[1] mem_la_addr[20] mem_la_addr[21]
+ mem_la_addr[22] mem_la_addr[23] mem_la_addr[24] mem_la_addr[25] mem_la_addr[26]
+ mem_la_addr[27] mem_la_addr[28] mem_la_addr[29] mem_la_addr[2] mem_la_addr[30] mem_la_addr[31]
+ mem_la_addr[3] mem_la_addr[4] mem_la_addr[5] mem_la_addr[6] mem_la_addr[7] mem_la_addr[8]
+ mem_la_addr[9] mem_la_read mem_la_wdata[0] mem_la_wdata[10] mem_la_wdata[11] mem_la_wdata[12]
+ mem_la_wdata[13] mem_la_wdata[14] mem_la_wdata[15] mem_la_wdata[16] mem_la_wdata[17]
+ mem_la_wdata[18] mem_la_wdata[19] mem_la_wdata[1] mem_la_wdata[20] mem_la_wdata[21]
+ mem_la_wdata[22] mem_la_wdata[23] mem_la_wdata[24] mem_la_wdata[25] mem_la_wdata[26]
+ mem_la_wdata[27] mem_la_wdata[28] mem_la_wdata[29] mem_la_wdata[2] mem_la_wdata[30]
+ mem_la_wdata[31] mem_la_wdata[3] mem_la_wdata[4] mem_la_wdata[5] mem_la_wdata[6]
+ mem_la_wdata[7] mem_la_wdata[8] mem_la_wdata[9] mem_la_write mem_la_wstrb[0] mem_la_wstrb[1]
+ mem_la_wstrb[2] mem_la_wstrb[3] mem_rdata[0] mem_rdata[10] mem_rdata[11] mem_rdata[12]
+ mem_rdata[13] mem_rdata[14] mem_rdata[15] mem_rdata[16] mem_rdata[17] mem_rdata[18]
+ mem_rdata[19] mem_rdata[1] mem_rdata[20] mem_rdata[21] mem_rdata[22] mem_rdata[23]
+ mem_rdata[24] mem_rdata[25] mem_rdata[26] mem_rdata[27] mem_rdata[28] mem_rdata[29]
+ mem_rdata[2] mem_rdata[30] mem_rdata[31] mem_rdata[3] mem_rdata[4] mem_rdata[5]
+ mem_rdata[6] mem_rdata[7] mem_rdata[8] mem_rdata[9] mem_ready mem_valid mem_wdata[0]
+ mem_wdata[10] mem_wdata[11] mem_wdata[12] mem_wdata[13] mem_wdata[14] mem_wdata[15]
+ mem_wdata[16] mem_wdata[17] mem_wdata[18] mem_wdata[19] mem_wdata[1] mem_wdata[20]
+ mem_wdata[21] mem_wdata[22] mem_wdata[23] mem_wdata[24] mem_wdata[25] mem_wdata[26]
+ mem_wdata[27] mem_wdata[28] mem_wdata[29] mem_wdata[2] mem_wdata[30] mem_wdata[31]
+ mem_wdata[3] mem_wdata[4] mem_wdata[5] mem_wdata[6] mem_wdata[7] mem_wdata[8] mem_wdata[9]
+ mem_wstrb[0] mem_wstrb[1] mem_wstrb[2] mem_wstrb[3] pcpi_insn[11] pcpi_insn[12]
+ pcpi_insn[13] pcpi_insn[14] pcpi_insn[15] pcpi_insn[16] pcpi_insn[17] pcpi_insn[18]
+ pcpi_insn[19] pcpi_insn[1] pcpi_insn[20] pcpi_insn[21] pcpi_insn[22] pcpi_insn[28]
+ pcpi_insn[29] pcpi_insn[30] pcpi_insn[31] pcpi_insn[9] pcpi_rd[0] pcpi_rd[10] pcpi_rd[11]
+ pcpi_rd[12] pcpi_rd[13] pcpi_rd[14] pcpi_rd[15] pcpi_rd[16] pcpi_rd[17] pcpi_rd[18]
+ pcpi_rd[19] pcpi_rd[1] pcpi_rd[20] pcpi_rd[21] pcpi_rd[22] pcpi_rd[23] pcpi_rd[24]
+ pcpi_rd[25] pcpi_rd[26] pcpi_rd[27] pcpi_rd[28] pcpi_rd[29] pcpi_rd[2] pcpi_rd[30]
+ pcpi_rd[31] pcpi_rd[3] pcpi_rd[4] pcpi_rd[5] pcpi_rd[6] pcpi_rd[7] pcpi_rd[8] pcpi_rd[9]
+ pcpi_ready pcpi_rs1[0] pcpi_rs1[10] pcpi_rs1[11] pcpi_rs1[12] pcpi_rs1[13] pcpi_rs1[14]
+ pcpi_rs1[15] pcpi_rs1[16] pcpi_rs1[17] pcpi_rs1[18] pcpi_rs1[19] pcpi_rs1[1] pcpi_rs1[20]
+ pcpi_rs1[21] pcpi_rs1[22] pcpi_rs1[23] pcpi_rs1[24] pcpi_rs1[25] pcpi_rs1[26] pcpi_rs1[27]
+ pcpi_rs1[28] pcpi_rs1[29] pcpi_rs1[2] pcpi_rs1[30] pcpi_rs1[31] pcpi_rs1[3] pcpi_rs1[4]
+ pcpi_rs1[5] pcpi_rs1[6] pcpi_rs1[7] pcpi_rs1[8] pcpi_rs1[9] pcpi_rs2[0] pcpi_rs2[10]
+ pcpi_rs2[11] pcpi_rs2[12] pcpi_rs2[13] pcpi_rs2[14] pcpi_rs2[15] pcpi_rs2[16] pcpi_rs2[17]
+ pcpi_rs2[18] pcpi_rs2[19] pcpi_rs2[1] pcpi_rs2[20] pcpi_rs2[21] pcpi_rs2[22] pcpi_rs2[23]
+ pcpi_rs2[24] pcpi_rs2[25] pcpi_rs2[26] pcpi_rs2[27] pcpi_rs2[28] pcpi_rs2[29] pcpi_rs2[2]
+ pcpi_rs2[30] pcpi_rs2[31] pcpi_rs2[3] pcpi_rs2[4] pcpi_rs2[5] pcpi_rs2[6] pcpi_rs2[7]
+ pcpi_rs2[8] pcpi_rs2[9] pcpi_wait pcpi_wr resetn trace_data[0] trace_data[16] trace_data[17]
+ trace_data[1] trace_data[20] trace_data[21] trace_data[22] trace_data[23] trace_data[24]
+ trace_data[25] trace_data[26] trace_data[27] trace_data[28] trace_data[29] trace_data[2]
+ trace_data[35] trace_data[3] trace_data[4] trace_data[5] trace_data[6] trace_data[7]
+ trace_data[8] trace_data[9] trace_valid trap pcpi_insn[27] trace_data[15] pcpi_insn[26]
+ trace_data[14] pcpi_insn[25] trace_data[13] pcpi_insn[24] trace_data[34] trace_data[12]
+ pcpi_insn[23] trace_data[33] trace_data[11] trace_data[32] trace_data[10] pcpi_valid
+ trace_data[31] trace_data[19] trace_data[30] trace_data[18] eoi[6] eoi[26] eoi[25]
+ pcpi_insn[0] eoi[14] eoi[24] pcpi_insn[10] eoi[13] eoi[23] eoi[12] pcpi_insn[8]
+ mem_addr[1] eoi[11] eoi[22] pcpi_insn[7] eoi[21] eoi[10] mem_addr[0] eoi[31] eoi[20]
+ pcpi_insn[6] eoi[9] eoi[30] eoi[19] pcpi_insn[5] eoi[8] eoi[29] pcpi_insn[4] eoi[18]
+ eoi[7] pcpi_insn[3] eoi[28] eoi[17] eoi[27] pcpi_insn[2]
XFILLER_0_94_55 VGND VGND VPWR VPWR sky130_fd_sc_hd__fill_2
X_09671_ _03901_ _03903_ _03796_ VGND VGND VPWR VPWR _03904_ sky130_fd_sc_hd__a21o_1
X_08622_ _02690_ _02895_ _02989_ VGND VGND VPWR VPWR _02990_ sky130_fd_sc_hd__a21o_1
XFILLER_0_89_483 VGND VGND VPWR VPWR sky130_fd_sc_hd__fill_1
X_08553_ _02925_ _02926_ VGND VGND VPWR VPWR _02927_ sky130_fd_sc_hd__nor2_1
XFILLER_0_49_314 VGND VGND VPWR VPWR sky130_fd_sc_hd__fill_1
XFILLER_0_77_667 VGND VGND VPWR VPWR sky130_fd_sc_hd__decap_4
X_08484_ _02243_ _02861_ VGND VGND VPWR VPWR _02863_ sky130_fd_sc_hd__nor2_1
XFILLER_0_134_83 VGND VGND VPWR VPWR sky130_fd_sc_hd__fill_1
XFILLER_0_76_166 VGND VGND VPWR VPWR sky130_fd_sc_hd__fill_1
XFILLER_0_64_306 VGND VGND VPWR VPWR sky130_fd_sc_hd__fill_2
XFILLER_0_134_238 VGND VGND VPWR VPWR sky130_fd_sc_hd__decap_8
XFILLER_0_17_233 VGND VGND VPWR VPWR sky130_fd_sc_hd__fill_1
XFILLER_0_17_244 VGND VGND VPWR VPWR sky130_fd_sc_hd__decap_4
XFILLER_0_17_266 VGND VGND VPWR VPWR sky130_fd_sc_hd__fill_1
XFILLER_0_17_277 VGND VGND VPWR VPWR sky130_fd_sc_hd__decap_3
X_09105_ cpuregs\[16\]\[3\] cpuregs\[17\]\[3\] _03342_ VGND VGND VPWR VPWR _03385_
+ sky130_fd_sc_hd__mux2_1
X_09036_ _00009_ VGND VGND VPWR VPWR _03317_ sky130_fd_sc_hd__buf_4
XFILLER_0_103_658 VGND VGND VPWR VPWR sky130_fd_sc_hd__fill_2
Xhold362 cpuregs\[22\]\[24\] VGND VGND VPWR VPWR net720 sky130_fd_sc_hd__dlygate4sd3_1
Xhold351 cpuregs\[12\]\[31\] VGND VGND VPWR VPWR net709 sky130_fd_sc_hd__dlygate4sd3_1
Xhold340 cpuregs\[19\]\[8\] VGND VGND VPWR VPWR net698 sky130_fd_sc_hd__dlygate4sd3_1
Xhold373 cpuregs\[20\]\[16\] VGND VGND VPWR VPWR net731 sky130_fd_sc_hd__dlygate4sd3_1
Xhold384 cpuregs\[28\]\[13\] VGND VGND VPWR VPWR net742 sky130_fd_sc_hd__dlygate4sd3_1
XFILLER_0_40_291 VPWR VGND VPWR VGND sky130_ef_sc_hd__decap_12
Xhold395 cpuregs\[18\]\[2\] VGND VGND VPWR VPWR net753 sky130_fd_sc_hd__dlygate4sd3_1
X_09938_ cpuregs\[8\]\[10\] cpuregs\[9\]\[10\] cpuregs\[10\]\[10\] cpuregs\[11\]\[10\]
+ _03876_ _03895_ VGND VGND VPWR VPWR _04164_ sky130_fd_sc_hd__mux4_1
Xhold1051 cpuregs\[25\]\[25\] VGND VGND VPWR VPWR net1409 sky130_fd_sc_hd__dlygate4sd3_1
XFILLER_0_99_225 VGND VGND VPWR VPWR sky130_fd_sc_hd__fill_2
Xhold1040 instr_rdcycle VGND VGND VPWR VPWR net1398 sky130_fd_sc_hd__dlygate4sd3_1
X_09869_ _03747_ _04089_ _04096_ VGND VGND VPWR VPWR _04097_ sky130_fd_sc_hd__or3_4
Xhold1073 cpuregs\[1\]\[29\] VGND VGND VPWR VPWR net1431 sky130_fd_sc_hd__dlygate4sd3_1
Xhold1062 cpuregs\[6\]\[17\] VGND VGND VPWR VPWR net1420 sky130_fd_sc_hd__dlygate4sd3_1
X_11900_ _05596_ VGND VGND VPWR VPWR _00608_ sky130_fd_sc_hd__clkbuf_1
X_12880_ cpuregs\[4\]\[1\] cpuregs\[5\]\[1\] cpuregs\[6\]\[1\] cpuregs\[7\]\[1\] _03323_
+ _03325_ VGND VGND VPWR VPWR _06378_ sky130_fd_sc_hd__mux4_1
Xhold1084 cpuregs\[4\]\[0\] VGND VGND VPWR VPWR net1442 sky130_fd_sc_hd__dlygate4sd3_1
XTAP_1800 VGND VPWR sky130_fd_sc_hd__tapvpwrvgnd_1
X_11831_ count_instr\[9\] count_instr\[8\] VGND VGND VPWR VPWR _05546_ sky130_fd_sc_hd__and2_1
Xhold1095 cpuregs\[7\]\[8\] VGND VGND VPWR VPWR net1453 sky130_fd_sc_hd__dlygate4sd3_1
X_14550_ net759 _05213_ _01634_ VGND VGND VPWR VPWR _01640_ sky130_fd_sc_hd__mux2_1
XTAP_1822 VGND VPWR sky130_fd_sc_hd__tapvpwrvgnd_1
XTAP_1833 VGND VPWR sky130_fd_sc_hd__tapvpwrvgnd_1
XTAP_1811 VGND VPWR sky130_fd_sc_hd__tapvpwrvgnd_1
XTAP_1866 VGND VPWR sky130_fd_sc_hd__tapvpwrvgnd_1
XTAP_1855 VGND VPWR sky130_fd_sc_hd__tapvpwrvgnd_1
XTAP_1844 VGND VPWR sky130_fd_sc_hd__tapvpwrvgnd_1
X_13501_ _03325_ VGND VGND VPWR VPWR _06979_ sky130_fd_sc_hd__buf_4
XFILLER_0_83_615 VGND VGND VPWR VPWR sky130_fd_sc_hd__fill_1
X_11762_ _05020_ net628 _05494_ VGND VGND VPWR VPWR _05502_ sky130_fd_sc_hd__mux2_1
XFILLER_0_55_317 VGND VGND VPWR VPWR sky130_fd_sc_hd__decap_8
XTAP_1899 VGND VPWR sky130_fd_sc_hd__tapvpwrvgnd_1
XTAP_1888 VGND VPWR sky130_fd_sc_hd__tapvpwrvgnd_1
XTAP_1877 VGND VPWR sky130_fd_sc_hd__tapvpwrvgnd_1
X_14481_ _01603_ VGND VGND VPWR VPWR _01085_ sky130_fd_sc_hd__clkbuf_1
X_11693_ _05465_ VGND VGND VPWR VPWR _00532_ sky130_fd_sc_hd__clkbuf_1
XFILLER_0_67_188 VGND VGND VPWR VPWR sky130_fd_sc_hd__decap_8
X_10713_ net1432 _03478_ _04907_ VGND VGND VPWR VPWR _04913_ sky130_fd_sc_hd__mux2_1
X_10644_ _03795_ _04844_ _04850_ VGND VGND VPWR VPWR _04851_ sky130_fd_sc_hd__or3_2
X_13432_ cpuregs\[0\]\[19\] cpuregs\[1\]\[19\] cpuregs\[2\]\[19\] cpuregs\[3\]\[19\]
+ _06740_ _06708_ VGND VGND VPWR VPWR _06912_ sky130_fd_sc_hd__mux4_1
X_16220_ clknet_leaf_19_clk _00837_ VGND VGND VPWR VPWR net227 sky130_fd_sc_hd__dfxtp_4
XFILLER_0_70_309 VGND VGND VPWR VPWR sky130_fd_sc_hd__decap_3
X_16151_ clknet_leaf_37_clk _07639_ VGND VGND VPWR VPWR reg_out\[29\] sky130_fd_sc_hd__dfxtp_1
X_10575_ _03780_ _04756_ _04783_ _03793_ VGND VGND VPWR VPWR _04784_ sky130_fd_sc_hd__a22o_1
X_13363_ cpuregs\[0\]\[17\] cpuregs\[1\]\[17\] cpuregs\[2\]\[17\] cpuregs\[3\]\[17\]
+ _06740_ _06708_ VGND VGND VPWR VPWR _06845_ sky130_fd_sc_hd__mux4_1
XFILLER_0_140_219 VGND VGND VPWR VPWR sky130_fd_sc_hd__decap_4
X_15102_ _01932_ VGND VGND VPWR VPWR _01409_ sky130_fd_sc_hd__clkbuf_1
X_12314_ _05924_ _05927_ _05928_ VGND VGND VPWR VPWR _05929_ sky130_fd_sc_hd__a21oi_1
XFILLER_0_2_119 VGND VGND VPWR VPWR sky130_fd_sc_hd__fill_2
Xrebuffer7 net366 VGND VGND VPWR VPWR net365 sky130_fd_sc_hd__clkbuf_1
XFILLER_0_121_444 VGND VGND VPWR VPWR sky130_fd_sc_hd__decap_4
X_13294_ _06638_ _06772_ _06775_ _06739_ _06777_ VGND VGND VPWR VPWR _06778_ sky130_fd_sc_hd__o311a_1
X_16082_ clknet_leaf_1_clk _00732_ VGND VGND VPWR VPWR count_cycle\[25\] sky130_fd_sc_hd__dfxtp_1
X_15033_ _03629_ net1249 _01887_ VGND VGND VPWR VPWR _01896_ sky130_fd_sc_hd__mux2_1
XFILLER_0_121_455 VGND VGND VPWR VPWR sky130_fd_sc_hd__fill_1
X_12245_ _05852_ net440 _05816_ _05865_ VGND VGND VPWR VPWR _00684_ sky130_fd_sc_hd__o211a_1
X_12176_ _05520_ VGND VGND VPWR VPWR _05802_ sky130_fd_sc_hd__clkbuf_4
X_11127_ _05149_ VGND VGND VPWR VPWR _00282_ sky130_fd_sc_hd__clkbuf_1
X_11058_ net718 _03591_ _05110_ VGND VGND VPWR VPWR _05113_ sky130_fd_sc_hd__mux2_1
XFILLER_0_3_39 VGND VGND VPWR VPWR sky130_fd_sc_hd__fill_1
X_15935_ clknet_leaf_141_clk _00585_ VGND VGND VPWR VPWR count_instr\[4\] sky130_fd_sc_hd__dfxtp_1
X_10009_ _04231_ _04232_ _02156_ VGND VGND VPWR VPWR _04233_ sky130_fd_sc_hd__mux2_1
XFILLER_0_64_47 VGND VGND VPWR VPWR sky130_fd_sc_hd__fill_1
X_15866_ clknet_leaf_125_clk _00516_ VGND VGND VPWR VPWR cpuregs\[20\]\[0\] sky130_fd_sc_hd__dfxtp_1
X_14817_ _01781_ VGND VGND VPWR VPWR _01275_ sky130_fd_sc_hd__clkbuf_1
X_15797_ clknet_leaf_45_clk _00447_ VGND VGND VPWR VPWR cpuregs\[26\]\[27\] sky130_fd_sc_hd__dfxtp_1
X_14748_ _05031_ net1237 _01742_ VGND VGND VPWR VPWR _01745_ sky130_fd_sc_hd__mux2_1
XFILLER_0_47_807 VGND VGND VPWR VPWR sky130_fd_sc_hd__fill_1
X_14679_ _01708_ VGND VGND VPWR VPWR _01210_ sky130_fd_sc_hd__clkbuf_1
XFILLER_0_73_103 VGND VGND VPWR VPWR sky130_fd_sc_hd__decap_8
X_16418_ clknet_leaf_25_clk _01000_ VGND VGND VPWR VPWR decoded_imm\[29\] sky130_fd_sc_hd__dfxtp_4
XFILLER_0_70_821 VGND VGND VPWR VPWR sky130_fd_sc_hd__fill_2
XFILLER_0_70_810 VGND VGND VPWR VPWR sky130_fd_sc_hd__fill_2
X_16349_ clknet_leaf_106_clk _00931_ VGND VGND VPWR VPWR cpuregs\[1\]\[14\] sky130_fd_sc_hd__dfxtp_1
XFILLER_0_6_469 VGND VGND VPWR VPWR sky130_fd_sc_hd__decap_4
XFILLER_0_13_95 VGND VGND VPWR VPWR sky130_fd_sc_hd__decap_4
XFILLER_0_125_783 VGND VGND VPWR VPWR sky130_fd_sc_hd__fill_1
XFILLER_0_89_44 VGND VGND VPWR VPWR sky130_fd_sc_hd__fill_1
XFILLER_0_14_269 VGND VGND VPWR VPWR sky130_fd_sc_hd__decap_4
XFILLER_0_42_567 VGND VGND VPWR VPWR sky130_fd_sc_hd__fill_2
XFILLER_0_42_589 VGND VGND VPWR VPWR sky130_fd_sc_hd__fill_1
XFILLER_0_1_174 VGND VGND VPWR VPWR sky130_fd_sc_hd__decap_6
XFILLER_0_10_486 VGND VGND VPWR VPWR sky130_fd_sc_hd__fill_1
X_07984_ reg_pc\[12\] decoded_imm\[12\] VGND VGND VPWR VPWR _02385_ sky130_fd_sc_hd__or2_1
X_09723_ decoded_imm\[5\] net198 VGND VGND VPWR VPWR _03954_ sky130_fd_sc_hd__and2_1
X_09654_ _03863_ _03874_ _03886_ VGND VGND VPWR VPWR _03887_ sky130_fd_sc_hd__or3_4
X_08605_ _02934_ _02972_ _02685_ VGND VGND VPWR VPWR _02974_ sky130_fd_sc_hd__a21oi_1
X_09585_ _03797_ VGND VGND VPWR VPWR _03819_ sky130_fd_sc_hd__buf_6
XTAP_1129 VGND VPWR sky130_fd_sc_hd__tapvpwrvgnd_1
XTAP_1118 VGND VPWR sky130_fd_sc_hd__tapvpwrvgnd_1
XTAP_1107 VGND VPWR sky130_fd_sc_hd__tapvpwrvgnd_1
XFILLER_0_49_122 VGND VGND VPWR VPWR sky130_fd_sc_hd__decap_4
X_08536_ _02310_ _02909_ VGND VGND VPWR VPWR _02911_ sky130_fd_sc_hd__or2_1
X_08467_ _02844_ _02755_ _02846_ _02847_ VGND VGND VPWR VPWR _02848_ sky130_fd_sc_hd__o2bb2a_1
X_08398_ net209 VGND VGND VPWR VPWR _02779_ sky130_fd_sc_hd__inv_2
XFILLER_0_73_670 VGND VGND VPWR VPWR sky130_fd_sc_hd__fill_2
X_10360_ _03780_ _04547_ _04574_ _03793_ VGND VGND VPWR VPWR _04575_ sky130_fd_sc_hd__a22o_1
X_10291_ _04477_ _04478_ _04507_ VGND VGND VPWR VPWR _04508_ sky130_fd_sc_hd__o21ai_1
X_09019_ _03303_ VGND VGND VPWR VPWR _00035_ sky130_fd_sc_hd__clkbuf_1
Xhold170 reg_next_pc\[23\] VGND VGND VPWR VPWR net528 sky130_fd_sc_hd__dlygate4sd3_1
X_12030_ _05519_ VGND VGND VPWR VPWR _05690_ sky130_fd_sc_hd__buf_2
Xhold192 _06169_ VGND VGND VPWR VPWR net550 sky130_fd_sc_hd__dlygate4sd3_1
Xhold181 _00736_ VGND VGND VPWR VPWR net539 sky130_fd_sc_hd__dlygate4sd3_1
XFILLER_0_18_18 VGND VGND VPWR VPWR sky130_fd_sc_hd__decap_8
X_13981_ _07400_ VGND VGND VPWR VPWR _00876_ sky130_fd_sc_hd__clkbuf_1
XFILLER_0_88_718 VGND VGND VPWR VPWR sky130_fd_sc_hd__fill_2
X_15720_ clknet_leaf_18_clk _00370_ VGND VGND VPWR VPWR cpuregs\[21\]\[14\] sky130_fd_sc_hd__dfxtp_1
X_12932_ _06351_ _06425_ _03377_ VGND VGND VPWR VPWR _06426_ sky130_fd_sc_hd__a21o_1
XTAP_2320 VGND VPWR sky130_fd_sc_hd__tapvpwrvgnd_1
X_15651_ clknet_leaf_111_clk _00301_ VGND VGND VPWR VPWR cpuregs\[14\]\[9\] sky130_fd_sc_hd__dfxtp_1
XTAP_2353 VGND VPWR sky130_fd_sc_hd__tapvpwrvgnd_1
XTAP_2342 VGND VPWR sky130_fd_sc_hd__tapvpwrvgnd_1
XTAP_2331 VGND VPWR sky130_fd_sc_hd__tapvpwrvgnd_1
X_14602_ _01667_ VGND VGND VPWR VPWR _01174_ sky130_fd_sc_hd__clkbuf_1
X_12863_ cpuregs\[8\]\[0\] cpuregs\[9\]\[0\] cpuregs\[10\]\[0\] cpuregs\[11\]\[0\]
+ _06344_ _03314_ VGND VGND VPWR VPWR _06362_ sky130_fd_sc_hd__mux4_1
XFILLER_0_139_820 VGND VGND VPWR VPWR sky130_fd_sc_hd__fill_2
X_12794_ _06311_ VGND VGND VPWR VPWR _00787_ sky130_fd_sc_hd__clkbuf_1
XTAP_1641 VGND VPWR sky130_fd_sc_hd__tapvpwrvgnd_1
XTAP_1630 VGND VPWR sky130_fd_sc_hd__tapvpwrvgnd_1
X_15582_ clknet_leaf_123_clk _00232_ VGND VGND VPWR VPWR cpuregs\[28\]\[4\] sky130_fd_sc_hd__dfxtp_1
X_11814_ net433 _05529_ _05533_ VGND VGND VPWR VPWR _05534_ sky130_fd_sc_hd__o21ai_1
XTAP_1685 VGND VPWR sky130_fd_sc_hd__tapvpwrvgnd_1
XFILLER_0_95_261 VGND VGND VPWR VPWR sky130_fd_sc_hd__fill_1
XTAP_1674 VGND VPWR sky130_fd_sc_hd__tapvpwrvgnd_1
XTAP_1663 VGND VPWR sky130_fd_sc_hd__tapvpwrvgnd_1
XTAP_1652 VGND VPWR sky130_fd_sc_hd__tapvpwrvgnd_1
XFILLER_0_83_434 VGND VGND VPWR VPWR sky130_fd_sc_hd__decap_8
X_14533_ net772 _05196_ _01623_ VGND VGND VPWR VPWR _01631_ sky130_fd_sc_hd__mux2_1
XFILLER_0_28_328 VGND VGND VPWR VPWR sky130_fd_sc_hd__decap_4
X_11745_ _05003_ net848 _05483_ VGND VGND VPWR VPWR _05493_ sky130_fd_sc_hd__mux2_1
XTAP_1696 VGND VPWR sky130_fd_sc_hd__tapvpwrvgnd_1
XFILLER_0_83_445 VGND VGND VPWR VPWR sky130_fd_sc_hd__decap_3
X_14464_ _01594_ VGND VGND VPWR VPWR _01077_ sky130_fd_sc_hd__clkbuf_1
XFILLER_0_55_136 VGND VGND VPWR VPWR sky130_fd_sc_hd__decap_8
XFILLER_0_50_27 VGND VGND VPWR VPWR sky130_fd_sc_hd__fill_1
X_16203_ clknet_leaf_51_clk _00820_ VGND VGND VPWR VPWR net208 sky130_fd_sc_hd__dfxtp_1
X_13415_ _06751_ _06890_ _06895_ _06798_ VGND VGND VPWR VPWR _06896_ sky130_fd_sc_hd__o211a_1
XFILLER_0_55_169 VGND VGND VPWR VPWR sky130_fd_sc_hd__decap_8
X_11676_ _05456_ VGND VGND VPWR VPWR _00524_ sky130_fd_sc_hd__clkbuf_1
X_10627_ _04830_ _04833_ VGND VGND VPWR VPWR _04834_ sky130_fd_sc_hd__nand2_1
X_14395_ _05018_ net1059 _01551_ VGND VGND VPWR VPWR _01558_ sky130_fd_sc_hd__mux2_1
XFILLER_0_3_417 VGND VGND VPWR VPWR sky130_fd_sc_hd__fill_2
X_10558_ _04127_ _04764_ _04766_ VGND VGND VPWR VPWR _04767_ sky130_fd_sc_hd__a21o_1
Xpicorv32_317 VGND VGND VPWR VPWR picorv32_317/HI pcpi_insn[28] sky130_fd_sc_hd__conb_1
Xpicorv32_306 VGND VGND VPWR VPWR picorv32_306/HI pcpi_insn[17] sky130_fd_sc_hd__conb_1
X_16134_ clknet_leaf_21_clk _07621_ VGND VGND VPWR VPWR reg_out\[12\] sky130_fd_sc_hd__dfxtp_1
X_13346_ _06792_ _06826_ _06828_ _06563_ VGND VGND VPWR VPWR _06829_ sky130_fd_sc_hd__a211o_1
XFILLER_0_3_428 VGND VGND VPWR VPWR sky130_fd_sc_hd__decap_6
Xpicorv32_328 VGND VGND VPWR VPWR picorv32_328/HI trace_data[6] sky130_fd_sc_hd__conb_1
X_13277_ _06761_ VGND VGND VPWR VPWR _00820_ sky130_fd_sc_hd__clkbuf_1
XFILLER_0_59_47 VGND VGND VPWR VPWR sky130_fd_sc_hd__decap_8
XFILLER_0_59_36 VGND VGND VPWR VPWR sky130_fd_sc_hd__decap_4
XFILLER_0_11_228 VGND VGND VPWR VPWR sky130_fd_sc_hd__fill_1
X_16065_ clknet_leaf_147_clk _00715_ VGND VGND VPWR VPWR count_cycle\[8\] sky130_fd_sc_hd__dfxtp_1
Xpicorv32_339 VGND VGND VPWR VPWR picorv32_339/HI trace_data[17] sky130_fd_sc_hd__conb_1
X_10489_ _03900_ _04699_ _03730_ VGND VGND VPWR VPWR _04700_ sky130_fd_sc_hd__a21o_1
X_15016_ _01864_ VGND VGND VPWR VPWR _01887_ sky130_fd_sc_hd__buf_4
X_12228_ _05792_ _05843_ _05844_ _05847_ _05849_ VGND VGND VPWR VPWR _05850_ sky130_fd_sc_hd__a32o_1
X_12159_ _05693_ _05698_ VGND VGND VPWR VPWR _05786_ sky130_fd_sc_hd__or2_1
X_16967_ clknet_leaf_78_clk _01531_ VGND VGND VPWR VPWR cpuregs\[10\]\[22\] sky130_fd_sc_hd__dfxtp_1
XFILLER_0_75_57 VGND VGND VPWR VPWR sky130_fd_sc_hd__decap_4
X_15918_ clknet_leaf_49_clk _00568_ VGND VGND VPWR VPWR cpuregs\[17\]\[20\] sky130_fd_sc_hd__dfxtp_1
XFILLER_0_79_729 VGND VGND VPWR VPWR sky130_fd_sc_hd__decap_4
X_16898_ clknet_leaf_87_clk _01462_ VGND VGND VPWR VPWR cpuregs\[8\]\[17\] sky130_fd_sc_hd__dfxtp_1
X_15849_ clknet_leaf_55_clk _00499_ VGND VGND VPWR VPWR cpuregs\[25\]\[15\] sky130_fd_sc_hd__dfxtp_1
X_09370_ reg_pc\[26\] _03607_ VGND VGND VPWR VPWR _03612_ sky130_fd_sc_hd__and2_1
X_08321_ net183 net215 VGND VGND VPWR VPWR _02702_ sky130_fd_sc_hd__nand2_1
X_08252_ _02268_ _02626_ _02635_ VGND VGND VPWR VPWR _07639_ sky130_fd_sc_hd__o21a_1
XFILLER_0_55_670 VGND VGND VPWR VPWR sky130_fd_sc_hd__fill_2
XFILLER_0_7_767 VPWR VGND VPWR VGND sky130_ef_sc_hd__decap_12
Xclkbuf_4_12_0_clk clknet_0_clk VGND VGND VPWR VPWR clknet_4_12_0_clk sky130_fd_sc_hd__clkbuf_8
X_08183_ count_instr\[25\] _02201_ _02233_ count_instr\[57\] VGND VGND VPWR VPWR _02571_
+ sky130_fd_sc_hd__a22o_1
XFILLER_0_40_60 VPWR VGND VPWR VGND sky130_ef_sc_hd__decap_12
XFILLER_0_30_504 VGND VGND VPWR VPWR sky130_fd_sc_hd__decap_6
XFILLER_0_40_82 VGND VGND VPWR VPWR sky130_fd_sc_hd__fill_2
XFILLER_0_113_764 VGND VGND VPWR VPWR sky130_fd_sc_hd__decap_4
Xoutput220 net220 VGND VGND VPWR VPWR pcpi_rs2[25] sky130_fd_sc_hd__clkbuf_4
Xoutput231 net231 VGND VGND VPWR VPWR pcpi_rs2[6] sky130_fd_sc_hd__clkbuf_4
XFILLER_0_10_250 VGND VGND VPWR VPWR sky130_fd_sc_hd__fill_2
X_07967_ _02197_ _02363_ _02365_ _02222_ _02369_ VGND VGND VPWR VPWR _07619_ sky130_fd_sc_hd__a221o_1
X_09706_ _03864_ VGND VGND VPWR VPWR _03938_ sky130_fd_sc_hd__buf_8
X_07898_ reg_pc\[6\] decoded_imm\[6\] VGND VGND VPWR VPWR _02305_ sky130_fd_sc_hd__nor2_1
X_09637_ _03839_ VGND VGND VPWR VPWR _03870_ sky130_fd_sc_hd__clkbuf_8
X_09568_ cpuregs\[8\]\[2\] cpuregs\[9\]\[2\] _03801_ VGND VGND VPWR VPWR _03802_ sky130_fd_sc_hd__mux2_1
XFILLER_0_139_149 VPWR VGND VPWR VGND sky130_ef_sc_hd__decap_12
X_08519_ _02846_ VGND VGND VPWR VPWR _02895_ sky130_fd_sc_hd__clkbuf_4
X_09499_ _03677_ _03721_ _03733_ _03660_ VGND VGND VPWR VPWR _03734_ sky130_fd_sc_hd__a211oi_1
X_11530_ _05379_ VGND VGND VPWR VPWR _00455_ sky130_fd_sc_hd__clkbuf_1
XFILLER_0_92_264 VGND VGND VPWR VPWR sky130_fd_sc_hd__decap_4
XFILLER_0_92_253 VGND VGND VPWR VPWR sky130_fd_sc_hd__fill_2
XFILLER_0_52_106 VGND VGND VPWR VPWR sky130_fd_sc_hd__decap_6
XFILLER_0_25_309 VGND VGND VPWR VPWR sky130_fd_sc_hd__fill_1
XFILLER_0_52_139 VGND VGND VPWR VPWR sky130_fd_sc_hd__fill_1
X_11461_ _05342_ VGND VGND VPWR VPWR _00423_ sky130_fd_sc_hd__clkbuf_1
X_10412_ cpuregs\[0\]\[23\] cpuregs\[1\]\[23\] _03824_ VGND VGND VPWR VPWR _04625_
+ sky130_fd_sc_hd__mux2_1
X_13200_ _03347_ VGND VGND VPWR VPWR _06687_ sky130_fd_sc_hd__buf_4
XFILLER_0_61_673 VGND VGND VPWR VPWR sky130_fd_sc_hd__fill_2
X_14180_ _02086_ _02112_ _03291_ VGND VGND VPWR VPWR _07511_ sky130_fd_sc_hd__or3_1
X_11392_ net1482 _05167_ _05302_ VGND VGND VPWR VPWR _05306_ sky130_fd_sc_hd__mux2_1
X_10343_ _04127_ _04555_ _04557_ VGND VGND VPWR VPWR _04558_ sky130_fd_sc_hd__a21o_1
XFILLER_0_60_172 VGND VGND VPWR VPWR sky130_fd_sc_hd__fill_1
X_13131_ _06447_ _06617_ _06619_ _06453_ VGND VGND VPWR VPWR _06620_ sky130_fd_sc_hd__a211o_1
XFILLER_0_131_561 VGND VGND VPWR VPWR sky130_fd_sc_hd__decap_3
X_10274_ _04030_ _04486_ _04490_ _03659_ VGND VGND VPWR VPWR _04491_ sky130_fd_sc_hd__o211a_1
X_13062_ _06518_ _06552_ VGND VGND VPWR VPWR _06553_ sky130_fd_sc_hd__or2_1
X_12013_ _05631_ _05677_ VGND VGND VPWR VPWR _05678_ sky130_fd_sc_hd__nor2_1
X_16821_ clknet_leaf_123_clk _01385_ VGND VGND VPWR VPWR cpuregs\[7\]\[4\] sky130_fd_sc_hd__dfxtp_1
X_16752_ clknet_leaf_103_clk _01316_ VGND VGND VPWR VPWR cpuregs\[4\]\[31\] sky130_fd_sc_hd__dfxtp_1
X_15703_ clknet_leaf_64_clk _00353_ VGND VGND VPWR VPWR cpuregs\[27\]\[29\] sky130_fd_sc_hd__dfxtp_1
X_13964_ is_alu_reg_reg _07329_ net241 _07388_ _02122_ VGND VGND VPWR VPWR _07389_
+ sky130_fd_sc_hd__a32o_1
X_16683_ clknet_leaf_69_clk _01250_ VGND VGND VPWR VPWR cpuregs\[29\]\[29\] sky130_fd_sc_hd__dfxtp_1
X_13895_ instr_bge _07325_ _07343_ _02149_ VGND VGND VPWR VPWR _07344_ sky130_fd_sc_hd__a22o_1
X_12915_ _06410_ _02753_ _06375_ VGND VGND VPWR VPWR _06411_ sky130_fd_sc_hd__mux2_1
XTAP_2161 VGND VPWR sky130_fd_sc_hd__tapvpwrvgnd_1
XTAP_2150 VGND VPWR sky130_fd_sc_hd__tapvpwrvgnd_1
X_15634_ clknet_leaf_58_clk _00284_ VGND VGND VPWR VPWR cpuregs\[31\]\[24\] sky130_fd_sc_hd__dfxtp_1
X_12846_ _00008_ VGND VGND VPWR VPWR _06345_ sky130_fd_sc_hd__clkbuf_8
XFILLER_0_0_29 VGND VGND VPWR VPWR sky130_fd_sc_hd__decap_3
XTAP_2194 VGND VPWR sky130_fd_sc_hd__tapvpwrvgnd_1
XTAP_2183 VGND VPWR sky130_fd_sc_hd__tapvpwrvgnd_1
XTAP_2172 VGND VPWR sky130_fd_sc_hd__tapvpwrvgnd_1
X_15565_ clknet_leaf_93_clk _00215_ VGND VGND VPWR VPWR cpuregs\[2\]\[19\] sky130_fd_sc_hd__dfxtp_1
XTAP_1460 VGND VPWR sky130_fd_sc_hd__tapvpwrvgnd_1
X_12777_ net543 net95 _06302_ VGND VGND VPWR VPWR _06303_ sky130_fd_sc_hd__mux2_1
XFILLER_0_131_6 VGND VGND VPWR VPWR sky130_fd_sc_hd__fill_2
XFILLER_0_126_300 VGND VGND VPWR VPWR sky130_fd_sc_hd__decap_8
XTAP_1493 VGND VPWR sky130_fd_sc_hd__tapvpwrvgnd_1
XTAP_1482 VGND VPWR sky130_fd_sc_hd__tapvpwrvgnd_1
XTAP_1471 VGND VPWR sky130_fd_sc_hd__tapvpwrvgnd_1
XFILLER_0_56_456 VGND VGND VPWR VPWR sky130_fd_sc_hd__fill_2
X_14516_ net674 _05179_ _01612_ VGND VGND VPWR VPWR _01622_ sky130_fd_sc_hd__mux2_1
X_15496_ clknet_leaf_136_clk _00146_ VGND VGND VPWR VPWR cpuregs\[30\]\[14\] sky130_fd_sc_hd__dfxtp_1
X_11728_ _05484_ VGND VGND VPWR VPWR _00548_ sky130_fd_sc_hd__clkbuf_1
XFILLER_0_16_309 VGND VGND VPWR VPWR sky130_fd_sc_hd__decap_3
X_11659_ net1239 _05159_ _05447_ VGND VGND VPWR VPWR _05448_ sky130_fd_sc_hd__mux2_1
X_14447_ _01585_ VGND VGND VPWR VPWR _01069_ sky130_fd_sc_hd__clkbuf_1
XFILLER_0_4_737 VPWR VGND VPWR VGND sky130_ef_sc_hd__decap_12
XFILLER_0_3_214 VGND VGND VPWR VPWR sky130_fd_sc_hd__decap_4
X_14378_ _05001_ net1518 _07616_ VGND VGND VPWR VPWR _01549_ sky130_fd_sc_hd__mux2_1
Xhold917 cpuregs\[27\]\[20\] VGND VGND VPWR VPWR net1275 sky130_fd_sc_hd__dlygate4sd3_1
X_13329_ _06639_ _06811_ VGND VGND VPWR VPWR _06812_ sky130_fd_sc_hd__and2_1
Xhold906 cpuregs\[5\]\[17\] VGND VGND VPWR VPWR net1264 sky130_fd_sc_hd__dlygate4sd3_1
Xhold928 cpuregs\[27\]\[31\] VGND VGND VPWR VPWR net1286 sky130_fd_sc_hd__dlygate4sd3_1
X_16117_ clknet_leaf_0_clk _00767_ VGND VGND VPWR VPWR count_cycle\[60\] sky130_fd_sc_hd__dfxtp_1
Xhold939 cpuregs\[3\]\[1\] VGND VGND VPWR VPWR net1297 sky130_fd_sc_hd__dlygate4sd3_1
XFILLER_0_12_559 VGND VGND VPWR VPWR sky130_fd_sc_hd__fill_1
X_16048_ clknet_leaf_34_clk _00698_ VGND VGND VPWR VPWR reg_next_pc\[23\] sky130_fd_sc_hd__dfxtp_1
XFILLER_0_86_56 VGND VGND VPWR VPWR sky130_fd_sc_hd__fill_2
X_08870_ net207 _03204_ _03210_ VGND VGND VPWR VPWR net101 sky130_fd_sc_hd__a21o_4
X_07821_ _02203_ VGND VGND VPWR VPWR _02233_ sky130_fd_sc_hd__buf_2
XFILLER_0_43_7 VGND VGND VPWR VPWR sky130_fd_sc_hd__fill_2
X_07752_ is_jalr_addi_slti_sltiu_xori_ori_andi is_lui_auipc_jal VGND VGND VPWR VPWR
+ _02171_ sky130_fd_sc_hd__nor2_4
X_07683_ mem_state\[0\] mem_state\[1\] VGND VGND VPWR VPWR _02112_ sky130_fd_sc_hd__nor2_1
X_09422_ _00015_ VGND VGND VPWR VPWR _03658_ sky130_fd_sc_hd__inv_4
X_09353_ net1311 _03597_ _03578_ VGND VGND VPWR VPWR _03598_ sky130_fd_sc_hd__mux2_1
XFILLER_0_87_570 VGND VGND VPWR VPWR sky130_fd_sc_hd__fill_2
X_08304_ net206 VGND VGND VPWR VPWR _02685_ sky130_fd_sc_hd__buf_2
X_09284_ _03537_ VGND VGND VPWR VPWR _03538_ sky130_fd_sc_hd__clkbuf_4
XFILLER_0_19_169 VGND VGND VPWR VPWR sky130_fd_sc_hd__fill_2
XFILLER_0_28_670 VGND VGND VPWR VPWR sky130_fd_sc_hd__decap_3
X_08235_ net21 _02447_ _02428_ VGND VGND VPWR VPWR _02620_ sky130_fd_sc_hd__a21o_1
XFILLER_0_90_757 VGND VGND VPWR VPWR sky130_fd_sc_hd__fill_2
XFILLER_0_7_586 VGND VGND VPWR VPWR sky130_fd_sc_hd__decap_6
X_08166_ count_cycle\[24\] _02454_ _02553_ _02554_ VGND VGND VPWR VPWR _02555_ sky130_fd_sc_hd__a211o_2
XFILLER_0_120_509 VGND VGND VPWR VPWR sky130_fd_sc_hd__fill_1
XFILLER_0_101_723 VGND VGND VPWR VPWR sky130_fd_sc_hd__decap_4
X_08097_ _02475_ _02486_ _02489_ _02170_ VGND VGND VPWR VPWR _02491_ sky130_fd_sc_hd__a31oi_1
XFILLER_0_101_745 VGND VGND VPWR VPWR sky130_fd_sc_hd__decap_8
XFILLER_0_30_378 VGND VGND VPWR VPWR sky130_fd_sc_hd__decap_6
XFILLER_0_100_277 VGND VGND VPWR VPWR sky130_fd_sc_hd__fill_1
X_08999_ _02089_ VGND VGND VPWR VPWR _03291_ sky130_fd_sc_hd__buf_4
X_10961_ _05061_ VGND VGND VPWR VPWR _00204_ sky130_fd_sc_hd__clkbuf_1
X_13680_ cpuregs\[6\]\[27\] cpuregs\[7\]\[27\] _06842_ VGND VGND VPWR VPWR _07152_
+ sky130_fd_sc_hd__mux2_1
X_12700_ net412 VGND VGND VPWR VPWR _06240_ sky130_fd_sc_hd__inv_2
X_10892_ _05017_ VGND VGND VPWR VPWR _00179_ sky130_fd_sc_hd__clkbuf_1
X_12631_ _06190_ VGND VGND VPWR VPWR _00745_ sky130_fd_sc_hd__clkbuf_1
XFILLER_0_66_743 VGND VGND VPWR VPWR sky130_fd_sc_hd__fill_1
X_15350_ _03571_ net1136 _02052_ VGND VGND VPWR VPWR _02062_ sky130_fd_sc_hd__mux2_1
XFILLER_0_65_253 VGND VGND VPWR VPWR sky130_fd_sc_hd__fill_1
XFILLER_0_53_404 VGND VGND VPWR VPWR sky130_fd_sc_hd__decap_4
X_12562_ _06141_ VGND VGND VPWR VPWR _00725_ sky130_fd_sc_hd__clkbuf_1
XFILLER_0_38_467 VGND VGND VPWR VPWR sky130_fd_sc_hd__fill_1
X_11513_ _05369_ VGND VGND VPWR VPWR _00448_ sky130_fd_sc_hd__clkbuf_1
X_12493_ _05790_ _05760_ _06092_ _05802_ VGND VGND VPWR VPWR _06093_ sky130_fd_sc_hd__a22o_1
X_15281_ net534 VGND VGND VPWR VPWR _02026_ sky130_fd_sc_hd__clkbuf_1
XFILLER_0_80_223 VGND VGND VPWR VPWR sky130_fd_sc_hd__decap_8
X_14301_ mem_rdata_q\[25\] _07576_ VGND VGND VPWR VPWR _07581_ sky130_fd_sc_hd__and2_1
XFILLER_0_19_681 VGND VGND VPWR VPWR sky130_fd_sc_hd__fill_1
X_11444_ net1188 _05219_ _05324_ VGND VGND VPWR VPWR _05333_ sky130_fd_sc_hd__mux2_1
X_14232_ _07518_ VGND VGND VPWR VPWR _07541_ sky130_fd_sc_hd__buf_12
XFILLER_0_34_662 VGND VGND VPWR VPWR sky130_fd_sc_hd__fill_1
X_14163_ _05043_ net1292 _07493_ VGND VGND VPWR VPWR _07502_ sky130_fd_sc_hd__mux2_1
X_11375_ _05296_ VGND VGND VPWR VPWR _00383_ sky130_fd_sc_hd__clkbuf_1
X_10326_ decoded_imm\[21\] net184 VGND VGND VPWR VPWR _04541_ sky130_fd_sc_hd__nand2_1
X_13114_ _06351_ _06602_ _03377_ VGND VGND VPWR VPWR _06603_ sky130_fd_sc_hd__a21o_1
XTAP_507 VGND VPWR sky130_fd_sc_hd__tapvpwrvgnd_1
X_14094_ is_slli_srli_srai _07382_ _07364_ _07465_ VGND VGND VPWR VPWR _00912_ sky130_fd_sc_hd__a22o_1
X_10257_ decoded_imm\[19\] _02493_ VGND VGND VPWR VPWR _04474_ sky130_fd_sc_hd__nand2_1
XTAP_518 VGND VPWR sky130_fd_sc_hd__tapvpwrvgnd_1
XTAP_529 VGND VPWR sky130_fd_sc_hd__tapvpwrvgnd_1
X_13045_ cpuregs\[12\]\[8\] cpuregs\[13\]\[8\] cpuregs\[14\]\[8\] cpuregs\[15\]\[8\]
+ _06418_ _06419_ VGND VGND VPWR VPWR _06536_ sky130_fd_sc_hd__mux4_1
X_10188_ _04404_ _04405_ _04406_ VGND VGND VPWR VPWR _04407_ sky130_fd_sc_hd__a21oi_1
X_16804_ clknet_leaf_90_clk _01368_ VGND VGND VPWR VPWR cpuregs\[6\]\[19\] sky130_fd_sc_hd__dfxtp_1
X_14996_ _03511_ net1118 _01876_ VGND VGND VPWR VPWR _01877_ sky130_fd_sc_hd__mux2_1
X_16735_ clknet_leaf_106_clk _01299_ VGND VGND VPWR VPWR cpuregs\[4\]\[14\] sky130_fd_sc_hd__dfxtp_1
X_13947_ _02140_ VGND VGND VPWR VPWR _07377_ sky130_fd_sc_hd__buf_2
XFILLER_0_88_345 VGND VGND VPWR VPWR sky130_fd_sc_hd__decap_4
X_16666_ clknet_leaf_135_clk _01233_ VGND VGND VPWR VPWR cpuregs\[29\]\[12\] sky130_fd_sc_hd__dfxtp_1
X_13878_ instr_beq _07325_ _07329_ _02149_ VGND VGND VPWR VPWR _07330_ sky130_fd_sc_hd__a22o_1
X_15617_ clknet_leaf_130_clk _00267_ VGND VGND VPWR VPWR cpuregs\[31\]\[7\] sky130_fd_sc_hd__dfxtp_1
X_12829_ _02174_ _02182_ _02116_ VGND VGND VPWR VPWR _06331_ sky130_fd_sc_hd__a21o_1
X_16597_ clknet_leaf_111_clk _01164_ VGND VGND VPWR VPWR cpuregs\[9\]\[7\] sky130_fd_sc_hd__dfxtp_1
XTAP_1290 VGND VPWR sky130_fd_sc_hd__tapvpwrvgnd_1
X_15548_ clknet_leaf_131_clk _00198_ VGND VGND VPWR VPWR cpuregs\[2\]\[2\] sky130_fd_sc_hd__dfxtp_1
X_15479_ clknet_leaf_70_clk _00129_ VGND VGND VPWR VPWR cpuregs\[12\]\[29\] sky130_fd_sc_hd__dfxtp_1
XFILLER_0_44_448 VGND VGND VPWR VPWR sky130_fd_sc_hd__decap_3
Xclkbuf_leaf_150_clk clknet_4_0_0_clk VGND VGND VPWR VPWR clknet_leaf_150_clk sky130_fd_sc_hd__clkbuf_16
XFILLER_0_114_314 VGND VGND VPWR VPWR sky130_fd_sc_hd__fill_1
XFILLER_0_112_75 VGND VGND VPWR VPWR sky130_fd_sc_hd__fill_1
X_08020_ _02207_ _02416_ _02284_ _02418_ VGND VGND VPWR VPWR _02419_ sky130_fd_sc_hd__a22o_1
Xhold703 cpuregs\[26\]\[2\] VGND VGND VPWR VPWR net1061 sky130_fd_sc_hd__dlygate4sd3_1
Xhold714 cpuregs\[27\]\[27\] VGND VGND VPWR VPWR net1072 sky130_fd_sc_hd__dlygate4sd3_1
Xhold736 cpuregs\[2\]\[18\] VGND VGND VPWR VPWR net1094 sky130_fd_sc_hd__dlygate4sd3_1
Xhold725 cpuregs\[9\]\[12\] VGND VGND VPWR VPWR net1083 sky130_fd_sc_hd__dlygate4sd3_1
XFILLER_0_110_542 VGND VGND VPWR VPWR sky130_fd_sc_hd__fill_1
Xhold769 cpuregs\[31\]\[30\] VGND VGND VPWR VPWR net1127 sky130_fd_sc_hd__dlygate4sd3_1
Xhold758 cpuregs\[5\]\[18\] VGND VGND VPWR VPWR net1116 sky130_fd_sc_hd__dlygate4sd3_1
X_09971_ cpuregs\[12\]\[11\] cpuregs\[13\]\[11\] _04058_ VGND VGND VPWR VPWR _04196_
+ sky130_fd_sc_hd__mux2_1
Xhold747 cpuregs\[1\]\[3\] VGND VGND VPWR VPWR net1105 sky130_fd_sc_hd__dlygate4sd3_1
X_08922_ _03238_ VGND VGND VPWR VPWR net93 sky130_fd_sc_hd__buf_2
X_08853_ _02132_ _02133_ VGND VGND VPWR VPWR _03202_ sky130_fd_sc_hd__nor2_2
X_08784_ _03126_ _03132_ _03130_ VGND VGND VPWR VPWR _03140_ sky130_fd_sc_hd__o21a_1
XFILLER_0_98_109 VGND VGND VPWR VPWR sky130_fd_sc_hd__decap_4
X_07804_ _02212_ _02214_ _02216_ net8 VGND VGND VPWR VPWR _02217_ sky130_fd_sc_hd__a22o_1
X_07735_ _02155_ VGND VGND VPWR VPWR _02156_ sky130_fd_sc_hd__buf_4
XFILLER_0_79_345 VGND VGND VPWR VPWR sky130_fd_sc_hd__fill_2
X_09405_ _03642_ VGND VGND VPWR VPWR _00067_ sky130_fd_sc_hd__clkbuf_1
X_07666_ mem_do_rdata net34 cpu_state\[6\] VGND VGND VPWR VPWR _02096_ sky130_fd_sc_hd__and3b_1
XFILLER_0_94_359 VGND VGND VPWR VPWR sky130_fd_sc_hd__decap_4
X_09336_ _03546_ _03580_ _03581_ _03582_ VGND VGND VPWR VPWR _03583_ sky130_fd_sc_hd__a22o_2
X_09267_ reg_pc\[12\] _03515_ _03467_ VGND VGND VPWR VPWR _03523_ sky130_fd_sc_hd__a21oi_1
XFILLER_0_118_697 VGND VGND VPWR VPWR sky130_fd_sc_hd__decap_3
X_08218_ net20 _02466_ _02428_ VGND VGND VPWR VPWR _02604_ sky130_fd_sc_hd__a21o_1
Xclkbuf_leaf_141_clk clknet_4_3_0_clk VGND VGND VPWR VPWR clknet_leaf_141_clk sky130_fd_sc_hd__clkbuf_16
XFILLER_0_105_369 VGND VGND VPWR VPWR sky130_fd_sc_hd__decap_3
XFILLER_0_90_587 VGND VGND VPWR VPWR sky130_fd_sc_hd__fill_1
X_09198_ _03434_ _03458_ _03461_ _03462_ VGND VGND VPWR VPWR _03463_ sky130_fd_sc_hd__a22o_2
X_08149_ count_cycle\[22\] _02232_ _02539_ VGND VGND VPWR VPWR _02540_ sky130_fd_sc_hd__a21o_1
XFILLER_0_31_654 VGND VGND VPWR VPWR sky130_fd_sc_hd__fill_1
X_11160_ _03471_ VGND VGND VPWR VPWR _05169_ sky130_fd_sc_hd__clkbuf_4
X_10111_ cpuregs\[14\]\[15\] cpuregs\[15\]\[15\] _03801_ VGND VGND VPWR VPWR _04332_
+ sky130_fd_sc_hd__mux2_1
X_11091_ _05130_ VGND VGND VPWR VPWR _00265_ sky130_fd_sc_hd__clkbuf_1
XFILLER_0_30_197 VGND VGND VPWR VPWR sky130_fd_sc_hd__fill_1
X_10042_ cpuregs\[14\]\[13\] cpuregs\[15\]\[13\] _03801_ VGND VGND VPWR VPWR _04265_
+ sky130_fd_sc_hd__mux2_1
Xhold41 count_cycle\[0\] VGND VGND VPWR VPWR net399 sky130_fd_sc_hd__clkdlybuf4s25_1
Xhold30 decoded_rd\[3\] VGND VGND VPWR VPWR net388 sky130_fd_sc_hd__dlygate4sd3_1
Xhold63 reg_next_pc\[1\] VGND VGND VPWR VPWR net421 sky130_fd_sc_hd__dlygate4sd3_1
Xhold74 count_cycle\[52\] VGND VGND VPWR VPWR net432 sky130_fd_sc_hd__dlygate4sd3_1
Xhold52 count_cycle\[13\] VGND VGND VPWR VPWR net410 sky130_fd_sc_hd__dlygate4sd3_1
XFILLER_0_26_18 VGND VGND VPWR VPWR sky130_fd_sc_hd__fill_2
X_14850_ _01799_ VGND VGND VPWR VPWR _01290_ sky130_fd_sc_hd__clkbuf_1
XFILLER_0_98_643 VGND VGND VPWR VPWR sky130_fd_sc_hd__fill_1
XFILLER_0_98_610 VGND VGND VPWR VPWR sky130_fd_sc_hd__fill_1
X_13801_ _06457_ _07268_ VGND VGND VPWR VPWR _07269_ sky130_fd_sc_hd__and2_1
Xhold85 count_cycle\[41\] VGND VGND VPWR VPWR net443 sky130_fd_sc_hd__dlygate4sd3_1
Xhold96 _00734_ VGND VGND VPWR VPWR net454 sky130_fd_sc_hd__dlygate4sd3_1
X_14781_ _01762_ VGND VGND VPWR VPWR _01258_ sky130_fd_sc_hd__clkbuf_1
X_13732_ cpuregs\[12\]\[29\] cpuregs\[13\]\[29\] cpuregs\[14\]\[29\] cpuregs\[15\]\[29\]
+ _07027_ _06392_ VGND VGND VPWR VPWR _07202_ sky130_fd_sc_hd__mux4_1
XFILLER_0_97_153 VGND VGND VPWR VPWR sky130_fd_sc_hd__fill_2
X_11993_ count_instr\[53\] count_instr\[52\] count_instr\[51\] _05654_ VGND VGND VPWR
+ VPWR _05664_ sky130_fd_sc_hd__and4_2
X_16520_ clknet_leaf_2_clk _01097_ VGND VGND VPWR VPWR mem_rdata_q\[4\] sky130_fd_sc_hd__dfxtp_1
X_10944_ _04981_ net1107 _05052_ VGND VGND VPWR VPWR _05053_ sky130_fd_sc_hd__mux2_1
X_13663_ cpuregs\[28\]\[26\] cpuregs\[29\]\[26\] _07018_ VGND VGND VPWR VPWR _07136_
+ sky130_fd_sc_hd__mux2_1
X_10875_ _04984_ VGND VGND VPWR VPWR _05006_ sky130_fd_sc_hd__buf_4
XFILLER_0_85_337 VGND VGND VPWR VPWR sky130_fd_sc_hd__fill_1
X_16451_ clknet_leaf_127_clk _01033_ VGND VGND VPWR VPWR cpuregs\[18\]\[4\] sky130_fd_sc_hd__dfxtp_1
XFILLER_0_38_231 VPWR VGND VPWR VGND sky130_ef_sc_hd__decap_12
X_15402_ clknet_leaf_83_clk _00057_ VGND VGND VPWR VPWR cpuregs\[11\]\[20\] sky130_fd_sc_hd__dfxtp_1
X_13594_ _06455_ _07063_ _07068_ VGND VGND VPWR VPWR _07069_ sky130_fd_sc_hd__o21ba_1
X_16382_ clknet_leaf_144_clk _00964_ VGND VGND VPWR VPWR net166 sky130_fd_sc_hd__dfxtp_1
X_12614_ count_cycle\[32\] count_cycle\[33\] count_cycle\[34\] _06171_ VGND VGND VPWR
+ VPWR _06178_ sky130_fd_sc_hd__and4_2
X_15333_ _02053_ VGND VGND VPWR VPWR _01519_ sky130_fd_sc_hd__clkbuf_1
XFILLER_0_53_212 VPWR VGND VPWR VGND sky130_ef_sc_hd__decap_12
XFILLER_0_5_309 VGND VGND VPWR VPWR sky130_fd_sc_hd__fill_1
X_12545_ _06127_ _06128_ _06129_ VGND VGND VPWR VPWR _06130_ sky130_fd_sc_hd__and3b_1
XFILLER_0_108_174 VGND VGND VPWR VPWR sky130_fd_sc_hd__fill_1
XFILLER_0_53_256 VGND VGND VPWR VPWR sky130_fd_sc_hd__fill_1
XFILLER_0_53_234 VGND VGND VPWR VPWR sky130_fd_sc_hd__decap_4
Xclkbuf_leaf_132_clk clknet_4_9_0_clk VGND VGND VPWR VPWR clknet_leaf_132_clk sky130_fd_sc_hd__clkbuf_16
X_12476_ _06005_ _05757_ VGND VGND VPWR VPWR _06077_ sky130_fd_sc_hd__xor2_1
XFILLER_0_123_133 VGND VGND VPWR VPWR sky130_fd_sc_hd__decap_4
X_15264_ _02017_ VGND VGND VPWR VPWR _01486_ sky130_fd_sc_hd__clkbuf_1
XFILLER_0_123_166 VGND VGND VPWR VPWR sky130_fd_sc_hd__fill_2
X_11427_ _05301_ VGND VGND VPWR VPWR _05324_ sky130_fd_sc_hd__buf_4
XANTENNA_5 _02473_ VGND VGND VPWR VPWR sky130_fd_sc_hd__diode_2
XFILLER_0_21_120 VGND VGND VPWR VPWR sky130_fd_sc_hd__decap_3
X_15195_ _03498_ net805 _01973_ VGND VGND VPWR VPWR _01982_ sky130_fd_sc_hd__mux2_1
X_14215_ _07532_ VGND VGND VPWR VPWR _00966_ sky130_fd_sc_hd__clkbuf_1
XFILLER_0_123_199 VGND VGND VPWR VPWR sky130_fd_sc_hd__decap_3
X_14146_ _07470_ VGND VGND VPWR VPWR _07493_ sky130_fd_sc_hd__buf_4
X_11358_ _05287_ VGND VGND VPWR VPWR _00375_ sky130_fd_sc_hd__clkbuf_1
XFILLER_0_10_805 VGND VGND VPWR VPWR sky130_fd_sc_hd__decap_6
X_10309_ cpuregs\[4\]\[20\] cpuregs\[5\]\[20\] cpuregs\[6\]\[20\] cpuregs\[7\]\[20\]
+ _03894_ _04090_ VGND VGND VPWR VPWR _04525_ sky130_fd_sc_hd__mux4_1
XTAP_315 VGND VPWR sky130_fd_sc_hd__tapvpwrvgnd_1
XTAP_304 VGND VPWR sky130_fd_sc_hd__tapvpwrvgnd_1
X_11289_ _05250_ VGND VGND VPWR VPWR _00343_ sky130_fd_sc_hd__clkbuf_1
X_14077_ decoded_imm_j\[11\] _01113_ _03295_ VGND VGND VPWR VPWR _07455_ sky130_fd_sc_hd__mux2_1
XTAP_348 VGND VPWR sky130_fd_sc_hd__tapvpwrvgnd_1
XTAP_337 VGND VPWR sky130_fd_sc_hd__tapvpwrvgnd_1
XTAP_326 VGND VPWR sky130_fd_sc_hd__tapvpwrvgnd_1
XTAP_359 VGND VPWR sky130_fd_sc_hd__tapvpwrvgnd_1
X_13028_ _06518_ _06519_ VGND VGND VPWR VPWR _06520_ sky130_fd_sc_hd__or2_1
Xrebuffer17 _06150_ VGND VGND VPWR VPWR net375 sky130_fd_sc_hd__clkbuf_1
XFILLER_0_83_79 VGND VGND VPWR VPWR sky130_fd_sc_hd__fill_1
X_14979_ _03456_ net1068 _01865_ VGND VGND VPWR VPWR _01868_ sky130_fd_sc_hd__mux2_1
XFILLER_0_107_86 VGND VGND VPWR VPWR sky130_fd_sc_hd__decap_4
XFILLER_0_77_827 VGND VGND VPWR VPWR sky130_fd_sc_hd__fill_1
X_16718_ clknet_leaf_13_clk _00024_ VGND VGND VPWR VPWR mem_wordsize\[0\] sky130_fd_sc_hd__dfxtp_1
X_16649_ clknet_leaf_63_clk _01216_ VGND VGND VPWR VPWR cpuregs\[23\]\[27\] sky130_fd_sc_hd__dfxtp_1
XFILLER_0_9_615 VGND VGND VPWR VPWR sky130_fd_sc_hd__fill_1
X_09121_ _03324_ VGND VGND VPWR VPWR _03400_ sky130_fd_sc_hd__buf_4
XFILLER_0_32_50 VGND VGND VPWR VPWR sky130_fd_sc_hd__fill_2
XFILLER_0_115_612 VGND VGND VPWR VPWR sky130_fd_sc_hd__decap_4
Xclkbuf_leaf_123_clk clknet_4_8_0_clk VGND VGND VPWR VPWR clknet_leaf_123_clk sky130_fd_sc_hd__clkbuf_16
XFILLER_0_72_587 VGND VGND VPWR VPWR sky130_fd_sc_hd__fill_1
XFILLER_0_44_278 VGND VGND VPWR VPWR sky130_fd_sc_hd__decap_4
X_09052_ _03328_ _03331_ _03332_ VGND VGND VPWR VPWR _03333_ sky130_fd_sc_hd__o21a_1
XFILLER_0_115_689 VGND VGND VPWR VPWR sky130_fd_sc_hd__decap_4
Xhold500 cpuregs\[14\]\[29\] VGND VGND VPWR VPWR net858 sky130_fd_sc_hd__dlygate4sd3_1
XFILLER_0_102_306 VGND VGND VPWR VPWR sky130_fd_sc_hd__fill_2
X_08003_ net175 VGND VGND VPWR VPWR _02403_ sky130_fd_sc_hd__clkbuf_4
Xhold511 cpuregs\[11\]\[2\] VGND VGND VPWR VPWR net869 sky130_fd_sc_hd__dlygate4sd3_1
XFILLER_0_102_339 VGND VGND VPWR VPWR sky130_fd_sc_hd__decap_3
Xhold522 cpuregs\[12\]\[18\] VGND VGND VPWR VPWR net880 sky130_fd_sc_hd__dlygate4sd3_1
Xhold533 cpuregs\[1\]\[1\] VGND VGND VPWR VPWR net891 sky130_fd_sc_hd__dlygate4sd3_1
Xhold544 cpuregs\[7\]\[6\] VGND VGND VPWR VPWR net902 sky130_fd_sc_hd__dlygate4sd3_1
Xhold555 cpuregs\[17\]\[21\] VGND VGND VPWR VPWR net913 sky130_fd_sc_hd__dlygate4sd3_1
Xhold577 cpuregs\[12\]\[20\] VGND VGND VPWR VPWR net935 sky130_fd_sc_hd__dlygate4sd3_1
Xhold588 cpuregs\[19\]\[11\] VGND VGND VPWR VPWR net946 sky130_fd_sc_hd__dlygate4sd3_1
Xhold566 cpuregs\[26\]\[7\] VGND VGND VPWR VPWR net924 sky130_fd_sc_hd__dlygate4sd3_1
Xhold599 cpuregs\[11\]\[26\] VGND VGND VPWR VPWR net957 sky130_fd_sc_hd__dlygate4sd3_1
X_09954_ cpuregs\[16\]\[10\] cpuregs\[17\]\[10\] cpuregs\[18\]\[10\] cpuregs\[19\]\[10\]
+ _03941_ _04028_ VGND VGND VPWR VPWR _04180_ sky130_fd_sc_hd__mux4_1
X_09885_ _04077_ _04080_ _04079_ VGND VGND VPWR VPWR _04112_ sky130_fd_sc_hd__o21a_1
X_08905_ _02111_ VGND VGND VPWR VPWR _03227_ sky130_fd_sc_hd__buf_4
Xhold1200 cpuregs\[23\]\[6\] VGND VGND VPWR VPWR net1558 sky130_fd_sc_hd__dlygate4sd3_1
XTAP_860 VGND VPWR sky130_fd_sc_hd__tapvpwrvgnd_1
XTAP_871 VGND VPWR sky130_fd_sc_hd__tapvpwrvgnd_1
X_08836_ _02857_ _03186_ VGND VGND VPWR VPWR _03187_ sky130_fd_sc_hd__or2_1
Xhold1222 cpuregs\[9\]\[28\] VGND VGND VPWR VPWR net1580 sky130_fd_sc_hd__dlygate4sd3_1
Xhold1233 cpuregs\[26\]\[1\] VGND VGND VPWR VPWR net1591 sky130_fd_sc_hd__dlygate4sd3_1
XTAP_882 VGND VPWR sky130_fd_sc_hd__tapvpwrvgnd_1
Xhold1211 cpuregs\[21\]\[9\] VGND VGND VPWR VPWR net1569 sky130_fd_sc_hd__dlygate4sd3_1
XTAP_893 VGND VPWR sky130_fd_sc_hd__tapvpwrvgnd_1
Xhold1266 net143 VGND VGND VPWR VPWR net1624 sky130_fd_sc_hd__dlygate4sd3_1
Xhold1244 decoded_imm\[28\] VGND VGND VPWR VPWR net1602 sky130_fd_sc_hd__dlygate4sd3_1
Xhold1255 cpuregs\[24\]\[31\] VGND VGND VPWR VPWR net1613 sky130_fd_sc_hd__dlygate4sd3_1
X_08767_ _02548_ _03103_ _03123_ VGND VGND VPWR VPWR _03124_ sky130_fd_sc_hd__o21ai_1
Xhold1299 decoded_imm\[12\] VGND VGND VPWR VPWR net1657 sky130_fd_sc_hd__dlygate4sd3_1
Xhold1277 cpuregs\[23\]\[1\] VGND VGND VPWR VPWR net1635 sky130_fd_sc_hd__dlygate4sd3_1
Xhold1288 is_alu_reg_reg VGND VGND VPWR VPWR net1646 sky130_fd_sc_hd__dlygate4sd3_1
X_08698_ _03057_ _03059_ VGND VGND VPWR VPWR _03060_ sky130_fd_sc_hd__xor2_1
X_07718_ mem_wordsize\[1\] VGND VGND VPWR VPWR _02143_ sky130_fd_sc_hd__clkbuf_4
XFILLER_0_137_225 VGND VGND VPWR VPWR sky130_fd_sc_hd__fill_1
X_10660_ _02082_ _04834_ _04835_ _04866_ VGND VGND VPWR VPWR _04867_ sky130_fd_sc_hd__a31o_1
XFILLER_0_82_318 VPWR VGND VPWR VGND sky130_ef_sc_hd__decap_12
X_09319_ reg_pc\[19\] reg_pc\[18\] _03554_ VGND VGND VPWR VPWR _03568_ sky130_fd_sc_hd__and3_1
X_10591_ _04795_ _04798_ VGND VGND VPWR VPWR _04799_ sky130_fd_sc_hd__xnor2_1
Xclkbuf_leaf_114_clk clknet_4_10_0_clk VGND VGND VPWR VPWR clknet_leaf_114_clk sky130_fd_sc_hd__clkbuf_16
XFILLER_0_105_133 VGND VGND VPWR VPWR sky130_fd_sc_hd__fill_1
XFILLER_0_105_111 VGND VGND VPWR VPWR sky130_fd_sc_hd__fill_1
X_12330_ _05852_ net463 _05816_ _05943_ VGND VGND VPWR VPWR _00691_ sky130_fd_sc_hd__o211a_1
XFILLER_0_120_103 VGND VGND VPWR VPWR sky130_fd_sc_hd__fill_2
X_12261_ _05870_ _05872_ _05869_ VGND VGND VPWR VPWR _05880_ sky130_fd_sc_hd__a21boi_1
X_11212_ _05204_ VGND VGND VPWR VPWR _00312_ sky130_fd_sc_hd__clkbuf_1
X_14000_ mem_rdata_q\[2\] mem_rdata_q\[3\] mem_rdata_q\[0\] mem_rdata_q\[1\] VGND
+ VGND VPWR VPWR _07415_ sky130_fd_sc_hd__and4bb_1
X_12192_ _05523_ VGND VGND VPWR VPWR _05816_ sky130_fd_sc_hd__clkbuf_4
Xoutput42 net42 VGND VGND VPWR VPWR mem_addr[17] sky130_fd_sc_hd__clkbuf_4
Xoutput64 net64 VGND VGND VPWR VPWR mem_addr[9] sky130_fd_sc_hd__clkbuf_4
XFILLER_0_101_383 VGND VGND VPWR VPWR sky130_fd_sc_hd__fill_1
X_11143_ _05157_ VGND VGND VPWR VPWR _00290_ sky130_fd_sc_hd__clkbuf_1
Xoutput53 net53 VGND VGND VPWR VPWR mem_addr[28] sky130_fd_sc_hd__clkbuf_4
Xoutput75 net75 VGND VGND VPWR VPWR mem_la_addr[19] sky130_fd_sc_hd__clkbuf_4
Xoutput97 net97 VGND VGND VPWR VPWR mem_la_wdata[0] sky130_fd_sc_hd__clkbuf_4
X_11074_ net706 _03641_ _05087_ VGND VGND VPWR VPWR _05121_ sky130_fd_sc_hd__mux2_1
X_15951_ clknet_leaf_152_clk _00601_ VGND VGND VPWR VPWR count_instr\[20\] sky130_fd_sc_hd__dfxtp_1
Xoutput86 net86 VGND VGND VPWR VPWR mem_la_addr[2] sky130_fd_sc_hd__clkbuf_4
X_14902_ _01826_ VGND VGND VPWR VPWR _01315_ sky130_fd_sc_hd__clkbuf_1
X_15882_ clknet_leaf_53_clk _00532_ VGND VGND VPWR VPWR cpuregs\[20\]\[16\] sky130_fd_sc_hd__dfxtp_1
X_10025_ cpuregs\[24\]\[12\] cpuregs\[25\]\[12\] cpuregs\[26\]\[12\] cpuregs\[27\]\[12\]
+ _03935_ _03936_ VGND VGND VPWR VPWR _04249_ sky130_fd_sc_hd__mux4_1
X_14833_ _01789_ VGND VGND VPWR VPWR _01283_ sky130_fd_sc_hd__clkbuf_1
X_14764_ _05047_ net1570 _01719_ VGND VGND VPWR VPWR _01753_ sky130_fd_sc_hd__mux2_1
X_11976_ net413 _05648_ _05651_ VGND VGND VPWR VPWR _00629_ sky130_fd_sc_hd__a21oi_1
X_10927_ _03621_ VGND VGND VPWR VPWR _05041_ sky130_fd_sc_hd__clkbuf_4
X_13715_ _06962_ _07178_ _07185_ VGND VGND VPWR VPWR _07186_ sky130_fd_sc_hd__or3_1
X_14695_ _01716_ VGND VGND VPWR VPWR _01218_ sky130_fd_sc_hd__clkbuf_1
X_16503_ clknet_leaf_53_clk _01085_ VGND VGND VPWR VPWR cpuregs\[19\]\[24\] sky130_fd_sc_hd__dfxtp_1
XFILLER_0_58_326 VGND VGND VPWR VPWR sky130_fd_sc_hd__fill_1
X_13646_ _06868_ _07116_ _07118_ VGND VGND VPWR VPWR _07119_ sky130_fd_sc_hd__a21o_1
X_16434_ clknet_leaf_25_clk _01016_ VGND VGND VPWR VPWR decoded_imm\[13\] sky130_fd_sc_hd__dfxtp_2
XFILLER_0_27_702 VGND VGND VPWR VPWR sky130_fd_sc_hd__decap_4
XPHY_170 VGND VGND VPWR VPWR sky130_fd_sc_hd__decap_3
XFILLER_0_82_830 VGND VGND VPWR VPWR sky130_fd_sc_hd__fill_2
X_10858_ _04994_ VGND VGND VPWR VPWR _00168_ sky130_fd_sc_hd__clkbuf_1
X_13577_ _06751_ _07048_ _07052_ _06798_ VGND VGND VPWR VPWR _07053_ sky130_fd_sc_hd__o211a_1
XPHY_192 VGND VGND VPWR VPWR sky130_fd_sc_hd__decap_3
XPHY_181 VGND VGND VPWR VPWR sky130_fd_sc_hd__decap_3
X_16365_ clknet_leaf_92_clk _00947_ VGND VGND VPWR VPWR cpuregs\[1\]\[30\] sky130_fd_sc_hd__dfxtp_1
Xclkbuf_leaf_105_clk clknet_4_11_0_clk VGND VGND VPWR VPWR clknet_leaf_105_clk sky130_fd_sc_hd__clkbuf_16
X_10789_ _04954_ VGND VGND VPWR VPWR _00139_ sky130_fd_sc_hd__clkbuf_1
XFILLER_0_14_418 VGND VGND VPWR VPWR sky130_fd_sc_hd__fill_2
X_12528_ net411 _06114_ _02185_ VGND VGND VPWR VPWR _06117_ sky130_fd_sc_hd__o21ai_1
XFILLER_0_26_289 VGND VGND VPWR VPWR sky130_fd_sc_hd__decap_8
X_16296_ clknet_leaf_3_clk _00881_ VGND VGND VPWR VPWR instr_rdcycle sky130_fd_sc_hd__dfxtp_1
X_15316_ _02044_ VGND VGND VPWR VPWR _01511_ sky130_fd_sc_hd__clkbuf_1
X_12459_ _05751_ _05753_ _06034_ VGND VGND VPWR VPWR _06062_ sky130_fd_sc_hd__and3_1
XFILLER_0_78_24 VGND VGND VPWR VPWR sky130_fd_sc_hd__fill_1
X_15247_ net462 VGND VGND VPWR VPWR _02009_ sky130_fd_sc_hd__clkbuf_1
XFILLER_0_2_813 VGND VGND VPWR VPWR sky130_fd_sc_hd__fill_2
XFILLER_0_50_793 VGND VGND VPWR VPWR sky130_fd_sc_hd__fill_2
X_15178_ _01972_ VGND VGND VPWR VPWR _01973_ sky130_fd_sc_hd__buf_4
XFILLER_0_120_692 VGND VGND VPWR VPWR sky130_fd_sc_hd__fill_2
X_14129_ _07484_ VGND VGND VPWR VPWR _00928_ sky130_fd_sc_hd__clkbuf_1
X_09670_ cpuregs\[28\]\[3\] cpuregs\[29\]\[3\] _03902_ VGND VGND VPWR VPWR _03903_
+ sky130_fd_sc_hd__mux2_1
XFILLER_0_118_85 VGND VGND VPWR VPWR sky130_fd_sc_hd__decap_4
X_08621_ _02403_ net207 _02942_ _02841_ VGND VGND VPWR VPWR _02989_ sky130_fd_sc_hd__a31o_1
XFILLER_0_27_61 VGND VGND VPWR VPWR sky130_fd_sc_hd__fill_1
X_08552_ _02325_ _02924_ VGND VGND VPWR VPWR _02926_ sky130_fd_sc_hd__nor2_1
X_08483_ _02243_ _02861_ VGND VGND VPWR VPWR _02862_ sky130_fd_sc_hd__and2_1
XFILLER_0_49_337 VGND VGND VPWR VPWR sky130_fd_sc_hd__fill_2
XFILLER_0_49_326 VGND VGND VPWR VPWR sky130_fd_sc_hd__fill_2
XFILLER_0_119_225 VPWR VGND VPWR VGND sky130_ef_sc_hd__decap_12
XFILLER_0_119_214 VGND VGND VPWR VPWR sky130_fd_sc_hd__decap_8
XFILLER_0_119_203 VGND VGND VPWR VPWR sky130_fd_sc_hd__decap_4
XFILLER_0_92_616 VGND VGND VPWR VPWR sky130_fd_sc_hd__decap_4
XFILLER_0_119_269 VGND VGND VPWR VPWR sky130_fd_sc_hd__fill_2
XFILLER_0_107_409 VGND VGND VPWR VPWR sky130_fd_sc_hd__decap_4
XFILLER_0_73_830 VGND VGND VPWR VPWR sky130_fd_sc_hd__fill_2
XFILLER_0_57_370 VGND VGND VPWR VPWR sky130_fd_sc_hd__fill_2
XFILLER_0_17_212 VGND VGND VPWR VPWR sky130_fd_sc_hd__decap_8
XFILLER_0_134_217 VGND VGND VPWR VPWR sky130_fd_sc_hd__fill_2
XFILLER_0_128_781 VGND VGND VPWR VPWR sky130_fd_sc_hd__decap_4
XFILLER_0_115_442 VGND VGND VPWR VPWR sky130_fd_sc_hd__decap_6
XFILLER_0_72_351 VGND VGND VPWR VPWR sky130_fd_sc_hd__decap_4
XFILLER_0_17_289 VGND VGND VPWR VPWR sky130_fd_sc_hd__fill_1
X_09104_ cpuregs\[20\]\[3\] cpuregs\[21\]\[3\] cpuregs\[22\]\[3\] cpuregs\[23\]\[3\]
+ _03313_ _03314_ VGND VGND VPWR VPWR _03384_ sky130_fd_sc_hd__mux4_1
XFILLER_0_32_204 VPWR VGND VPWR VGND sky130_ef_sc_hd__decap_12
XFILLER_0_33_727 VGND VGND VPWR VPWR sky130_fd_sc_hd__fill_1
XFILLER_0_103_604 VGND VGND VPWR VPWR sky130_fd_sc_hd__fill_1
XFILLER_0_5_673 VGND VGND VPWR VPWR sky130_fd_sc_hd__decap_4
X_09035_ _03311_ _03315_ VGND VGND VPWR VPWR _03316_ sky130_fd_sc_hd__or2_1
Xhold352 net148 VGND VGND VPWR VPWR net710 sky130_fd_sc_hd__dlygate4sd3_1
Xhold341 cpuregs\[5\]\[23\] VGND VGND VPWR VPWR net699 sky130_fd_sc_hd__dlygate4sd3_1
XFILLER_0_130_445 VGND VGND VPWR VPWR sky130_fd_sc_hd__fill_1
Xhold330 cpuregs\[24\]\[2\] VGND VGND VPWR VPWR net688 sky130_fd_sc_hd__dlygate4sd3_1
Xhold374 cpuregs\[11\]\[19\] VGND VGND VPWR VPWR net732 sky130_fd_sc_hd__dlygate4sd3_1
Xhold396 decoded_imm_j\[11\] VGND VGND VPWR VPWR net754 sky130_fd_sc_hd__dlygate4sd3_1
Xhold385 count_instr\[31\] VGND VGND VPWR VPWR net743 sky130_fd_sc_hd__dlygate4sd3_1
Xhold363 cpuregs\[19\]\[7\] VGND VGND VPWR VPWR net721 sky130_fd_sc_hd__dlygate4sd3_1
XFILLER_0_111_692 VGND VGND VPWR VPWR sky130_fd_sc_hd__decap_6
X_09937_ _02082_ _04157_ _04158_ _04162_ VGND VGND VPWR VPWR _04163_ sky130_fd_sc_hd__a31o_1
Xhold1041 cpuregs\[13\]\[6\] VGND VGND VPWR VPWR net1399 sky130_fd_sc_hd__dlygate4sd3_1
XTAP_690 VGND VPWR sky130_fd_sc_hd__tapvpwrvgnd_1
Xhold1030 cpuregs\[31\]\[5\] VGND VGND VPWR VPWR net1388 sky130_fd_sc_hd__dlygate4sd3_1
X_09868_ _03677_ _04091_ _04095_ _03660_ VGND VGND VPWR VPWR _04096_ sky130_fd_sc_hd__o211a_1
X_08819_ _02621_ _03171_ VGND VGND VPWR VPWR _03172_ sky130_fd_sc_hd__nand2_1
XFILLER_0_99_248 VGND VGND VPWR VPWR sky130_fd_sc_hd__fill_1
Xhold1085 cpuregs\[29\]\[18\] VGND VGND VPWR VPWR net1443 sky130_fd_sc_hd__dlygate4sd3_1
Xhold1063 cpuregs\[9\]\[31\] VGND VGND VPWR VPWR net1421 sky130_fd_sc_hd__dlygate4sd3_1
Xhold1052 cpuregs\[11\]\[13\] VGND VGND VPWR VPWR net1410 sky130_fd_sc_hd__dlygate4sd3_1
X_09799_ cpuregs\[16\]\[6\] cpuregs\[17\]\[6\] cpuregs\[18\]\[6\] cpuregs\[19\]\[6\]
+ _03941_ _04028_ VGND VGND VPWR VPWR _04029_ sky130_fd_sc_hd__mux4_1
Xhold1074 cpuregs\[12\]\[5\] VGND VGND VPWR VPWR net1432 sky130_fd_sc_hd__dlygate4sd3_1
Xhold1096 cpuregs\[4\]\[30\] VGND VGND VPWR VPWR net1454 sky130_fd_sc_hd__dlygate4sd3_1
X_11830_ net449 _05542_ _05545_ VGND VGND VPWR VPWR _00589_ sky130_fd_sc_hd__a21oi_1
XTAP_1823 VGND VPWR sky130_fd_sc_hd__tapvpwrvgnd_1
XTAP_1834 VGND VPWR sky130_fd_sc_hd__tapvpwrvgnd_1
XTAP_1812 VGND VPWR sky130_fd_sc_hd__tapvpwrvgnd_1
XTAP_1801 VGND VPWR sky130_fd_sc_hd__tapvpwrvgnd_1
X_11761_ _05501_ VGND VGND VPWR VPWR _00564_ sky130_fd_sc_hd__clkbuf_1
X_13500_ _06962_ _06968_ _06977_ VGND VGND VPWR VPWR _06978_ sky130_fd_sc_hd__or3_2
XTAP_1867 VGND VPWR sky130_fd_sc_hd__tapvpwrvgnd_1
XTAP_1856 VGND VPWR sky130_fd_sc_hd__tapvpwrvgnd_1
XTAP_1845 VGND VPWR sky130_fd_sc_hd__tapvpwrvgnd_1
X_10712_ _04912_ VGND VGND VPWR VPWR _00104_ sky130_fd_sc_hd__clkbuf_1
XTAP_1889 VGND VPWR sky130_fd_sc_hd__tapvpwrvgnd_1
XTAP_1878 VGND VPWR sky130_fd_sc_hd__tapvpwrvgnd_1
X_14480_ net645 _05211_ _01598_ VGND VGND VPWR VPWR _01603_ sky130_fd_sc_hd__mux2_1
X_11692_ net731 _05194_ _05458_ VGND VGND VPWR VPWR _05465_ sky130_fd_sc_hd__mux2_1
XFILLER_0_48_381 VGND VGND VPWR VPWR sky130_fd_sc_hd__decap_3
X_10643_ _04125_ _04845_ _04849_ _03829_ VGND VGND VPWR VPWR _04850_ sky130_fd_sc_hd__o211a_1
X_13431_ _03317_ VGND VGND VPWR VPWR _06911_ sky130_fd_sc_hd__clkbuf_4
XFILLER_0_134_751 VGND VGND VPWR VPWR sky130_fd_sc_hd__fill_2
X_16150_ clknet_leaf_38_clk _07638_ VGND VGND VPWR VPWR reg_out\[28\] sky130_fd_sc_hd__dfxtp_1
X_10574_ _03794_ _04769_ _04782_ _03775_ reg_pc\[27\] VGND VGND VPWR VPWR _04783_
+ sky130_fd_sc_hd__a32o_1
X_13362_ _06773_ _06843_ VGND VGND VPWR VPWR _06844_ sky130_fd_sc_hd__and2_1
XFILLER_0_63_373 VGND VGND VPWR VPWR sky130_fd_sc_hd__decap_3
XFILLER_0_36_598 VGND VGND VPWR VPWR sky130_fd_sc_hd__fill_2
X_15101_ net976 _05219_ _01923_ VGND VGND VPWR VPWR _01932_ sky130_fd_sc_hd__mux2_1
XFILLER_0_106_475 VGND VGND VPWR VPWR sky130_fd_sc_hd__fill_1
X_12313_ _05924_ _05927_ _05769_ VGND VGND VPWR VPWR _05928_ sky130_fd_sc_hd__o21ai_1
XFILLER_0_91_693 VGND VGND VPWR VPWR sky130_fd_sc_hd__decap_4
X_16081_ clknet_leaf_0_clk _00731_ VGND VGND VPWR VPWR count_cycle\[24\] sky130_fd_sc_hd__dfxtp_1
Xrebuffer8 net367 VGND VGND VPWR VPWR net366 sky130_fd_sc_hd__clkbuf_1
X_15032_ _01895_ VGND VGND VPWR VPWR _01376_ sky130_fd_sc_hd__clkbuf_1
X_13293_ _06580_ _06776_ VGND VGND VPWR VPWR _06777_ sky130_fd_sc_hd__or2_1
X_12244_ _05853_ _05864_ _05695_ VGND VGND VPWR VPWR _05865_ sky130_fd_sc_hd__o21ai_1
X_12175_ _05792_ _05797_ _05798_ _05800_ VGND VGND VPWR VPWR _05801_ sky130_fd_sc_hd__a31o_1
X_11126_ net1044 _03591_ _05146_ VGND VGND VPWR VPWR _05149_ sky130_fd_sc_hd__mux2_1
X_11057_ _05112_ VGND VGND VPWR VPWR _00249_ sky130_fd_sc_hd__clkbuf_1
X_15934_ clknet_leaf_148_clk _00584_ VGND VGND VPWR VPWR count_instr\[3\] sky130_fd_sc_hd__dfxtp_1
X_10008_ _02340_ _02445_ _03997_ VGND VGND VPWR VPWR _04232_ sky130_fd_sc_hd__mux2_1
X_15865_ clknet_leaf_97_clk _00515_ VGND VGND VPWR VPWR cpuregs\[25\]\[31\] sky130_fd_sc_hd__dfxtp_1
XFILLER_0_64_37 VGND VGND VPWR VPWR sky130_fd_sc_hd__decap_4
X_14816_ net1263 _05207_ _01778_ VGND VGND VPWR VPWR _01781_ sky130_fd_sc_hd__mux2_1
X_15796_ clknet_leaf_46_clk _00446_ VGND VGND VPWR VPWR cpuregs\[26\]\[26\] sky130_fd_sc_hd__dfxtp_1
XFILLER_0_86_421 VGND VGND VPWR VPWR sky130_fd_sc_hd__decap_3
X_14747_ _01744_ VGND VGND VPWR VPWR _01242_ sky130_fd_sc_hd__clkbuf_1
XFILLER_0_80_47 VGND VGND VPWR VPWR sky130_fd_sc_hd__fill_1
X_11959_ _05639_ VGND VGND VPWR VPWR _00624_ sky130_fd_sc_hd__clkbuf_1
X_14678_ net1182 _05205_ _01706_ VGND VGND VPWR VPWR _01708_ sky130_fd_sc_hd__mux2_1
XFILLER_0_104_54 VGND VGND VPWR VPWR sky130_fd_sc_hd__decap_4
X_13629_ cpuregs\[22\]\[25\] cpuregs\[23\]\[25\] _06386_ VGND VGND VPWR VPWR _07103_
+ sky130_fd_sc_hd__mux2_1
X_16417_ clknet_leaf_25_clk _00999_ VGND VGND VPWR VPWR decoded_imm\[30\] sky130_fd_sc_hd__dfxtp_2
XFILLER_0_89_23 VGND VGND VPWR VPWR sky130_fd_sc_hd__decap_4
XFILLER_0_6_448 VGND VGND VPWR VPWR sky130_fd_sc_hd__fill_1
XFILLER_0_15_727 VGND VGND VPWR VPWR sky130_fd_sc_hd__fill_1
XFILLER_0_27_576 VGND VGND VPWR VPWR sky130_fd_sc_hd__fill_1
XFILLER_0_42_502 VGND VGND VPWR VPWR sky130_fd_sc_hd__fill_2
X_16348_ clknet_leaf_111_clk _00930_ VGND VGND VPWR VPWR cpuregs\[1\]\[13\] sky130_fd_sc_hd__dfxtp_1
XFILLER_0_81_181 VGND VGND VPWR VPWR sky130_fd_sc_hd__decap_6
XFILLER_0_54_384 VGND VGND VPWR VPWR sky130_fd_sc_hd__fill_2
X_16279_ clknet_leaf_149_clk _00864_ VGND VGND VPWR VPWR instr_xori sky130_fd_sc_hd__dfxtp_1
XFILLER_0_22_281 VGND VGND VPWR VPWR sky130_fd_sc_hd__fill_1
X_07983_ _02359_ _02362_ _02375_ _02383_ _02374_ VGND VGND VPWR VPWR _02384_ sky130_fd_sc_hd__o311a_2
X_09722_ _03911_ _03915_ VGND VGND VPWR VPWR _03953_ sky130_fd_sc_hd__nand2_1
X_09653_ _03744_ _03877_ _03884_ _03885_ VGND VGND VPWR VPWR _03886_ sky130_fd_sc_hd__o211a_1
X_08604_ _02934_ _02685_ _02972_ VGND VGND VPWR VPWR _02973_ sky130_fd_sc_hd__and3_1
X_09584_ _03661_ VGND VGND VPWR VPWR _03818_ sky130_fd_sc_hd__buf_4
XFILLER_0_89_281 VGND VGND VPWR VPWR sky130_fd_sc_hd__fill_2
XFILLER_0_77_410 VGND VGND VPWR VPWR sky130_fd_sc_hd__fill_2
X_08535_ _02310_ _02909_ VGND VGND VPWR VPWR _02910_ sky130_fd_sc_hd__nand2_1
XTAP_1119 VGND VPWR sky130_fd_sc_hd__tapvpwrvgnd_1
XTAP_1108 VGND VPWR sky130_fd_sc_hd__tapvpwrvgnd_1
XFILLER_0_108_707 VGND VGND VPWR VPWR sky130_fd_sc_hd__fill_1
X_08466_ is_compare _02838_ _02840_ _02845_ VGND VGND VPWR VPWR _02847_ sky130_fd_sc_hd__nor4_4
XFILLER_0_49_167 VGND VGND VPWR VPWR sky130_fd_sc_hd__fill_1
XFILLER_0_9_242 VGND VGND VPWR VPWR sky130_fd_sc_hd__fill_2
X_08397_ _02548_ _02762_ _02710_ _02770_ _02777_ VGND VGND VPWR VPWR _02778_ sky130_fd_sc_hd__o221ai_2
XFILLER_0_64_137 VGND VGND VPWR VPWR sky130_fd_sc_hd__decap_3
XFILLER_0_46_830 VGND VGND VPWR VPWR sky130_fd_sc_hd__fill_2
XFILLER_0_33_502 VGND VGND VPWR VPWR sky130_fd_sc_hd__fill_2
XFILLER_0_115_250 VGND VGND VPWR VPWR sky130_fd_sc_hd__decap_8
XFILLER_0_60_332 VGND VGND VPWR VPWR sky130_fd_sc_hd__fill_2
XFILLER_0_60_354 VGND VGND VPWR VPWR sky130_fd_sc_hd__decap_8
XFILLER_0_14_760 VGND VGND VPWR VPWR sky130_fd_sc_hd__fill_1
XFILLER_0_131_776 VGND VGND VPWR VPWR sky130_fd_sc_hd__decap_8
XFILLER_0_130_242 VGND VGND VPWR VPWR sky130_fd_sc_hd__fill_2
X_10290_ _02160_ _04479_ _04506_ _03717_ VGND VGND VPWR VPWR _04507_ sky130_fd_sc_hd__a22oi_1
X_09018_ decoded_imm_j\[18\] _01111_ _03296_ VGND VGND VPWR VPWR _03303_ sky130_fd_sc_hd__mux2_2
XFILLER_0_60_376 VGND VGND VPWR VPWR sky130_fd_sc_hd__fill_2
XFILLER_0_13_270 VGND VGND VPWR VPWR sky130_fd_sc_hd__decap_8
XFILLER_0_130_264 VGND VGND VPWR VPWR sky130_fd_sc_hd__fill_2
Xhold171 reg_next_pc\[10\] VGND VGND VPWR VPWR net529 sky130_fd_sc_hd__dlygate4sd3_1
Xhold160 cpuregs\[0\]\[8\] VGND VGND VPWR VPWR net518 sky130_fd_sc_hd__dlygate4sd3_1
XFILLER_0_130_297 VGND VGND VPWR VPWR sky130_fd_sc_hd__decap_3
Xhold182 net55 VGND VGND VPWR VPWR net540 sky130_fd_sc_hd__dlygate4sd3_1
Xhold193 net137 VGND VGND VPWR VPWR net551 sky130_fd_sc_hd__dlygate4sd3_1
X_13980_ _07377_ _07399_ VGND VGND VPWR VPWR _07400_ sky130_fd_sc_hd__and2_1
X_12931_ cpuregs\[10\]\[5\] cpuregs\[11\]\[5\] _06424_ VGND VGND VPWR VPWR _06425_
+ sky130_fd_sc_hd__mux2_1
XTAP_2310 VGND VPWR sky130_fd_sc_hd__tapvpwrvgnd_1
X_12862_ _06342_ _06347_ _06354_ _06360_ VGND VGND VPWR VPWR _06361_ sky130_fd_sc_hd__a31o_1
X_15650_ clknet_leaf_113_clk _00300_ VGND VGND VPWR VPWR cpuregs\[14\]\[8\] sky130_fd_sc_hd__dfxtp_1
XTAP_2343 VGND VPWR sky130_fd_sc_hd__tapvpwrvgnd_1
XTAP_2332 VGND VPWR sky130_fd_sc_hd__tapvpwrvgnd_1
XTAP_2321 VGND VPWR sky130_fd_sc_hd__tapvpwrvgnd_1
X_14601_ _05020_ net1502 _01659_ VGND VGND VPWR VPWR _01667_ sky130_fd_sc_hd__mux2_1
XFILLER_0_68_421 VGND VGND VPWR VPWR sky130_fd_sc_hd__fill_2
X_11813_ _02140_ VGND VGND VPWR VPWR _05533_ sky130_fd_sc_hd__buf_4
XTAP_2354 VGND VPWR sky130_fd_sc_hd__tapvpwrvgnd_1
XTAP_1642 VGND VPWR sky130_fd_sc_hd__tapvpwrvgnd_1
XTAP_1631 VGND VPWR sky130_fd_sc_hd__tapvpwrvgnd_1
X_12793_ net42 net73 _06302_ VGND VGND VPWR VPWR _06311_ sky130_fd_sc_hd__mux2_1
XTAP_1620 VGND VPWR sky130_fd_sc_hd__tapvpwrvgnd_1
XFILLER_0_68_454 VGND VGND VPWR VPWR sky130_fd_sc_hd__fill_1
X_15581_ clknet_leaf_123_clk _00231_ VGND VGND VPWR VPWR cpuregs\[28\]\[3\] sky130_fd_sc_hd__dfxtp_1
XFILLER_0_95_273 VGND VGND VPWR VPWR sky130_fd_sc_hd__fill_1
XTAP_1675 VGND VPWR sky130_fd_sc_hd__tapvpwrvgnd_1
XTAP_1664 VGND VPWR sky130_fd_sc_hd__tapvpwrvgnd_1
XTAP_1653 VGND VPWR sky130_fd_sc_hd__tapvpwrvgnd_1
X_14532_ _01630_ VGND VGND VPWR VPWR _01141_ sky130_fd_sc_hd__clkbuf_1
X_11744_ _05492_ VGND VGND VPWR VPWR _00556_ sky130_fd_sc_hd__clkbuf_1
XFILLER_0_28_307 VGND VGND VPWR VPWR sky130_fd_sc_hd__fill_1
XTAP_1697 VGND VPWR sky130_fd_sc_hd__tapvpwrvgnd_1
XTAP_1686 VGND VPWR sky130_fd_sc_hd__tapvpwrvgnd_1
X_14463_ net613 _05194_ _01587_ VGND VGND VPWR VPWR _01594_ sky130_fd_sc_hd__mux2_1
XFILLER_0_55_126 VGND VGND VPWR VPWR sky130_fd_sc_hd__fill_1
X_11675_ net1029 _05177_ _05447_ VGND VGND VPWR VPWR _05456_ sky130_fd_sc_hd__mux2_1
X_10626_ _04831_ _04832_ VGND VGND VPWR VPWR _04833_ sky130_fd_sc_hd__nor2_1
X_16202_ clknet_leaf_52_clk _00819_ VGND VGND VPWR VPWR net207 sky130_fd_sc_hd__dfxtp_4
X_13414_ _06792_ _06891_ _06893_ _06894_ VGND VGND VPWR VPWR _06895_ sky130_fd_sc_hd__a211o_1
X_14394_ _01557_ VGND VGND VPWR VPWR _01044_ sky130_fd_sc_hd__clkbuf_1
X_16133_ clknet_leaf_24_clk _07620_ VGND VGND VPWR VPWR reg_out\[11\] sky130_fd_sc_hd__dfxtp_1
XFILLER_0_70_129 VGND VGND VPWR VPWR sky130_fd_sc_hd__fill_1
XFILLER_0_51_332 VGND VGND VPWR VPWR sky130_fd_sc_hd__fill_1
XFILLER_0_51_310 VGND VGND VPWR VPWR sky130_fd_sc_hd__fill_1
XFILLER_0_36_384 VGND VGND VPWR VPWR sky130_fd_sc_hd__fill_1
Xpicorv32_307 VGND VGND VPWR VPWR picorv32_307/HI pcpi_insn[18] sky130_fd_sc_hd__conb_1
Xpicorv32_318 VGND VGND VPWR VPWR picorv32_318/HI pcpi_insn[29] sky130_fd_sc_hd__conb_1
X_10557_ _03823_ _04765_ _03730_ VGND VGND VPWR VPWR _04766_ sky130_fd_sc_hd__a21o_1
XFILLER_0_122_721 VGND VGND VPWR VPWR sky130_fd_sc_hd__fill_1
X_13345_ _06794_ _06827_ VGND VGND VPWR VPWR _06828_ sky130_fd_sc_hd__and2_1
Xpicorv32_329 VGND VGND VPWR VPWR picorv32_329/HI trace_data[7] sky130_fd_sc_hd__conb_1
X_10488_ cpuregs\[0\]\[25\] cpuregs\[1\]\[25\] _03880_ VGND VGND VPWR VPWR _04699_
+ sky130_fd_sc_hd__mux2_1
X_13276_ _06760_ _02688_ _06629_ VGND VGND VPWR VPWR _06761_ sky130_fd_sc_hd__mux2_1
X_16064_ clknet_leaf_148_clk _00714_ VGND VGND VPWR VPWR count_cycle\[7\] sky130_fd_sc_hd__dfxtp_1
XFILLER_0_121_253 VPWR VGND VPWR VGND sky130_ef_sc_hd__decap_12
X_15015_ _01886_ VGND VGND VPWR VPWR _01368_ sky130_fd_sc_hd__clkbuf_1
X_12227_ _05811_ _05848_ VGND VGND VPWR VPWR _05849_ sky130_fd_sc_hd__nor2_1
X_12158_ cpu_state\[1\] decoder_trigger VGND VGND VPWR VPWR _05785_ sky130_fd_sc_hd__nand2_2
X_16966_ clknet_leaf_78_clk _01530_ VGND VGND VPWR VPWR cpuregs\[10\]\[21\] sky130_fd_sc_hd__dfxtp_1
X_12089_ _05690_ reg_pc\[18\] VGND VGND VPWR VPWR _05732_ sky130_fd_sc_hd__or2_1
X_11109_ net689 _03538_ _05135_ VGND VGND VPWR VPWR _05140_ sky130_fd_sc_hd__mux2_1
X_15917_ clknet_leaf_56_clk _00567_ VGND VGND VPWR VPWR cpuregs\[17\]\[19\] sky130_fd_sc_hd__dfxtp_1
X_16897_ clknet_leaf_86_clk _01461_ VGND VGND VPWR VPWR cpuregs\[8\]\[16\] sky130_fd_sc_hd__dfxtp_1
XFILLER_0_91_57 VPWR VGND VPWR VGND sky130_ef_sc_hd__decap_12
X_15848_ clknet_leaf_18_clk _00498_ VGND VGND VPWR VPWR cpuregs\[25\]\[14\] sky130_fd_sc_hd__dfxtp_1
X_15779_ clknet_leaf_138_clk _00429_ VGND VGND VPWR VPWR cpuregs\[26\]\[9\] sky130_fd_sc_hd__dfxtp_1
X_08320_ net183 net215 VGND VGND VPWR VPWR _02701_ sky130_fd_sc_hd__or2_1
X_08251_ _02630_ _02631_ _02634_ _02268_ VGND VGND VPWR VPWR _02635_ sky130_fd_sc_hd__o211ai_1
XFILLER_0_74_457 VGND VGND VPWR VPWR sky130_fd_sc_hd__decap_3
XFILLER_0_131_41 VPWR VGND VPWR VGND sky130_ef_sc_hd__decap_12
X_08182_ _02204_ count_cycle\[57\] VGND VGND VPWR VPWR _02570_ sky130_fd_sc_hd__and2_1
XFILLER_0_7_779 VGND VGND VPWR VPWR sky130_fd_sc_hd__decap_4
XFILLER_0_40_72 VGND VGND VPWR VPWR sky130_fd_sc_hd__decap_4
XFILLER_0_132_529 VGND VGND VPWR VPWR sky130_fd_sc_hd__decap_3
Xoutput210 net210 VGND VGND VPWR VPWR pcpi_rs2[16] sky130_fd_sc_hd__clkbuf_4
Xoutput221 net221 VGND VGND VPWR VPWR pcpi_rs2[26] sky130_fd_sc_hd__clkbuf_4
Xoutput232 net232 VGND VGND VPWR VPWR pcpi_rs2[7] sky130_fd_sc_hd__clkbuf_4
XFILLER_0_30_549 VGND VGND VPWR VPWR sky130_fd_sc_hd__decap_4
XFILLER_0_140_595 VGND VGND VPWR VPWR sky130_fd_sc_hd__fill_2
XFILLER_0_10_262 VGND VGND VPWR VPWR sky130_fd_sc_hd__decap_4
XFILLER_0_11_785 VPWR VGND VPWR VGND sky130_ef_sc_hd__decap_12
X_07966_ _02207_ _02366_ _02284_ _02368_ VGND VGND VPWR VPWR _02369_ sky130_fd_sc_hd__a22o_1
XFILLER_0_4_83 VGND VGND VPWR VPWR sky130_fd_sc_hd__fill_1
X_09705_ cpuregs\[4\]\[4\] cpuregs\[5\]\[4\] cpuregs\[6\]\[4\] cpuregs\[7\]\[4\] _03935_
+ _03936_ VGND VGND VPWR VPWR _03937_ sky130_fd_sc_hd__mux4_1
Xclkbuf_leaf_94_clk clknet_4_12_0_clk VGND VGND VPWR VPWR clknet_leaf_94_clk sky130_fd_sc_hd__clkbuf_16
X_07897_ _02291_ _02303_ _02290_ VGND VGND VPWR VPWR _02304_ sky130_fd_sc_hd__a21oi_1
X_09636_ cpuregs\[12\]\[3\] cpuregs\[13\]\[3\] _03755_ VGND VGND VPWR VPWR _03869_
+ sky130_fd_sc_hd__mux2_1
X_09567_ _03749_ VGND VGND VPWR VPWR _03801_ sky130_fd_sc_hd__buf_6
X_08518_ _02867_ _02891_ _02892_ _02894_ _02667_ VGND VGND VPWR VPWR alu_out\[4\]
+ sky130_fd_sc_hd__a32o_1
X_09498_ _03724_ _03725_ _03729_ _03732_ VGND VGND VPWR VPWR _03733_ sky130_fd_sc_hd__o211a_1
XFILLER_0_136_813 VGND VGND VPWR VPWR sky130_fd_sc_hd__fill_2
XFILLER_0_93_766 VGND VGND VPWR VPWR sky130_fd_sc_hd__fill_2
X_08449_ _02825_ _02761_ VGND VGND VPWR VPWR _02830_ sky130_fd_sc_hd__nor2_2
XFILLER_0_19_830 VGND VGND VPWR VPWR sky130_fd_sc_hd__fill_2
XFILLER_0_52_129 VGND VGND VPWR VPWR sky130_fd_sc_hd__fill_1
X_11460_ net700 _05167_ _05338_ VGND VGND VPWR VPWR _05342_ sky130_fd_sc_hd__mux2_1
X_10411_ cpuregs\[2\]\[23\] cpuregs\[3\]\[23\] _03768_ VGND VGND VPWR VPWR _04624_
+ sky130_fd_sc_hd__mux2_1
X_11391_ _05305_ VGND VGND VPWR VPWR _00390_ sky130_fd_sc_hd__clkbuf_1
X_10342_ _03823_ _04556_ _03730_ VGND VGND VPWR VPWR _04557_ sky130_fd_sc_hd__a21o_1
XFILLER_0_60_151 VGND VGND VPWR VPWR sky130_fd_sc_hd__decap_3
X_13130_ _03341_ _06618_ VGND VGND VPWR VPWR _06619_ sky130_fd_sc_hd__and2_1
X_13061_ cpuregs\[16\]\[8\] cpuregs\[17\]\[8\] cpuregs\[18\]\[8\] cpuregs\[19\]\[8\]
+ _06443_ _06444_ VGND VGND VPWR VPWR _06552_ sky130_fd_sc_hd__mux4_1
XFILLER_0_131_595 VGND VGND VPWR VPWR sky130_fd_sc_hd__fill_1
X_10273_ _03696_ _04487_ _04489_ VGND VGND VPWR VPWR _04490_ sky130_fd_sc_hd__a21o_1
X_12012_ count_instr\[59\] count_instr\[58\] count_instr\[57\] _05671_ VGND VGND VPWR
+ VPWR _05677_ sky130_fd_sc_hd__and4_1
X_16820_ clknet_leaf_122_clk _01384_ VGND VGND VPWR VPWR cpuregs\[7\]\[3\] sky130_fd_sc_hd__dfxtp_1
X_16751_ clknet_leaf_91_clk _01315_ VGND VGND VPWR VPWR cpuregs\[4\]\[30\] sky130_fd_sc_hd__dfxtp_1
X_15702_ clknet_leaf_65_clk _00352_ VGND VGND VPWR VPWR cpuregs\[27\]\[28\] sky130_fd_sc_hd__dfxtp_1
Xclkbuf_leaf_85_clk clknet_4_14_0_clk VGND VGND VPWR VPWR clknet_leaf_85_clk sky130_fd_sc_hd__clkbuf_16
X_13963_ _07324_ VGND VGND VPWR VPWR _07388_ sky130_fd_sc_hd__clkbuf_4
X_16682_ clknet_leaf_67_clk _01249_ VGND VGND VPWR VPWR cpuregs\[29\]\[28\] sky130_fd_sc_hd__dfxtp_1
X_13894_ _07326_ _07342_ VGND VGND VPWR VPWR _07343_ sky130_fd_sc_hd__and2_1
X_12914_ decoded_imm\[3\] _03391_ _02171_ VGND VGND VPWR VPWR _06410_ sky130_fd_sc_hd__mux2_1
XTAP_2162 VGND VPWR sky130_fd_sc_hd__tapvpwrvgnd_1
XTAP_2151 VGND VPWR sky130_fd_sc_hd__tapvpwrvgnd_1
XTAP_2140 VGND VPWR sky130_fd_sc_hd__tapvpwrvgnd_1
X_15633_ clknet_leaf_69_clk _00283_ VGND VGND VPWR VPWR cpuregs\[31\]\[23\] sky130_fd_sc_hd__dfxtp_1
XFILLER_0_68_240 VGND VGND VPWR VPWR sky130_fd_sc_hd__fill_1
X_12845_ _03322_ VGND VGND VPWR VPWR _06344_ sky130_fd_sc_hd__buf_6
X_12776_ _06293_ VGND VGND VPWR VPWR _06302_ sky130_fd_sc_hd__buf_12
XTAP_2195 VGND VPWR sky130_fd_sc_hd__tapvpwrvgnd_1
XTAP_2184 VGND VPWR sky130_fd_sc_hd__tapvpwrvgnd_1
XTAP_2173 VGND VPWR sky130_fd_sc_hd__tapvpwrvgnd_1
X_15564_ clknet_leaf_84_clk _00214_ VGND VGND VPWR VPWR cpuregs\[2\]\[18\] sky130_fd_sc_hd__dfxtp_1
XTAP_1450 VGND VPWR sky130_fd_sc_hd__tapvpwrvgnd_1
XFILLER_0_68_251 VGND VGND VPWR VPWR sky130_fd_sc_hd__fill_1
XFILLER_0_138_150 VPWR VGND VPWR VGND sky130_ef_sc_hd__decap_12
XTAP_1483 VGND VPWR sky130_fd_sc_hd__tapvpwrvgnd_1
XTAP_1472 VGND VPWR sky130_fd_sc_hd__tapvpwrvgnd_1
XTAP_1461 VGND VPWR sky130_fd_sc_hd__tapvpwrvgnd_1
X_11727_ _04981_ net1246 _05483_ VGND VGND VPWR VPWR _05484_ sky130_fd_sc_hd__mux2_1
X_14515_ _01621_ VGND VGND VPWR VPWR _01133_ sky130_fd_sc_hd__clkbuf_1
XTAP_1494 VGND VPWR sky130_fd_sc_hd__tapvpwrvgnd_1
X_15495_ clknet_leaf_99_clk _00145_ VGND VGND VPWR VPWR cpuregs\[30\]\[13\] sky130_fd_sc_hd__dfxtp_1
XFILLER_0_37_671 VGND VGND VPWR VPWR sky130_fd_sc_hd__fill_1
XFILLER_0_83_287 VGND VGND VPWR VPWR sky130_fd_sc_hd__decap_3
XFILLER_0_71_438 VGND VGND VPWR VPWR sky130_fd_sc_hd__fill_1
X_11658_ _05446_ VGND VGND VPWR VPWR _05447_ sky130_fd_sc_hd__buf_4
XFILLER_0_9_39 VGND VGND VPWR VPWR sky130_fd_sc_hd__decap_4
X_14446_ net698 _05177_ _01576_ VGND VGND VPWR VPWR _01585_ sky130_fd_sc_hd__mux2_1
X_10609_ _03834_ _04814_ _04816_ VGND VGND VPWR VPWR _04817_ sky130_fd_sc_hd__a21o_1
XFILLER_0_4_749 VGND VGND VPWR VPWR sky130_fd_sc_hd__decap_6
X_14377_ _01548_ VGND VGND VPWR VPWR _01036_ sky130_fd_sc_hd__clkbuf_1
X_11589_ _04983_ _05227_ VGND VGND VPWR VPWR _05410_ sky130_fd_sc_hd__or2_4
XFILLER_0_101_55 VGND VGND VPWR VPWR sky130_fd_sc_hd__fill_1
X_13328_ cpuregs\[4\]\[16\] cpuregs\[5\]\[16\] _06575_ VGND VGND VPWR VPWR _06811_
+ sky130_fd_sc_hd__mux2_1
Xhold907 cpuregs\[3\]\[11\] VGND VGND VPWR VPWR net1265 sky130_fd_sc_hd__dlygate4sd3_1
XFILLER_0_10_64 VGND VGND VPWR VPWR sky130_fd_sc_hd__decap_3
X_16116_ clknet_leaf_0_clk _00766_ VGND VGND VPWR VPWR count_cycle\[59\] sky130_fd_sc_hd__dfxtp_1
XFILLER_0_24_365 VGND VGND VPWR VPWR sky130_fd_sc_hd__decap_3
Xhold918 cpuregs\[31\]\[8\] VGND VGND VPWR VPWR net1276 sky130_fd_sc_hd__dlygate4sd3_1
Xhold929 cpuregs\[16\]\[23\] VGND VGND VPWR VPWR net1287 sky130_fd_sc_hd__dlygate4sd3_1
XFILLER_0_122_584 VGND VGND VPWR VPWR sky130_fd_sc_hd__decap_4
X_16047_ clknet_leaf_32_clk _00697_ VGND VGND VPWR VPWR reg_next_pc\[22\] sky130_fd_sc_hd__dfxtp_1
X_13259_ _06631_ _06734_ _06743_ VGND VGND VPWR VPWR _06744_ sky130_fd_sc_hd__or3_2
XFILLER_0_50_9 VGND VGND VPWR VPWR sky130_fd_sc_hd__fill_1
X_07820_ _02202_ VGND VGND VPWR VPWR _02232_ sky130_fd_sc_hd__buf_4
X_07751_ _02169_ VGND VGND VPWR VPWR _02170_ sky130_fd_sc_hd__buf_4
XFILLER_0_19_84 VGND VGND VPWR VPWR sky130_fd_sc_hd__decap_4
Xclkbuf_leaf_76_clk clknet_4_15_0_clk VGND VGND VPWR VPWR clknet_leaf_76_clk sky130_fd_sc_hd__clkbuf_16
XFILLER_0_79_505 VGND VGND VPWR VPWR sky130_fd_sc_hd__fill_2
X_16949_ clknet_leaf_122_clk _01513_ VGND VGND VPWR VPWR cpuregs\[10\]\[4\] sky130_fd_sc_hd__dfxtp_1
XFILLER_0_29_6 VGND VGND VPWR VPWR sky130_fd_sc_hd__decap_8
XFILLER_0_126_41 VGND VGND VPWR VPWR sky130_fd_sc_hd__decap_3
X_07682_ _02110_ VGND VGND VPWR VPWR _02111_ sky130_fd_sc_hd__buf_4
XFILLER_0_126_85 VGND VGND VPWR VPWR sky130_fd_sc_hd__fill_1
X_09421_ _03656_ VGND VGND VPWR VPWR _03657_ sky130_fd_sc_hd__clkbuf_4
X_09352_ _03596_ VGND VGND VPWR VPWR _03597_ sky130_fd_sc_hd__clkbuf_4
X_08303_ _02672_ _02673_ _02683_ VGND VGND VPWR VPWR _02684_ sky130_fd_sc_hd__a21bo_1
X_09283_ _03534_ _03535_ _03449_ _03536_ VGND VGND VPWR VPWR _03537_ sky130_fd_sc_hd__a2bb2o_2
XFILLER_0_62_416 VGND VGND VPWR VPWR sky130_fd_sc_hd__decap_4
XFILLER_0_16_811 VGND VGND VPWR VPWR sky130_fd_sc_hd__fill_1
X_08234_ _02614_ _02617_ VGND VGND VPWR VPWR _02619_ sky130_fd_sc_hd__or2_1
X_08165_ count_instr\[56\] _02233_ count_cycle\[56\] _02456_ VGND VGND VPWR VPWR _02554_
+ sky130_fd_sc_hd__a22o_1
X_08096_ _02475_ _02486_ _02489_ VGND VGND VPWR VPWR _02490_ sky130_fd_sc_hd__a21o_1
XFILLER_0_3_771 VPWR VGND VPWR VGND sky130_ef_sc_hd__decap_12
X_08998_ _03290_ VGND VGND VPWR VPWR net88 sky130_fd_sc_hd__clkbuf_4
Xclkbuf_leaf_67_clk clknet_4_13_0_clk VGND VGND VPWR VPWR clknet_leaf_67_clk sky130_fd_sc_hd__clkbuf_16
XFILLER_0_97_302 VPWR VGND VPWR VGND sky130_ef_sc_hd__decap_12
X_07949_ _02224_ _02133_ net18 net32 _02210_ VGND VGND VPWR VPWR _02353_ sky130_fd_sc_hd__a32o_1
X_10960_ _05001_ net984 _05052_ VGND VGND VPWR VPWR _05061_ sky130_fd_sc_hd__mux2_1
X_10891_ _05016_ net1390 _05006_ VGND VGND VPWR VPWR _05017_ sky130_fd_sc_hd__mux2_1
X_09619_ _03852_ VGND VGND VPWR VPWR _00071_ sky130_fd_sc_hd__clkbuf_1
X_12630_ _02141_ _06188_ _06189_ VGND VGND VPWR VPWR _06190_ sky130_fd_sc_hd__and3_1
XFILLER_0_38_446 VGND VGND VPWR VPWR sky130_fd_sc_hd__decap_3
XFILLER_0_136_643 VGND VGND VPWR VPWR sky130_fd_sc_hd__fill_1
X_12561_ _06139_ _06128_ _06140_ VGND VGND VPWR VPWR _06141_ sky130_fd_sc_hd__and3b_1
X_11512_ net744 _05219_ _05360_ VGND VGND VPWR VPWR _05369_ sky130_fd_sc_hd__mux2_1
X_12492_ _02153_ _06084_ _06085_ _06091_ VGND VGND VPWR VPWR _06092_ sky130_fd_sc_hd__a31o_1
X_15280_ _02025_ VGND VGND VPWR VPWR _01494_ sky130_fd_sc_hd__clkbuf_1
X_14300_ _07569_ _07573_ _07580_ _07575_ net879 VGND VGND VPWR VPWR _01003_ sky130_fd_sc_hd__o32a_1
XFILLER_0_53_449 VGND VGND VPWR VPWR sky130_fd_sc_hd__decap_6
XFILLER_0_19_671 VGND VGND VPWR VPWR sky130_fd_sc_hd__fill_1
X_11443_ _05332_ VGND VGND VPWR VPWR _00415_ sky130_fd_sc_hd__clkbuf_1
X_14231_ _07540_ VGND VGND VPWR VPWR _00974_ sky130_fd_sc_hd__clkbuf_1
XFILLER_0_18_181 VPWR VGND VPWR VGND sky130_ef_sc_hd__decap_12
X_14162_ _07501_ VGND VGND VPWR VPWR _00944_ sky130_fd_sc_hd__clkbuf_1
XFILLER_0_22_825 VGND VGND VPWR VPWR sky130_fd_sc_hd__fill_1
X_11374_ _05041_ net1508 _05288_ VGND VGND VPWR VPWR _05296_ sky130_fd_sc_hd__mux2_1
X_13113_ cpuregs\[10\]\[10\] cpuregs\[11\]\[10\] _06424_ VGND VGND VPWR VPWR _06602_
+ sky130_fd_sc_hd__mux2_1
XFILLER_0_131_370 VGND VGND VPWR VPWR sky130_fd_sc_hd__fill_1
X_10325_ _04540_ VGND VGND VPWR VPWR _00089_ sky130_fd_sc_hd__clkbuf_1
X_14093_ _07333_ _07464_ VGND VGND VPWR VPWR _07465_ sky130_fd_sc_hd__nor2_1
X_10256_ decoded_imm\[19\] net181 VGND VGND VPWR VPWR _04473_ sky130_fd_sc_hd__nor2_1
XTAP_508 VGND VPWR sky130_fd_sc_hd__tapvpwrvgnd_1
XTAP_519 VGND VPWR sky130_fd_sc_hd__tapvpwrvgnd_1
X_13044_ _06343_ VGND VGND VPWR VPWR _06535_ sky130_fd_sc_hd__buf_4
XFILLER_0_56_27 VGND VGND VPWR VPWR sky130_fd_sc_hd__fill_1
X_10187_ _04404_ _04405_ _02081_ VGND VGND VPWR VPWR _04406_ sky130_fd_sc_hd__o21ai_1
X_16803_ clknet_leaf_85_clk _01367_ VGND VGND VPWR VPWR cpuregs\[6\]\[18\] sky130_fd_sc_hd__dfxtp_1
Xclkbuf_leaf_58_clk clknet_4_12_0_clk VGND VGND VPWR VPWR clknet_leaf_58_clk sky130_fd_sc_hd__clkbuf_16
X_14995_ _01864_ VGND VGND VPWR VPWR _01876_ sky130_fd_sc_hd__buf_4
X_16734_ clknet_leaf_111_clk _01298_ VGND VGND VPWR VPWR cpuregs\[4\]\[13\] sky130_fd_sc_hd__dfxtp_1
Xclkbuf_4_11_0_clk clknet_0_clk VGND VGND VPWR VPWR clknet_4_11_0_clk sky130_fd_sc_hd__clkbuf_8
X_13946_ _07376_ VGND VGND VPWR VPWR _00865_ sky130_fd_sc_hd__clkbuf_1
X_16665_ clknet_leaf_100_clk _01232_ VGND VGND VPWR VPWR cpuregs\[29\]\[11\] sky130_fd_sc_hd__dfxtp_1
X_15616_ clknet_leaf_143_clk _00266_ VGND VGND VPWR VPWR cpuregs\[31\]\[6\] sky130_fd_sc_hd__dfxtp_1
X_13877_ _07326_ _07328_ VGND VGND VPWR VPWR _07329_ sky130_fd_sc_hd__and2_1
X_12828_ cpu_state\[2\] cpu_state\[4\] VGND VGND VPWR VPWR _06330_ sky130_fd_sc_hd__or2_1
X_16596_ clknet_leaf_115_clk _01163_ VGND VGND VPWR VPWR cpuregs\[9\]\[6\] sky130_fd_sc_hd__dfxtp_1
X_12759_ _06290_ _06291_ VGND VGND VPWR VPWR _06292_ sky130_fd_sc_hd__and2b_1
XTAP_1291 VGND VPWR sky130_fd_sc_hd__tapvpwrvgnd_1
XTAP_1280 VGND VPWR sky130_fd_sc_hd__tapvpwrvgnd_1
XFILLER_0_8_329 VGND VGND VPWR VPWR sky130_fd_sc_hd__fill_1
X_15547_ clknet_leaf_124_clk _00197_ VGND VGND VPWR VPWR cpuregs\[2\]\[1\] sky130_fd_sc_hd__dfxtp_1
XFILLER_0_127_665 VGND VGND VPWR VPWR sky130_fd_sc_hd__fill_1
X_15478_ clknet_leaf_68_clk _00128_ VGND VGND VPWR VPWR cpuregs\[12\]\[28\] sky130_fd_sc_hd__dfxtp_1
XFILLER_0_44_416 VGND VGND VPWR VPWR sky130_fd_sc_hd__decap_4
XFILLER_0_115_827 VGND VGND VPWR VPWR sky130_fd_sc_hd__fill_2
X_14429_ _01575_ VGND VGND VPWR VPWR _01576_ sky130_fd_sc_hd__buf_4
XFILLER_0_126_197 VGND VGND VPWR VPWR sky130_fd_sc_hd__fill_2
XFILLER_0_130_819 VGND VGND VPWR VPWR sky130_fd_sc_hd__fill_1
Xhold715 cpuregs\[24\]\[30\] VGND VGND VPWR VPWR net1073 sky130_fd_sc_hd__dlygate4sd3_1
Xhold726 cpuregs\[5\]\[1\] VGND VGND VPWR VPWR net1084 sky130_fd_sc_hd__dlygate4sd3_1
Xhold737 cpuregs\[7\]\[3\] VGND VGND VPWR VPWR net1095 sky130_fd_sc_hd__dlygate4sd3_1
Xhold704 cpuregs\[14\]\[7\] VGND VGND VPWR VPWR net1062 sky130_fd_sc_hd__dlygate4sd3_1
XFILLER_0_122_381 VGND VGND VPWR VPWR sky130_fd_sc_hd__fill_2
Xhold759 cpuregs\[31\]\[29\] VGND VGND VPWR VPWR net1117 sky130_fd_sc_hd__dlygate4sd3_1
X_09970_ cpuregs\[14\]\[11\] cpuregs\[15\]\[11\] _04194_ VGND VGND VPWR VPWR _04195_
+ sky130_fd_sc_hd__mux2_1
Xhold748 cpuregs\[26\]\[0\] VGND VGND VPWR VPWR net1106 sky130_fd_sc_hd__dlygate4sd3_1
XFILLER_0_0_741 VGND VGND VPWR VPWR sky130_fd_sc_hd__fill_2
XFILLER_0_12_368 VGND VGND VPWR VPWR sky130_fd_sc_hd__decap_3
X_08921_ _02325_ _03237_ _03227_ VGND VGND VPWR VPWR _03238_ sky130_fd_sc_hd__mux2_1
XFILLER_0_0_763 VGND VGND VPWR VPWR sky130_fd_sc_hd__fill_2
XFILLER_0_40_699 VGND VGND VPWR VPWR sky130_fd_sc_hd__fill_1
X_08852_ _02743_ _03197_ _03201_ _02867_ VGND VGND VPWR VPWR alu_out\[31\] sky130_fd_sc_hd__a22o_1
XFILLER_0_0_785 VGND VGND VPWR VPWR sky130_fd_sc_hd__fill_2
X_07803_ _02215_ mem_wordsize\[2\] _02134_ VGND VGND VPWR VPWR _02216_ sky130_fd_sc_hd__o21a_2
X_08783_ _02578_ _03138_ VGND VGND VPWR VPWR _03139_ sky130_fd_sc_hd__xnor2_1
Xclkbuf_leaf_49_clk clknet_4_7_0_clk VGND VGND VPWR VPWR clknet_leaf_49_clk sky130_fd_sc_hd__clkbuf_16
XFILLER_0_79_324 VGND VGND VPWR VPWR sky130_fd_sc_hd__decap_6
XFILLER_0_27_3 VPWR VGND VPWR VGND sky130_ef_sc_hd__decap_12
X_07734_ reg_sh\[3\] reg_sh\[2\] reg_sh\[4\] VGND VGND VPWR VPWR _02155_ sky130_fd_sc_hd__or3_1
XFILLER_0_79_357 VGND VGND VPWR VPWR sky130_fd_sc_hd__fill_1
X_07665_ _02093_ _02094_ VGND VGND VPWR VPWR _02095_ sky130_fd_sc_hd__or2_1
X_09404_ net1048 _03641_ _03445_ VGND VGND VPWR VPWR _03642_ sky130_fd_sc_hd__mux2_1
XFILLER_0_1_51 VGND VGND VPWR VPWR sky130_fd_sc_hd__fill_1
XFILLER_0_109_109 VGND VGND VPWR VPWR sky130_fd_sc_hd__decap_3
XFILLER_0_94_349 VGND VGND VPWR VPWR sky130_fd_sc_hd__fill_1
X_09335_ reg_pc\[21\] _03573_ _03459_ VGND VGND VPWR VPWR _03582_ sky130_fd_sc_hd__o21a_1
XFILLER_0_118_643 VGND VGND VPWR VPWR sky130_fd_sc_hd__fill_1
X_09266_ reg_pc\[12\] _03515_ VGND VGND VPWR VPWR _03522_ sky130_fd_sc_hd__or2_1
X_08217_ _02586_ _02591_ _02601_ _02170_ VGND VGND VPWR VPWR _02603_ sky130_fd_sc_hd__a31oi_1
XFILLER_0_62_257 VPWR VGND VPWR VGND sky130_ef_sc_hd__decap_12
XFILLER_0_71_780 VGND VGND VPWR VPWR sky130_fd_sc_hd__decap_4
X_09197_ reg_pc\[3\] reg_pc\[2\] VGND VGND VPWR VPWR _03462_ sky130_fd_sc_hd__nand2_1
XFILLER_0_132_167 VGND VGND VPWR VPWR sky130_fd_sc_hd__fill_2
X_08148_ count_instr\[54\] _02233_ _02235_ _02538_ VGND VGND VPWR VPWR _02539_ sky130_fd_sc_hd__a211o_1
XFILLER_0_31_633 VGND VGND VPWR VPWR sky130_fd_sc_hd__decap_3
XFILLER_0_43_493 VGND VGND VPWR VPWR sky130_fd_sc_hd__fill_2
X_08079_ reg_pc\[18\] decoded_imm\[18\] VGND VGND VPWR VPWR _02474_ sky130_fd_sc_hd__or2_1
X_10110_ cpuregs\[8\]\[15\] cpuregs\[9\]\[15\] cpuregs\[10\]\[15\] cpuregs\[11\]\[15\]
+ _03798_ _03811_ VGND VGND VPWR VPWR _04331_ sky130_fd_sc_hd__mux4_1
X_11090_ net1388 _03478_ _05124_ VGND VGND VPWR VPWR _05130_ sky130_fd_sc_hd__mux2_1
X_10041_ cpuregs\[8\]\[13\] cpuregs\[9\]\[13\] cpuregs\[10\]\[13\] cpuregs\[11\]\[13\]
+ _03798_ _03811_ VGND VGND VPWR VPWR _04264_ sky130_fd_sc_hd__mux4_1
Xhold31 instr_auipc VGND VGND VPWR VPWR net389 sky130_fd_sc_hd__dlygate4sd3_1
Xhold42 count_cycle\[48\] VGND VGND VPWR VPWR net400 sky130_fd_sc_hd__dlygate4sd3_1
Xhold53 count_cycle\[9\] VGND VGND VPWR VPWR net411 sky130_fd_sc_hd__buf_1
Xhold64 instr_lh VGND VGND VPWR VPWR net422 sky130_fd_sc_hd__dlygate4sd3_1
X_13800_ cpuregs\[6\]\[31\] cpuregs\[7\]\[31\] _06383_ VGND VGND VPWR VPWR _07268_
+ sky130_fd_sc_hd__mux2_1
X_11992_ _05663_ VGND VGND VPWR VPWR _00633_ sky130_fd_sc_hd__clkbuf_1
Xhold86 count_instr\[12\] VGND VGND VPWR VPWR net444 sky130_fd_sc_hd__dlygate4sd3_1
Xhold75 count_instr\[4\] VGND VGND VPWR VPWR net433 sky130_fd_sc_hd__dlygate4sd3_1
X_14780_ net1455 _05171_ _01756_ VGND VGND VPWR VPWR _01762_ sky130_fd_sc_hd__mux2_1
Xhold97 cpuregs\[0\]\[2\] VGND VGND VPWR VPWR net455 sky130_fd_sc_hd__dlygate4sd3_1
X_13731_ _07201_ VGND VGND VPWR VPWR _00834_ sky130_fd_sc_hd__clkbuf_1
X_10943_ _05051_ VGND VGND VPWR VPWR _05052_ sky130_fd_sc_hd__buf_4
XFILLER_0_97_165 VGND VGND VPWR VPWR sky130_fd_sc_hd__decap_3
X_13662_ cpuregs\[24\]\[26\] cpuregs\[25\]\[26\] cpuregs\[26\]\[26\] cpuregs\[27\]\[26\]
+ _06856_ _06889_ VGND VGND VPWR VPWR _07135_ sky130_fd_sc_hd__mux4_1
X_10874_ _03510_ VGND VGND VPWR VPWR _05005_ sky130_fd_sc_hd__clkbuf_4
X_16450_ clknet_leaf_128_clk _01032_ VGND VGND VPWR VPWR cpuregs\[18\]\[3\] sky130_fd_sc_hd__dfxtp_1
XFILLER_0_42_29 VGND VGND VPWR VPWR sky130_fd_sc_hd__fill_1
X_16381_ clknet_leaf_75_clk _00963_ VGND VGND VPWR VPWR net165 sky130_fd_sc_hd__dfxtp_1
X_13593_ _03318_ _07065_ _07067_ _03332_ VGND VGND VPWR VPWR _07068_ sky130_fd_sc_hd__a31o_1
X_15401_ clknet_leaf_91_clk _00056_ VGND VGND VPWR VPWR cpuregs\[11\]\[19\] sky130_fd_sc_hd__dfxtp_1
X_12613_ _06177_ VGND VGND VPWR VPWR _00740_ sky130_fd_sc_hd__clkbuf_1
XFILLER_0_38_243 VGND VGND VPWR VPWR sky130_fd_sc_hd__decap_8
XFILLER_0_81_511 VGND VGND VPWR VPWR sky130_fd_sc_hd__fill_1
X_15332_ _03511_ net1364 _02052_ VGND VGND VPWR VPWR _02053_ sky130_fd_sc_hd__mux2_1
X_12544_ count_cycle\[13\] _06124_ VGND VGND VPWR VPWR _06129_ sky130_fd_sc_hd__or2_1
X_12475_ _05749_ _05751_ _05753_ _05755_ _06005_ VGND VGND VPWR VPWR _06076_ sky130_fd_sc_hd__o41a_1
X_15263_ net484 VGND VGND VPWR VPWR _02017_ sky130_fd_sc_hd__clkbuf_1
XFILLER_0_34_460 VGND VGND VPWR VPWR sky130_fd_sc_hd__decap_6
XFILLER_0_123_156 VGND VGND VPWR VPWR sky130_fd_sc_hd__fill_1
XANTENNA_6 _02516_ VGND VGND VPWR VPWR sky130_fd_sc_hd__diode_2
X_11426_ _05323_ VGND VGND VPWR VPWR _00407_ sky130_fd_sc_hd__clkbuf_1
XFILLER_0_1_505 VGND VGND VPWR VPWR sky130_fd_sc_hd__fill_1
X_15194_ _01981_ VGND VGND VPWR VPWR _01452_ sky130_fd_sc_hd__clkbuf_1
X_14214_ net551 net99 _07530_ VGND VGND VPWR VPWR _07532_ sky130_fd_sc_hd__mux2_1
X_14145_ _07492_ VGND VGND VPWR VPWR _00936_ sky130_fd_sc_hd__clkbuf_1
X_11357_ _05024_ net1608 _05277_ VGND VGND VPWR VPWR _05287_ sky130_fd_sc_hd__mux2_1
XFILLER_0_6_29 VGND VGND VPWR VPWR sky130_fd_sc_hd__fill_2
XFILLER_0_21_154 VGND VGND VPWR VPWR sky130_fd_sc_hd__fill_2
X_10308_ _03739_ _04519_ _04523_ _03873_ VGND VGND VPWR VPWR _04524_ sky130_fd_sc_hd__o211a_1
X_14076_ _07454_ VGND VGND VPWR VPWR _00905_ sky130_fd_sc_hd__clkbuf_1
XTAP_305 VGND VPWR sky130_fd_sc_hd__tapvpwrvgnd_1
X_11288_ net658 _05200_ _05240_ VGND VGND VPWR VPWR _05250_ sky130_fd_sc_hd__mux2_1
XTAP_349 VGND VPWR sky130_fd_sc_hd__tapvpwrvgnd_1
XTAP_338 VGND VPWR sky130_fd_sc_hd__tapvpwrvgnd_1
XTAP_316 VGND VPWR sky130_fd_sc_hd__tapvpwrvgnd_1
XTAP_327 VGND VPWR sky130_fd_sc_hd__tapvpwrvgnd_1
X_13027_ cpuregs\[16\]\[7\] cpuregs\[17\]\[7\] cpuregs\[18\]\[7\] cpuregs\[19\]\[7\]
+ _06443_ _06444_ VGND VGND VPWR VPWR _06519_ sky130_fd_sc_hd__mux4_1
X_10239_ cpuregs\[4\]\[18\] cpuregs\[5\]\[18\] cpuregs\[6\]\[18\] cpuregs\[7\]\[18\]
+ _03894_ _04090_ VGND VGND VPWR VPWR _04457_ sky130_fd_sc_hd__mux4_1
Xrebuffer18 _05547_ VGND VGND VPWR VPWR net376 sky130_fd_sc_hd__clkbuf_1
X_16717_ clknet_leaf_99_clk _01284_ VGND VGND VPWR VPWR cpuregs\[3\]\[31\] sky130_fd_sc_hd__dfxtp_1
X_14978_ _01867_ VGND VGND VPWR VPWR _01350_ sky130_fd_sc_hd__clkbuf_1
XFILLER_0_16_85 VGND VGND VPWR VPWR sky130_fd_sc_hd__decap_3
X_13929_ _07363_ VGND VGND VPWR VPWR _07364_ sky130_fd_sc_hd__buf_2
X_16648_ clknet_leaf_47_clk _01215_ VGND VGND VPWR VPWR cpuregs\[23\]\[26\] sky130_fd_sc_hd__dfxtp_1
XFILLER_0_76_338 VGND VGND VPWR VPWR sky130_fd_sc_hd__decap_3
XFILLER_0_123_53 VGND VGND VPWR VPWR sky130_fd_sc_hd__decap_3
X_16579_ clknet_leaf_97_clk _01156_ VGND VGND VPWR VPWR cpuregs\[24\]\[31\] sky130_fd_sc_hd__dfxtp_1
XFILLER_0_8_126 VPWR VGND VPWR VGND sky130_ef_sc_hd__decap_12
X_09120_ _03318_ _03398_ VGND VGND VPWR VPWR _03399_ sky130_fd_sc_hd__or2_1
X_09051_ _00010_ VGND VGND VPWR VPWR _03332_ sky130_fd_sc_hd__clkbuf_8
XFILLER_0_115_646 VGND VGND VPWR VPWR sky130_fd_sc_hd__fill_2
X_08002_ _02400_ _02401_ VGND VGND VPWR VPWR _02402_ sky130_fd_sc_hd__xnor2_1
Xhold501 decoded_imm\[18\] VGND VGND VPWR VPWR net859 sky130_fd_sc_hd__dlygate4sd3_1
XFILLER_0_13_644 VGND VGND VPWR VPWR sky130_fd_sc_hd__fill_1
Xhold545 cpuregs\[11\]\[29\] VGND VGND VPWR VPWR net903 sky130_fd_sc_hd__dlygate4sd3_1
Xhold534 cpuregs\[22\]\[18\] VGND VGND VPWR VPWR net892 sky130_fd_sc_hd__dlygate4sd3_1
Xhold523 cpuregs\[7\]\[4\] VGND VGND VPWR VPWR net881 sky130_fd_sc_hd__dlygate4sd3_1
Xmax_cap242 net243 VGND VGND VPWR VPWR net242 sky130_fd_sc_hd__buf_1
Xhold512 cpuregs\[27\]\[9\] VGND VGND VPWR VPWR net870 sky130_fd_sc_hd__dlygate4sd3_1
Xhold567 cpuregs\[15\]\[18\] VGND VGND VPWR VPWR net925 sky130_fd_sc_hd__dlygate4sd3_1
Xhold556 cpuregs\[24\]\[12\] VGND VGND VPWR VPWR net914 sky130_fd_sc_hd__dlygate4sd3_1
Xhold578 cpuregs\[24\]\[5\] VGND VGND VPWR VPWR net936 sky130_fd_sc_hd__dlygate4sd3_1
XFILLER_0_40_474 VGND VGND VPWR VPWR sky130_fd_sc_hd__fill_2
X_09953_ cpuregs\[20\]\[10\] cpuregs\[21\]\[10\] cpuregs\[22\]\[10\] cpuregs\[23\]\[10\]
+ _04100_ _03939_ VGND VGND VPWR VPWR _04179_ sky130_fd_sc_hd__mux4_1
Xhold589 cpuregs\[30\]\[5\] VGND VGND VPWR VPWR net947 sky130_fd_sc_hd__dlygate4sd3_1
X_09884_ _04109_ _04110_ VGND VGND VPWR VPWR _04111_ sky130_fd_sc_hd__nand2_1
X_08904_ reg_out\[2\] reg_next_pc\[2\] _03225_ VGND VGND VPWR VPWR _03226_ sky130_fd_sc_hd__mux2_1
XTAP_850 VGND VPWR sky130_fd_sc_hd__tapvpwrvgnd_1
XTAP_861 VGND VPWR sky130_fd_sc_hd__tapvpwrvgnd_1
Xhold1223 cpuregs\[29\]\[25\] VGND VGND VPWR VPWR net1581 sky130_fd_sc_hd__dlygate4sd3_1
X_08835_ _02838_ _02846_ _02741_ VGND VGND VPWR VPWR _03186_ sky130_fd_sc_hd__mux2_1
Xhold1234 reg_pc\[16\] VGND VGND VPWR VPWR net1592 sky130_fd_sc_hd__dlygate4sd3_1
Xhold1212 cpuregs\[29\]\[30\] VGND VGND VPWR VPWR net1570 sky130_fd_sc_hd__dlygate4sd3_1
Xhold1201 cpuregs\[29\]\[2\] VGND VGND VPWR VPWR net1559 sky130_fd_sc_hd__dlygate4sd3_1
XTAP_883 VGND VPWR sky130_fd_sc_hd__tapvpwrvgnd_1
XTAP_872 VGND VPWR sky130_fd_sc_hd__tapvpwrvgnd_1
XTAP_894 VGND VPWR sky130_fd_sc_hd__tapvpwrvgnd_1
X_08766_ _02536_ _03087_ _03103_ net186 VGND VGND VPWR VPWR _03123_ sky130_fd_sc_hd__a22o_1
Xhold1267 reg_next_pc\[15\] VGND VGND VPWR VPWR net1625 sky130_fd_sc_hd__dlygate4sd3_1
Xhold1256 decoded_imm\[7\] VGND VGND VPWR VPWR net1614 sky130_fd_sc_hd__dlygate4sd3_1
Xhold1245 cpuregs\[29\]\[3\] VGND VGND VPWR VPWR net1603 sky130_fd_sc_hd__dlygate4sd3_1
Xhold1278 cpuregs\[4\]\[11\] VGND VGND VPWR VPWR net1636 sky130_fd_sc_hd__dlygate4sd3_1
Xhold1289 net134 VGND VGND VPWR VPWR net1647 sky130_fd_sc_hd__dlygate4sd3_1
X_07717_ net414 _02139_ _02142_ VGND VGND VPWR VPWR _00017_ sky130_fd_sc_hd__o21a_1
X_08697_ _03045_ _03048_ _03058_ VGND VGND VPWR VPWR _03059_ sky130_fd_sc_hd__o21ai_1
XFILLER_0_95_603 VGND VGND VPWR VPWR sky130_fd_sc_hd__decap_4
XFILLER_0_73_80 VGND VGND VPWR VPWR sky130_fd_sc_hd__decap_3
XFILLER_0_79_198 VGND VGND VPWR VPWR sky130_fd_sc_hd__fill_1
X_09318_ reg_pc\[18\] reg_pc\[17\] _03549_ reg_pc\[19\] VGND VGND VPWR VPWR _03567_
+ sky130_fd_sc_hd__a31o_1
XFILLER_0_75_382 VGND VGND VPWR VPWR sky130_fd_sc_hd__fill_1
XFILLER_0_36_725 VGND VGND VPWR VPWR sky130_fd_sc_hd__fill_1
XFILLER_0_118_451 VGND VGND VPWR VPWR sky130_fd_sc_hd__fill_2
X_10590_ _04796_ _04797_ VGND VGND VPWR VPWR _04798_ sky130_fd_sc_hd__and2b_1
XFILLER_0_90_330 VPWR VGND VPWR VGND sky130_ef_sc_hd__decap_12
X_09249_ reg_pc\[10\] _03500_ VGND VGND VPWR VPWR _03507_ sky130_fd_sc_hd__and2_1
XFILLER_0_106_679 VGND VGND VPWR VPWR sky130_fd_sc_hd__fill_2
X_12260_ _05877_ _05878_ VGND VGND VPWR VPWR _05879_ sky130_fd_sc_hd__nor2_1
XFILLER_0_50_249 VGND VGND VPWR VPWR sky130_fd_sc_hd__decap_3
X_11211_ net659 _05202_ _05203_ VGND VGND VPWR VPWR _05204_ sky130_fd_sc_hd__mux2_1
XFILLER_0_102_830 VGND VGND VPWR VPWR sky130_fd_sc_hd__fill_2
X_12191_ _05741_ net426 _05725_ _05815_ VGND VGND VPWR VPWR _00680_ sky130_fd_sc_hd__o211a_1
Xoutput43 net43 VGND VGND VPWR VPWR mem_addr[18] sky130_fd_sc_hd__clkbuf_4
X_11142_ net1127 _03641_ _05123_ VGND VGND VPWR VPWR _05157_ sky130_fd_sc_hd__mux2_1
Xoutput54 net54 VGND VGND VPWR VPWR mem_addr[29] sky130_fd_sc_hd__clkbuf_4
Xoutput76 net76 VGND VGND VPWR VPWR mem_la_addr[20] sky130_fd_sc_hd__clkbuf_4
Xoutput65 net65 VGND VGND VPWR VPWR mem_instr sky130_fd_sc_hd__clkbuf_4
X_11073_ _05120_ VGND VGND VPWR VPWR _00257_ sky130_fd_sc_hd__clkbuf_1
Xoutput98 net98 VGND VGND VPWR VPWR mem_la_wdata[10] sky130_fd_sc_hd__clkbuf_4
Xoutput87 net87 VGND VGND VPWR VPWR mem_la_addr[30] sky130_fd_sc_hd__clkbuf_4
X_15950_ clknet_leaf_152_clk _00600_ VGND VGND VPWR VPWR count_instr\[19\] sky130_fd_sc_hd__dfxtp_1
X_14901_ _03641_ net1454 _01792_ VGND VGND VPWR VPWR _01826_ sky130_fd_sc_hd__mux2_1
X_15881_ clknet_leaf_55_clk _00531_ VGND VGND VPWR VPWR cpuregs\[20\]\[15\] sky130_fd_sc_hd__dfxtp_1
X_10024_ cpuregs\[28\]\[12\] cpuregs\[29\]\[12\] cpuregs\[30\]\[12\] cpuregs\[31\]\[12\]
+ _03865_ _03942_ VGND VGND VPWR VPWR _04248_ sky130_fd_sc_hd__mux4_1
X_14832_ net1547 _05223_ net237 VGND VGND VPWR VPWR _01789_ sky130_fd_sc_hd__mux2_1
X_14763_ _01752_ VGND VGND VPWR VPWR _01250_ sky130_fd_sc_hd__clkbuf_1
X_11975_ net413 _05648_ _05533_ VGND VGND VPWR VPWR _05651_ sky130_fd_sc_hd__o21ai_1
X_16502_ clknet_leaf_43_clk _01084_ VGND VGND VPWR VPWR cpuregs\[19\]\[23\] sky130_fd_sc_hd__dfxtp_1
X_13714_ _06969_ _07180_ _07182_ _03309_ _07184_ VGND VGND VPWR VPWR _07185_ sky130_fd_sc_hd__o311a_1
X_14694_ net1102 _05221_ _01706_ VGND VGND VPWR VPWR _01716_ sky130_fd_sc_hd__mux2_1
X_10926_ _05040_ VGND VGND VPWR VPWR _00190_ sky130_fd_sc_hd__clkbuf_1
XFILLER_0_85_113 VGND VGND VPWR VPWR sky130_fd_sc_hd__decap_4
XFILLER_0_129_738 VGND VGND VPWR VPWR sky130_fd_sc_hd__fill_2
X_13645_ _03340_ _07117_ _06998_ VGND VGND VPWR VPWR _07118_ sky130_fd_sc_hd__a21o_1
X_16433_ clknet_leaf_25_clk _01015_ VGND VGND VPWR VPWR decoded_imm\[14\] sky130_fd_sc_hd__dfxtp_2
XFILLER_0_73_308 VGND VGND VPWR VPWR sky130_fd_sc_hd__fill_1
X_10857_ _04993_ net1156 _04985_ VGND VGND VPWR VPWR _04994_ sky130_fd_sc_hd__mux2_1
XFILLER_0_128_259 VGND VGND VPWR VPWR sky130_fd_sc_hd__fill_2
XPHY_160 VGND VGND VPWR VPWR sky130_fd_sc_hd__decap_3
XFILLER_0_54_522 VGND VGND VPWR VPWR sky130_fd_sc_hd__decap_8
X_16364_ clknet_leaf_67_clk _00946_ VGND VGND VPWR VPWR cpuregs\[1\]\[29\] sky130_fd_sc_hd__dfxtp_1
X_13576_ _06792_ _07049_ _07051_ _06894_ VGND VGND VPWR VPWR _07052_ sky130_fd_sc_hd__a211o_1
XPHY_193 VGND VGND VPWR VPWR sky130_fd_sc_hd__decap_3
XPHY_182 VGND VGND VPWR VPWR sky130_fd_sc_hd__decap_3
XPHY_171 VGND VGND VPWR VPWR sky130_fd_sc_hd__decap_3
XFILLER_0_26_235 VGND VGND VPWR VPWR sky130_fd_sc_hd__fill_1
X_10788_ net649 _03491_ _04946_ VGND VGND VPWR VPWR _04954_ sky130_fd_sc_hd__mux2_1
XFILLER_0_124_421 VGND VGND VPWR VPWR sky130_fd_sc_hd__decap_3
X_12527_ _06116_ VGND VGND VPWR VPWR _00715_ sky130_fd_sc_hd__clkbuf_1
X_16295_ clknet_leaf_4_clk _00880_ VGND VGND VPWR VPWR instr_srai sky130_fd_sc_hd__dfxtp_1
X_15315_ _03456_ net1427 _02041_ VGND VGND VPWR VPWR _02044_ sky130_fd_sc_hd__mux2_1
XFILLER_0_42_717 VGND VGND VPWR VPWR sky130_fd_sc_hd__fill_2
X_12458_ _06057_ _06060_ VGND VGND VPWR VPWR _06061_ sky130_fd_sc_hd__xnor2_1
X_15246_ _02008_ VGND VGND VPWR VPWR _01477_ sky130_fd_sc_hd__clkbuf_1
X_11409_ net1522 _05184_ _05313_ VGND VGND VPWR VPWR _05315_ sky130_fd_sc_hd__mux2_1
X_12389_ _05996_ _05997_ _05769_ VGND VGND VPWR VPWR _05998_ sky130_fd_sc_hd__o21ai_1
XFILLER_0_111_137 VGND VGND VPWR VPWR sky130_fd_sc_hd__decap_3
XFILLER_0_1_335 VGND VGND VPWR VPWR sky130_fd_sc_hd__fill_1
X_15177_ _03441_ _04905_ VGND VGND VPWR VPWR _01972_ sky130_fd_sc_hd__or2_4
X_14128_ _05008_ net943 _07482_ VGND VGND VPWR VPWR _07484_ sky130_fd_sc_hd__mux2_1
X_14059_ net395 _01102_ _07420_ VGND VGND VPWR VPWR _07446_ sky130_fd_sc_hd__mux2_1
XFILLER_0_118_75 VGND VGND VPWR VPWR sky130_fd_sc_hd__fill_1
X_08620_ _02867_ _02984_ _02985_ _02988_ _02686_ VGND VGND VPWR VPWR alu_out\[12\]
+ sky130_fd_sc_hd__a32o_1
XFILLER_0_27_40 VGND VGND VPWR VPWR sky130_fd_sc_hd__decap_4
X_08551_ net200 _02924_ VGND VGND VPWR VPWR _02925_ sky130_fd_sc_hd__and2_1
XFILLER_0_134_41 VPWR VGND VPWR VGND sky130_ef_sc_hd__decap_12
XFILLER_0_49_349 VGND VGND VPWR VPWR sky130_fd_sc_hd__decap_4
X_08482_ net252 _02860_ VGND VGND VPWR VPWR _02861_ sky130_fd_sc_hd__xnor2_1
XFILLER_0_134_85 VPWR VGND VPWR VGND sky130_ef_sc_hd__decap_12
XFILLER_0_9_402 VGND VGND VPWR VPWR sky130_fd_sc_hd__fill_2
XFILLER_0_119_237 VGND VGND VPWR VPWR sky130_fd_sc_hd__fill_1
XFILLER_0_9_446 VGND VGND VPWR VPWR sky130_fd_sc_hd__fill_2
XFILLER_0_18_725 VGND VGND VPWR VPWR sky130_fd_sc_hd__fill_2
XFILLER_0_91_138 VGND VGND VPWR VPWR sky130_fd_sc_hd__fill_1
X_09103_ _03341_ _03380_ _03382_ VGND VGND VPWR VPWR _03383_ sky130_fd_sc_hd__a21o_1
XFILLER_0_127_281 VGND VGND VPWR VPWR sky130_fd_sc_hd__decap_4
XFILLER_0_4_151 VGND VGND VPWR VPWR sky130_fd_sc_hd__fill_1
XFILLER_0_32_216 VGND VGND VPWR VPWR sky130_fd_sc_hd__fill_1
X_09034_ cpuregs\[4\]\[2\] cpuregs\[5\]\[2\] cpuregs\[6\]\[2\] cpuregs\[7\]\[2\] _03313_
+ _03314_ VGND VGND VPWR VPWR _03315_ sky130_fd_sc_hd__mux4_1
Xhold320 cpuregs\[12\]\[30\] VGND VGND VPWR VPWR net678 sky130_fd_sc_hd__dlygate4sd3_1
XFILLER_0_102_104 VGND VGND VPWR VPWR sky130_fd_sc_hd__decap_6
XFILLER_0_102_148 VGND VGND VPWR VPWR sky130_fd_sc_hd__fill_2
Xhold331 cpuregs\[31\]\[14\] VGND VGND VPWR VPWR net689 sky130_fd_sc_hd__dlygate4sd3_1
Xhold353 cpuregs\[30\]\[14\] VGND VGND VPWR VPWR net711 sky130_fd_sc_hd__dlygate4sd3_1
XFILLER_0_4_195 VGND VGND VPWR VPWR sky130_fd_sc_hd__fill_1
XFILLER_0_13_485 VGND VGND VPWR VPWR sky130_fd_sc_hd__decap_3
Xhold342 cpuregs\[26\]\[3\] VGND VGND VPWR VPWR net700 sky130_fd_sc_hd__dlygate4sd3_1
Xhold386 cpuregs\[26\]\[28\] VGND VGND VPWR VPWR net744 sky130_fd_sc_hd__dlygate4sd3_1
Xhold375 cpuregs\[26\]\[19\] VGND VGND VPWR VPWR net733 sky130_fd_sc_hd__dlygate4sd3_1
Xhold364 cpuregs\[19\]\[31\] VGND VGND VPWR VPWR net722 sky130_fd_sc_hd__dlygate4sd3_1
XFILLER_0_2_9 VPWR VGND VPWR VGND sky130_ef_sc_hd__decap_12
X_09936_ _02156_ _04159_ _04161_ _02159_ VGND VGND VPWR VPWR _04162_ sky130_fd_sc_hd__o211a_1
Xhold397 _01018_ VGND VGND VPWR VPWR net755 sky130_fd_sc_hd__dlygate4sd3_1
XFILLER_0_0_390 VGND VGND VPWR VPWR sky130_fd_sc_hd__fill_2
Xhold1042 cpuregs\[17\]\[30\] VGND VGND VPWR VPWR net1400 sky130_fd_sc_hd__dlygate4sd3_1
Xhold1020 cpuregs\[2\]\[11\] VGND VGND VPWR VPWR net1378 sky130_fd_sc_hd__dlygate4sd3_1
XTAP_691 VGND VPWR sky130_fd_sc_hd__tapvpwrvgnd_1
XTAP_680 VGND VPWR sky130_fd_sc_hd__tapvpwrvgnd_1
X_09867_ _03720_ _04092_ _04094_ VGND VGND VPWR VPWR _04095_ sky130_fd_sc_hd__a21o_1
Xhold1031 cpuregs\[1\]\[2\] VGND VGND VPWR VPWR net1389 sky130_fd_sc_hd__dlygate4sd3_1
X_08818_ net223 _03170_ VGND VGND VPWR VPWR _03171_ sky130_fd_sc_hd__xnor2_1
X_09798_ _03726_ VGND VGND VPWR VPWR _04028_ sky130_fd_sc_hd__buf_4
Xhold1075 cpuregs\[8\]\[18\] VGND VGND VPWR VPWR net1433 sky130_fd_sc_hd__dlygate4sd3_1
Xhold1064 cpuregs\[7\]\[11\] VGND VGND VPWR VPWR net1422 sky130_fd_sc_hd__dlygate4sd3_1
Xhold1053 cpuregs\[29\]\[0\] VGND VGND VPWR VPWR net1411 sky130_fd_sc_hd__dlygate4sd3_1
X_08749_ _03105_ _03106_ VGND VGND VPWR VPWR _03107_ sky130_fd_sc_hd__or2_1
Xhold1086 cpuregs\[29\]\[29\] VGND VGND VPWR VPWR net1444 sky130_fd_sc_hd__dlygate4sd3_1
Xhold1097 cpuregs\[3\]\[5\] VGND VGND VPWR VPWR net1455 sky130_fd_sc_hd__dlygate4sd3_1
XTAP_1824 VGND VPWR sky130_fd_sc_hd__tapvpwrvgnd_1
XTAP_1813 VGND VPWR sky130_fd_sc_hd__tapvpwrvgnd_1
XTAP_1802 VGND VPWR sky130_fd_sc_hd__tapvpwrvgnd_1
X_11760_ _05018_ net671 _05494_ VGND VGND VPWR VPWR _05501_ sky130_fd_sc_hd__mux2_1
XFILLER_0_67_113 VGND VGND VPWR VPWR sky130_fd_sc_hd__fill_1
XTAP_1857 VGND VPWR sky130_fd_sc_hd__tapvpwrvgnd_1
XTAP_1846 VGND VPWR sky130_fd_sc_hd__tapvpwrvgnd_1
XTAP_1835 VGND VPWR sky130_fd_sc_hd__tapvpwrvgnd_1
X_10711_ net1052 _03472_ _04907_ VGND VGND VPWR VPWR _04912_ sky130_fd_sc_hd__mux2_1
XTAP_1879 VGND VPWR sky130_fd_sc_hd__tapvpwrvgnd_1
XTAP_1868 VGND VPWR sky130_fd_sc_hd__tapvpwrvgnd_1
X_11691_ _05464_ VGND VGND VPWR VPWR _00531_ sky130_fd_sc_hd__clkbuf_1
X_10642_ _04127_ _04846_ _04848_ VGND VGND VPWR VPWR _04849_ sky130_fd_sc_hd__a21o_1
XFILLER_0_125_218 VGND VGND VPWR VPWR sky130_fd_sc_hd__decap_6
X_13430_ _06773_ _06909_ VGND VGND VPWR VPWR _06910_ sky130_fd_sc_hd__and2_1
XFILLER_0_82_138 VGND VGND VPWR VPWR sky130_fd_sc_hd__fill_2
XFILLER_0_134_741 VGND VGND VPWR VPWR sky130_fd_sc_hd__fill_1
X_10573_ _03817_ _04775_ _04781_ VGND VGND VPWR VPWR _04782_ sky130_fd_sc_hd__or3_1
XFILLER_0_106_432 VGND VGND VPWR VPWR sky130_fd_sc_hd__decap_6
XFILLER_0_106_421 VGND VGND VPWR VPWR sky130_fd_sc_hd__fill_2
X_13361_ cpuregs\[6\]\[17\] cpuregs\[7\]\[17\] _06842_ VGND VGND VPWR VPWR _06843_
+ sky130_fd_sc_hd__mux2_1
X_15100_ _01931_ VGND VGND VPWR VPWR _01408_ sky130_fd_sc_hd__clkbuf_1
X_13292_ cpuregs\[0\]\[15\] cpuregs\[1\]\[15\] cpuregs\[2\]\[15\] cpuregs\[3\]\[15\]
+ _06740_ _06708_ VGND VGND VPWR VPWR _06776_ sky130_fd_sc_hd__mux4_1
X_12312_ _05909_ _05925_ _05926_ VGND VGND VPWR VPWR _05927_ sky130_fd_sc_hd__o21ai_2
XFILLER_0_63_385 VGND VGND VPWR VPWR sky130_fd_sc_hd__decap_4
XFILLER_0_51_525 VGND VGND VPWR VPWR sky130_fd_sc_hd__fill_1
Xrebuffer9 net368 VGND VGND VPWR VPWR net367 sky130_fd_sc_hd__clkbuf_1
X_16080_ clknet_leaf_1_clk _00730_ VGND VGND VPWR VPWR count_cycle\[23\] sky130_fd_sc_hd__dfxtp_1
X_15031_ _03622_ net1149 _01887_ VGND VGND VPWR VPWR _01895_ sky130_fd_sc_hd__mux2_1
X_12243_ _05792_ _05860_ _05861_ _05863_ VGND VGND VPWR VPWR _05864_ sky130_fd_sc_hd__a31oi_1
XFILLER_0_139_19 VGND VGND VPWR VPWR sky130_fd_sc_hd__fill_1
X_12174_ _05700_ _05787_ _05799_ VGND VGND VPWR VPWR _05800_ sky130_fd_sc_hd__o21a_1
X_11125_ _05148_ VGND VGND VPWR VPWR _00281_ sky130_fd_sc_hd__clkbuf_1
X_11056_ net646 _03584_ _05110_ VGND VGND VPWR VPWR _05112_ sky130_fd_sc_hd__mux2_1
X_15933_ clknet_leaf_149_clk _00583_ VGND VGND VPWR VPWR count_instr\[2\] sky130_fd_sc_hd__dfxtp_1
X_10007_ _02378_ _02403_ _03997_ VGND VGND VPWR VPWR _04231_ sky130_fd_sc_hd__mux2_1
XFILLER_0_64_16 VGND VGND VPWR VPWR sky130_fd_sc_hd__fill_2
X_15864_ clknet_leaf_57_clk _00514_ VGND VGND VPWR VPWR cpuregs\[25\]\[30\] sky130_fd_sc_hd__dfxtp_1
X_15795_ clknet_leaf_64_clk _00445_ VGND VGND VPWR VPWR cpuregs\[26\]\[25\] sky130_fd_sc_hd__dfxtp_1
X_14815_ _01780_ VGND VGND VPWR VPWR _01274_ sky130_fd_sc_hd__clkbuf_1
X_14746_ _05029_ net1459 _01742_ VGND VGND VPWR VPWR _01744_ sky130_fd_sc_hd__mux2_1
XFILLER_0_86_466 VGND VGND VPWR VPWR sky130_fd_sc_hd__fill_1
XFILLER_0_58_157 VGND VGND VPWR VPWR sky130_fd_sc_hd__fill_1
X_11958_ _05637_ _05620_ _05638_ VGND VGND VPWR VPWR _05639_ sky130_fd_sc_hd__and3b_1
X_10909_ _03583_ VGND VGND VPWR VPWR _05029_ sky130_fd_sc_hd__buf_4
X_14677_ _01707_ VGND VGND VPWR VPWR _01209_ sky130_fd_sc_hd__clkbuf_1
X_11889_ net427 _05585_ _05588_ VGND VGND VPWR VPWR _00605_ sky130_fd_sc_hd__a21oi_1
X_13628_ cpuregs\[20\]\[25\] cpuregs\[21\]\[25\] _06456_ VGND VGND VPWR VPWR _07102_
+ sky130_fd_sc_hd__mux2_1
X_16416_ clknet_leaf_26_clk _00998_ VGND VGND VPWR VPWR decoded_imm\[31\] sky130_fd_sc_hd__dfxtp_2
XFILLER_0_55_831 VGND VGND VPWR VPWR sky130_fd_sc_hd__fill_1
XFILLER_0_13_53 VGND VGND VPWR VPWR sky130_fd_sc_hd__decap_3
X_13559_ _06970_ _07034_ VGND VGND VPWR VPWR _07035_ sky130_fd_sc_hd__and2_1
XFILLER_0_116_229 VGND VGND VPWR VPWR sky130_fd_sc_hd__fill_2
XFILLER_0_89_13 VGND VGND VPWR VPWR sky130_fd_sc_hd__decap_6
XFILLER_0_82_661 VGND VGND VPWR VPWR sky130_fd_sc_hd__fill_2
X_16347_ clknet_leaf_108_clk _00929_ VGND VGND VPWR VPWR cpuregs\[1\]\[12\] sky130_fd_sc_hd__dfxtp_1
XFILLER_0_89_57 VGND VGND VPWR VPWR sky130_fd_sc_hd__decap_6
XFILLER_0_27_599 VGND VGND VPWR VPWR sky130_fd_sc_hd__fill_1
XFILLER_0_120_65 VGND VGND VPWR VPWR sky130_fd_sc_hd__decap_3
X_16278_ clknet_leaf_141_clk _00863_ VGND VGND VPWR VPWR instr_sltiu sky130_fd_sc_hd__dfxtp_1
X_15229_ _03603_ net1122 _01995_ VGND VGND VPWR VPWR _02000_ sky130_fd_sc_hd__mux2_1
XFILLER_0_1_154 VPWR VGND VPWR VGND sky130_ef_sc_hd__decap_12
X_07982_ reg_pc\[10\] decoded_imm\[10\] _02373_ VGND VGND VPWR VPWR _02383_ sky130_fd_sc_hd__nand3_1
X_09721_ _03950_ _03951_ _03653_ VGND VGND VPWR VPWR _03952_ sky130_fd_sc_hd__mux2_1
XFILLER_0_38_50 VGND VGND VPWR VPWR sky130_fd_sc_hd__decap_6
XFILLER_0_38_83 VGND VGND VPWR VPWR sky130_fd_sc_hd__fill_1
X_09652_ _03659_ VGND VGND VPWR VPWR _03885_ sky130_fd_sc_hd__clkbuf_8
X_08603_ _02935_ _02971_ VGND VGND VPWR VPWR _02972_ sky130_fd_sc_hd__or2_1
X_09583_ _03687_ VGND VGND VPWR VPWR _03817_ sky130_fd_sc_hd__buf_4
X_08534_ _02664_ _02908_ VGND VGND VPWR VPWR _02909_ sky130_fd_sc_hd__xnor2_1
XTAP_1109 VGND VPWR sky130_fd_sc_hd__tapvpwrvgnd_1
X_08465_ _02845_ VGND VGND VPWR VPWR _02846_ sky130_fd_sc_hd__clkbuf_4
X_08396_ _02699_ _02700_ _02772_ _02776_ VGND VGND VPWR VPWR _02777_ sky130_fd_sc_hd__a22o_1
XFILLER_0_18_566 VGND VGND VPWR VPWR sky130_fd_sc_hd__fill_1
XFILLER_0_72_171 VGND VGND VPWR VPWR sky130_fd_sc_hd__fill_1
X_09017_ _03302_ VGND VGND VPWR VPWR _01111_ sky130_fd_sc_hd__buf_1
XFILLER_0_33_558 VGND VGND VPWR VPWR sky130_fd_sc_hd__fill_2
XFILLER_0_79_90 VGND VGND VPWR VPWR sky130_fd_sc_hd__fill_1
XFILLER_0_14_783 VGND VGND VPWR VPWR sky130_fd_sc_hd__fill_1
Xhold150 reg_next_pc\[8\] VGND VGND VPWR VPWR net508 sky130_fd_sc_hd__dlygate4sd3_1
Xhold161 cpuregs\[0\]\[12\] VGND VGND VPWR VPWR net519 sky130_fd_sc_hd__dlygate4sd3_1
Xhold183 reg_next_pc\[19\] VGND VGND VPWR VPWR net541 sky130_fd_sc_hd__dlygate4sd3_1
Xhold172 net41 VGND VGND VPWR VPWR net530 sky130_fd_sc_hd__dlygate4sd3_1
Xhold194 count_cycle\[11\] VGND VGND VPWR VPWR net552 sky130_fd_sc_hd__dlygate4sd3_1
X_09919_ _03817_ _04139_ _04145_ VGND VGND VPWR VPWR _04146_ sky130_fd_sc_hd__or3_1
X_12930_ _03312_ VGND VGND VPWR VPWR _06424_ sky130_fd_sc_hd__buf_4
XTAP_2311 VGND VPWR sky130_fd_sc_hd__tapvpwrvgnd_1
XTAP_2300 VGND VPWR sky130_fd_sc_hd__tapvpwrvgnd_1
XFILLER_0_87_219 VGND VGND VPWR VPWR sky130_fd_sc_hd__fill_2
X_12861_ _03321_ _06355_ _06359_ _03332_ VGND VGND VPWR VPWR _06360_ sky130_fd_sc_hd__o211a_1
XTAP_2344 VGND VPWR sky130_fd_sc_hd__tapvpwrvgnd_1
XTAP_2333 VGND VPWR sky130_fd_sc_hd__tapvpwrvgnd_1
XTAP_2322 VGND VPWR sky130_fd_sc_hd__tapvpwrvgnd_1
X_14600_ _01666_ VGND VGND VPWR VPWR _01173_ sky130_fd_sc_hd__clkbuf_1
X_11812_ _05532_ VGND VGND VPWR VPWR _00584_ sky130_fd_sc_hd__clkbuf_1
XTAP_1632 VGND VPWR sky130_fd_sc_hd__tapvpwrvgnd_1
XTAP_1621 VGND VPWR sky130_fd_sc_hd__tapvpwrvgnd_1
XTAP_1610 VGND VPWR sky130_fd_sc_hd__tapvpwrvgnd_1
X_12792_ _06310_ VGND VGND VPWR VPWR _00786_ sky130_fd_sc_hd__clkbuf_1
X_15580_ clknet_leaf_100_clk _00230_ VGND VGND VPWR VPWR cpuregs\[28\]\[2\] sky130_fd_sc_hd__dfxtp_1
XTAP_1676 VGND VPWR sky130_fd_sc_hd__tapvpwrvgnd_1
XTAP_1665 VGND VPWR sky130_fd_sc_hd__tapvpwrvgnd_1
XTAP_1643 VGND VPWR sky130_fd_sc_hd__tapvpwrvgnd_1
XTAP_1654 VGND VPWR sky130_fd_sc_hd__tapvpwrvgnd_1
X_14531_ net928 _05194_ _01623_ VGND VGND VPWR VPWR _01630_ sky130_fd_sc_hd__mux2_1
X_11743_ _05001_ net867 _05483_ VGND VGND VPWR VPWR _05492_ sky130_fd_sc_hd__mux2_1
XFILLER_0_138_365 VGND VGND VPWR VPWR sky130_fd_sc_hd__decap_4
XTAP_1698 VGND VPWR sky130_fd_sc_hd__tapvpwrvgnd_1
XTAP_1687 VGND VPWR sky130_fd_sc_hd__tapvpwrvgnd_1
X_14462_ _01593_ VGND VGND VPWR VPWR _01076_ sky130_fd_sc_hd__clkbuf_1
XFILLER_0_83_458 VGND VGND VPWR VPWR sky130_fd_sc_hd__decap_4
X_11674_ _05455_ VGND VGND VPWR VPWR _00523_ sky130_fd_sc_hd__clkbuf_1
XFILLER_0_126_549 VGND VGND VPWR VPWR sky130_fd_sc_hd__decap_4
X_10625_ decoded_imm\[29\] net192 VGND VGND VPWR VPWR _04832_ sky130_fd_sc_hd__and2_1
X_16201_ clknet_leaf_21_clk _00818_ VGND VGND VPWR VPWR net206 sky130_fd_sc_hd__dfxtp_1
X_13413_ _03310_ VGND VGND VPWR VPWR _06894_ sky130_fd_sc_hd__clkbuf_4
XFILLER_0_48_190 VGND VGND VPWR VPWR sky130_fd_sc_hd__decap_6
XFILLER_0_36_363 VGND VGND VPWR VPWR sky130_fd_sc_hd__fill_1
X_14393_ _05016_ net884 _01551_ VGND VGND VPWR VPWR _01557_ sky130_fd_sc_hd__mux2_1
X_16132_ clknet_leaf_24_clk _07619_ VGND VGND VPWR VPWR reg_out\[10\] sky130_fd_sc_hd__dfxtp_1
X_10556_ cpuregs\[0\]\[27\] cpuregs\[1\]\[27\] _03824_ VGND VGND VPWR VPWR _04765_
+ sky130_fd_sc_hd__mux2_1
Xpicorv32_308 VGND VGND VPWR VPWR picorv32_308/HI pcpi_insn[19] sky130_fd_sc_hd__conb_1
XFILLER_0_107_796 VGND VGND VPWR VPWR sky130_fd_sc_hd__fill_2
X_13344_ cpuregs\[30\]\[16\] cpuregs\[31\]\[16\] _06754_ VGND VGND VPWR VPWR _06827_
+ sky130_fd_sc_hd__mux2_1
X_10487_ cpuregs\[2\]\[25\] cpuregs\[3\]\[25\] _03755_ VGND VGND VPWR VPWR _04698_
+ sky130_fd_sc_hd__mux2_1
XFILLER_0_122_755 VGND VGND VPWR VPWR sky130_fd_sc_hd__fill_1
X_13275_ _06416_ _06744_ _06759_ _06470_ decoded_imm\[14\] VGND VGND VPWR VPWR _06760_
+ sky130_fd_sc_hd__a32o_1
Xpicorv32_319 VGND VGND VPWR VPWR picorv32_319/HI pcpi_insn[30] sky130_fd_sc_hd__conb_1
X_16063_ clknet_leaf_148_clk _00713_ VGND VGND VPWR VPWR count_cycle\[6\] sky130_fd_sc_hd__dfxtp_1
XFILLER_0_121_265 VGND VGND VPWR VPWR sky130_fd_sc_hd__decap_3
X_15014_ _03571_ net1001 _01876_ VGND VGND VPWR VPWR _01886_ sky130_fd_sc_hd__mux2_1
X_12226_ _05846_ _05837_ VGND VGND VPWR VPWR _05848_ sky130_fd_sc_hd__nor2_1
XFILLER_0_20_720 VGND VGND VPWR VPWR sky130_fd_sc_hd__fill_2
XFILLER_0_20_731 VGND VGND VPWR VPWR sky130_fd_sc_hd__fill_2
X_12157_ _05769_ _05781_ _05783_ VGND VGND VPWR VPWR _05784_ sky130_fd_sc_hd__and3_1
XFILLER_0_75_26 VGND VGND VPWR VPWR sky130_fd_sc_hd__fill_1
X_11108_ _05139_ VGND VGND VPWR VPWR _00273_ sky130_fd_sc_hd__clkbuf_1
X_16965_ clknet_leaf_83_clk _01529_ VGND VGND VPWR VPWR cpuregs\[10\]\[20\] sky130_fd_sc_hd__dfxtp_1
X_12088_ _03560_ reg_next_pc\[18\] _03223_ VGND VGND VPWR VPWR _05731_ sky130_fd_sc_hd__mux2_2
X_15916_ clknet_leaf_58_clk _00566_ VGND VGND VPWR VPWR cpuregs\[17\]\[18\] sky130_fd_sc_hd__dfxtp_1
X_16896_ clknet_leaf_86_clk _01460_ VGND VGND VPWR VPWR cpuregs\[8\]\[15\] sky130_fd_sc_hd__dfxtp_1
X_11039_ net742 _03532_ _05099_ VGND VGND VPWR VPWR _05103_ sky130_fd_sc_hd__mux2_1
X_15847_ clknet_leaf_98_clk _00497_ VGND VGND VPWR VPWR cpuregs\[25\]\[13\] sky130_fd_sc_hd__dfxtp_1
XFILLER_0_91_69 VGND VGND VPWR VPWR sky130_fd_sc_hd__decap_8
X_15778_ clknet_leaf_143_clk _00428_ VGND VGND VPWR VPWR cpuregs\[26\]\[8\] sky130_fd_sc_hd__dfxtp_1
X_14729_ _05012_ net1577 _01731_ VGND VGND VPWR VPWR _01735_ sky130_fd_sc_hd__mux2_1
XFILLER_0_47_628 VGND VGND VPWR VPWR sky130_fd_sc_hd__fill_2
X_08250_ _02309_ _02632_ _02446_ _02633_ VGND VGND VPWR VPWR _02634_ sky130_fd_sc_hd__o2bb2a_1
XFILLER_0_74_447 VGND VGND VPWR VPWR sky130_fd_sc_hd__fill_2
X_08181_ _02286_ _02555_ _02569_ VGND VGND VPWR VPWR _07634_ sky130_fd_sc_hd__o21a_1
XFILLER_0_131_53 VGND VGND VPWR VPWR sky130_fd_sc_hd__decap_3
XFILLER_0_43_823 VGND VGND VPWR VPWR sky130_fd_sc_hd__fill_2
XFILLER_0_125_582 VGND VGND VPWR VPWR sky130_fd_sc_hd__fill_2
Xoutput200 net200 VGND VGND VPWR VPWR pcpi_rs1[7] sky130_fd_sc_hd__clkbuf_4
XFILLER_0_70_675 VGND VGND VPWR VPWR sky130_fd_sc_hd__fill_1
Xoutput222 net222 VGND VGND VPWR VPWR pcpi_rs2[27] sky130_fd_sc_hd__clkbuf_4
XFILLER_0_2_474 VGND VGND VPWR VPWR sky130_fd_sc_hd__fill_2
Xoutput233 net233 VGND VGND VPWR VPWR pcpi_rs2[8] sky130_fd_sc_hd__clkbuf_4
Xoutput211 net211 VGND VGND VPWR VPWR pcpi_rs2[17] sky130_fd_sc_hd__clkbuf_4
XFILLER_0_112_287 VGND VGND VPWR VPWR sky130_fd_sc_hd__fill_1
XFILLER_0_10_241 VGND VGND VPWR VPWR sky130_fd_sc_hd__fill_2
XFILLER_0_10_296 VPWR VGND VPWR VGND sky130_ef_sc_hd__decap_12
XFILLER_0_11_797 VPWR VGND VPWR VGND sky130_ef_sc_hd__decap_12
X_07965_ count_instr\[10\] _02270_ count_cycle\[10\] _02202_ _02367_ VGND VGND VPWR
+ VPWR _02368_ sky130_fd_sc_hd__a221o_4
X_09704_ _03820_ VGND VGND VPWR VPWR _03936_ sky130_fd_sc_hd__clkbuf_8
X_09635_ _03823_ VGND VGND VPWR VPWR _03868_ sky130_fd_sc_hd__clkbuf_8
X_07896_ reg_pc\[5\] decoded_imm\[5\] VGND VGND VPWR VPWR _02303_ sky130_fd_sc_hd__nand2_1
X_09566_ cpuregs\[12\]\[2\] cpuregs\[13\]\[2\] cpuregs\[14\]\[2\] cpuregs\[15\]\[2\]
+ _03798_ _03799_ VGND VGND VPWR VPWR _03800_ sky130_fd_sc_hd__mux4_1
XFILLER_0_65_403 VGND VGND VPWR VPWR sky130_fd_sc_hd__decap_4
X_08517_ _02857_ _02893_ VGND VGND VPWR VPWR _02894_ sky130_fd_sc_hd__or2_1
X_09497_ _03731_ VGND VGND VPWR VPWR _03732_ sky130_fd_sc_hd__clkbuf_8
XFILLER_0_19_820 VGND VGND VPWR VPWR sky130_fd_sc_hd__fill_2
X_08448_ is_sltiu_bltu_sltu VGND VGND VPWR VPWR _02829_ sky130_fd_sc_hd__inv_2
XFILLER_0_135_346 VGND VGND VPWR VPWR sky130_fd_sc_hd__fill_1
X_10410_ cpuregs\[4\]\[23\] cpuregs\[5\]\[23\] cpuregs\[6\]\[23\] cpuregs\[7\]\[23\]
+ _03864_ _03820_ VGND VGND VPWR VPWR _04623_ sky130_fd_sc_hd__mux4_1
XFILLER_0_92_288 VGND VGND VPWR VPWR sky130_fd_sc_hd__decap_3
X_08379_ _02698_ _02722_ _02747_ _02759_ VGND VGND VPWR VPWR _02760_ sky130_fd_sc_hd__and4b_4
XFILLER_0_60_141 VGND VGND VPWR VPWR sky130_fd_sc_hd__fill_1
XFILLER_0_60_130 VGND VGND VPWR VPWR sky130_fd_sc_hd__decap_8
X_11390_ net666 _05165_ _05302_ VGND VGND VPWR VPWR _05305_ sky130_fd_sc_hd__mux2_1
X_10341_ cpuregs\[0\]\[21\] cpuregs\[1\]\[21\] _03824_ VGND VGND VPWR VPWR _04556_
+ sky130_fd_sc_hd__mux2_1
XFILLER_0_104_755 VGND VGND VPWR VPWR sky130_fd_sc_hd__fill_1
XFILLER_0_103_221 VGND VGND VPWR VPWR sky130_fd_sc_hd__decap_3
XFILLER_0_103_254 VGND VGND VPWR VPWR sky130_fd_sc_hd__fill_1
X_10272_ _03723_ _04488_ _03661_ VGND VGND VPWR VPWR _04489_ sky130_fd_sc_hd__a21o_1
X_13060_ _03307_ _06543_ _06550_ VGND VGND VPWR VPWR _06551_ sky130_fd_sc_hd__or3_2
X_12011_ _05676_ VGND VGND VPWR VPWR _00639_ sky130_fd_sc_hd__clkbuf_1
X_16750_ clknet_leaf_70_clk _01314_ VGND VGND VPWR VPWR cpuregs\[4\]\[29\] sky130_fd_sc_hd__dfxtp_1
X_13962_ mem_rdata_q\[31\] mem_rdata_q\[29\] _07380_ mem_rdata_q\[30\] VGND VGND VPWR
+ VPWR _07387_ sky130_fd_sc_hd__nor4b_1
X_15701_ clknet_leaf_45_clk _00351_ VGND VGND VPWR VPWR cpuregs\[27\]\[27\] sky130_fd_sc_hd__dfxtp_1
X_12913_ _06409_ VGND VGND VPWR VPWR _00808_ sky130_fd_sc_hd__clkbuf_1
X_16681_ clknet_leaf_68_clk _01248_ VGND VGND VPWR VPWR cpuregs\[29\]\[27\] sky130_fd_sc_hd__dfxtp_1
X_13893_ mem_rdata_q\[13\] mem_rdata_q\[12\] mem_rdata_q\[14\] VGND VGND VPWR VPWR
+ _07342_ sky130_fd_sc_hd__and3b_1
XTAP_2152 VGND VPWR sky130_fd_sc_hd__tapvpwrvgnd_1
XTAP_2141 VGND VPWR sky130_fd_sc_hd__tapvpwrvgnd_1
XTAP_2130 VGND VPWR sky130_fd_sc_hd__tapvpwrvgnd_1
X_15632_ clknet_leaf_61_clk _00282_ VGND VGND VPWR VPWR cpuregs\[31\]\[22\] sky130_fd_sc_hd__dfxtp_1
X_12844_ _03310_ VGND VGND VPWR VPWR _06343_ sky130_fd_sc_hd__clkbuf_8
XTAP_2185 VGND VPWR sky130_fd_sc_hd__tapvpwrvgnd_1
XTAP_2174 VGND VPWR sky130_fd_sc_hd__tapvpwrvgnd_1
XTAP_2163 VGND VPWR sky130_fd_sc_hd__tapvpwrvgnd_1
XFILLER_0_96_572 VGND VGND VPWR VPWR sky130_fd_sc_hd__fill_1
XFILLER_0_83_200 VPWR VGND VPWR VGND sky130_ef_sc_hd__decap_12
XTAP_1451 VGND VPWR sky130_fd_sc_hd__tapvpwrvgnd_1
XTAP_1440 VGND VPWR sky130_fd_sc_hd__tapvpwrvgnd_1
X_15563_ clknet_leaf_89_clk _00213_ VGND VGND VPWR VPWR cpuregs\[2\]\[17\] sky130_fd_sc_hd__dfxtp_1
X_12775_ _06301_ VGND VGND VPWR VPWR _00778_ sky130_fd_sc_hd__clkbuf_1
XTAP_2196 VGND VPWR sky130_fd_sc_hd__tapvpwrvgnd_1
XFILLER_0_127_814 VGND VGND VPWR VPWR sky130_fd_sc_hd__fill_2
XTAP_1484 VGND VPWR sky130_fd_sc_hd__tapvpwrvgnd_1
XTAP_1473 VGND VPWR sky130_fd_sc_hd__tapvpwrvgnd_1
XTAP_1462 VGND VPWR sky130_fd_sc_hd__tapvpwrvgnd_1
X_14514_ net1086 _05177_ _01612_ VGND VGND VPWR VPWR _01621_ sky130_fd_sc_hd__mux2_1
X_11726_ _05482_ VGND VGND VPWR VPWR _05483_ sky130_fd_sc_hd__buf_4
XFILLER_0_138_184 VPWR VGND VPWR VGND sky130_ef_sc_hd__decap_12
XFILLER_0_138_162 VGND VGND VPWR VPWR sky130_fd_sc_hd__decap_6
XFILLER_0_126_313 VGND VGND VPWR VPWR sky130_fd_sc_hd__decap_6
XTAP_1495 VGND VPWR sky130_fd_sc_hd__tapvpwrvgnd_1
X_15494_ clknet_leaf_135_clk _00144_ VGND VGND VPWR VPWR cpuregs\[30\]\[12\] sky130_fd_sc_hd__dfxtp_1
XFILLER_0_83_299 VGND VGND VPWR VPWR sky130_fd_sc_hd__decap_8
XFILLER_0_83_277 VGND VGND VPWR VPWR sky130_fd_sc_hd__decap_3
X_11657_ _04905_ _05264_ VGND VGND VPWR VPWR _05446_ sky130_fd_sc_hd__nor2_2
XFILLER_0_9_18 VGND VGND VPWR VPWR sky130_fd_sc_hd__fill_2
X_14445_ _01584_ VGND VGND VPWR VPWR _01068_ sky130_fd_sc_hd__clkbuf_1
X_10608_ _03900_ _04815_ _03839_ VGND VGND VPWR VPWR _04816_ sky130_fd_sc_hd__a21o_1
X_11588_ _05409_ VGND VGND VPWR VPWR _00483_ sky130_fd_sc_hd__clkbuf_1
XFILLER_0_52_642 VGND VGND VPWR VPWR sky130_fd_sc_hd__fill_2
XFILLER_0_52_631 VGND VGND VPWR VPWR sky130_fd_sc_hd__fill_2
X_14376_ _04999_ net1226 _07616_ VGND VGND VPWR VPWR _01548_ sky130_fd_sc_hd__mux2_1
Xhold919 cpuregs\[18\]\[27\] VGND VGND VPWR VPWR net1277 sky130_fd_sc_hd__dlygate4sd3_1
Xhold908 cpuregs\[18\]\[23\] VGND VGND VPWR VPWR net1266 sky130_fd_sc_hd__dlygate4sd3_1
X_10539_ _03717_ _04728_ _04748_ VGND VGND VPWR VPWR _04749_ sky130_fd_sc_hd__o21a_1
X_13327_ _06535_ _06805_ _06809_ _06542_ VGND VGND VPWR VPWR _06810_ sky130_fd_sc_hd__o211a_1
X_16115_ clknet_leaf_0_clk _00765_ VGND VGND VPWR VPWR count_cycle\[58\] sky130_fd_sc_hd__dfxtp_1
X_16046_ clknet_leaf_32_clk _00696_ VGND VGND VPWR VPWR reg_next_pc\[21\] sky130_fd_sc_hd__dfxtp_1
X_13258_ _06638_ _06736_ _06738_ _06739_ _06742_ VGND VGND VPWR VPWR _06743_ sky130_fd_sc_hd__o311a_1
XFILLER_0_20_550 VGND VGND VPWR VPWR sky130_fd_sc_hd__fill_2
X_12209_ _05811_ net383 VGND VGND VPWR VPWR _05832_ sky130_fd_sc_hd__nand2_4
X_13189_ _06580_ _06675_ VGND VGND VPWR VPWR _06676_ sky130_fd_sc_hd__or2_1
X_07750_ cpu_state\[3\] VGND VGND VPWR VPWR _02169_ sky130_fd_sc_hd__inv_2
X_16948_ clknet_leaf_120_clk _01512_ VGND VGND VPWR VPWR cpuregs\[10\]\[3\] sky130_fd_sc_hd__dfxtp_1
X_16879_ clknet_leaf_57_clk _01443_ VGND VGND VPWR VPWR cpuregs\[22\]\[30\] sky130_fd_sc_hd__dfxtp_1
X_07681_ mem_do_rinst mem_do_prefetch VGND VGND VPWR VPWR _02110_ sky130_fd_sc_hd__or2_1
X_09420_ decoded_imm_j\[19\] _03655_ is_lui_auipc_jal VGND VGND VPWR VPWR _03656_
+ sky130_fd_sc_hd__o21ba_2
X_09351_ _03593_ _03594_ _03449_ _03595_ VGND VGND VPWR VPWR _03596_ sky130_fd_sc_hd__a2bb2o_2
XFILLER_0_35_95 VGND VGND VPWR VPWR sky130_fd_sc_hd__decap_3
X_09282_ reg_out\[14\] alu_out_q\[14\] _03436_ VGND VGND VPWR VPWR _03536_ sky130_fd_sc_hd__mux2_1
X_08302_ _02676_ _02679_ _02682_ VGND VGND VPWR VPWR _02683_ sky130_fd_sc_hd__and3_1
XFILLER_0_117_324 VPWR VGND VPWR VGND sky130_ef_sc_hd__decap_12
X_08233_ _02614_ _02617_ VGND VGND VPWR VPWR _02618_ sky130_fd_sc_hd__nand2_1
XFILLER_0_133_806 VPWR VGND VPWR VGND sky130_ef_sc_hd__decap_12
XFILLER_0_117_346 VGND VGND VPWR VPWR sky130_fd_sc_hd__decap_4
XFILLER_0_105_508 VGND VGND VPWR VPWR sky130_fd_sc_hd__decap_3
XFILLER_0_15_311 VGND VGND VPWR VPWR sky130_fd_sc_hd__fill_2
X_08164_ count_instr\[24\] _02270_ VGND VGND VPWR VPWR _02553_ sky130_fd_sc_hd__and2_1
X_08095_ _02487_ _02488_ VGND VGND VPWR VPWR _02489_ sky130_fd_sc_hd__nand2_1
XFILLER_0_42_141 VGND VGND VPWR VPWR sky130_fd_sc_hd__fill_2
XFILLER_0_100_213 VGND VGND VPWR VPWR sky130_fd_sc_hd__fill_1
XFILLER_0_3_783 VGND VGND VPWR VPWR sky130_fd_sc_hd__fill_1
XFILLER_0_11_561 VGND VGND VPWR VPWR sky130_fd_sc_hd__fill_1
X_08997_ _02653_ _03289_ _02111_ VGND VGND VPWR VPWR _03290_ sky130_fd_sc_hd__mux2_1
X_07948_ net202 VGND VGND VPWR VPWR _02352_ sky130_fd_sc_hd__clkbuf_4
X_07879_ count_instr\[5\] _02270_ count_cycle\[37\] _02204_ VGND VGND VPWR VPWR _02287_
+ sky130_fd_sc_hd__a22o_1
X_10890_ _03543_ VGND VGND VPWR VPWR _05016_ sky130_fd_sc_hd__clkbuf_4
X_09618_ _03851_ _02243_ _03715_ VGND VGND VPWR VPWR _03852_ sky130_fd_sc_hd__mux2_1
X_09549_ _03705_ _03782_ _03783_ VGND VGND VPWR VPWR _03784_ sky130_fd_sc_hd__o21a_1
XFILLER_0_65_211 VPWR VGND VPWR VGND sky130_ef_sc_hd__decap_12
XFILLER_0_136_611 VGND VGND VPWR VPWR sky130_fd_sc_hd__fill_2
X_12560_ count_cycle\[17\] net361 count_cycle\[18\] VGND VGND VPWR VPWR _06140_ sky130_fd_sc_hd__a21o_1
XFILLER_0_38_458 VGND VGND VPWR VPWR sky130_fd_sc_hd__fill_1
X_11511_ _05368_ VGND VGND VPWR VPWR _00447_ sky130_fd_sc_hd__clkbuf_1
X_12491_ _05791_ _06090_ VGND VGND VPWR VPWR _06091_ sky130_fd_sc_hd__and2_1
XFILLER_0_65_277 VGND VGND VPWR VPWR sky130_fd_sc_hd__decap_3
X_11442_ net1622 _05217_ _05324_ VGND VGND VPWR VPWR _05332_ sky130_fd_sc_hd__mux2_1
XFILLER_0_123_305 VGND VGND VPWR VPWR sky130_fd_sc_hd__fill_1
X_14230_ net513 net107 _07530_ VGND VGND VPWR VPWR _07540_ sky130_fd_sc_hd__mux2_1
X_14161_ _05041_ net1523 _07493_ VGND VGND VPWR VPWR _07501_ sky130_fd_sc_hd__mux2_1
XFILLER_0_135_198 VPWR VGND VPWR VGND sky130_ef_sc_hd__decap_12
X_11373_ _05295_ VGND VGND VPWR VPWR _00382_ sky130_fd_sc_hd__clkbuf_1
X_10324_ _04539_ _02509_ _04509_ VGND VGND VPWR VPWR _04540_ sky130_fd_sc_hd__mux2_1
X_13112_ cpuregs\[8\]\[10\] cpuregs\[9\]\[10\] _06422_ VGND VGND VPWR VPWR _06601_
+ sky130_fd_sc_hd__mux2_1
XFILLER_0_0_219 VGND VGND VPWR VPWR sky130_fd_sc_hd__fill_1
XFILLER_0_104_585 VGND VGND VPWR VPWR sky130_fd_sc_hd__decap_3
X_14092_ _07327_ net241 net243 VGND VGND VPWR VPWR _07464_ sky130_fd_sc_hd__a21oi_1
X_10255_ _04472_ VGND VGND VPWR VPWR _00087_ sky130_fd_sc_hd__clkbuf_1
XTAP_509 VGND VPWR sky130_fd_sc_hd__tapvpwrvgnd_1
X_13043_ _06534_ VGND VGND VPWR VPWR _00813_ sky130_fd_sc_hd__clkbuf_1
X_10186_ _04370_ _04373_ _04372_ VGND VGND VPWR VPWR _04405_ sky130_fd_sc_hd__a21boi_1
X_16802_ clknet_leaf_89_clk _01366_ VGND VGND VPWR VPWR cpuregs\[6\]\[17\] sky130_fd_sc_hd__dfxtp_1
X_14994_ _01875_ VGND VGND VPWR VPWR _01358_ sky130_fd_sc_hd__clkbuf_1
X_16733_ clknet_leaf_108_clk _01297_ VGND VGND VPWR VPWR cpuregs\[4\]\[12\] sky130_fd_sc_hd__dfxtp_1
X_13945_ _07332_ _07375_ VGND VGND VPWR VPWR _07376_ sky130_fd_sc_hd__and2_1
XFILLER_0_72_27 VGND VGND VPWR VPWR sky130_fd_sc_hd__fill_1
X_16664_ clknet_leaf_134_clk _01231_ VGND VGND VPWR VPWR cpuregs\[29\]\[10\] sky130_fd_sc_hd__dfxtp_1
X_13876_ _07327_ mem_rdata_q\[13\] mem_rdata_q\[12\] VGND VGND VPWR VPWR _07328_ sky130_fd_sc_hd__nor3_1
X_12827_ _06329_ VGND VGND VPWR VPWR _00802_ sky130_fd_sc_hd__clkbuf_1
XFILLER_0_9_809 VGND VGND VPWR VPWR sky130_fd_sc_hd__decap_8
X_15615_ clknet_leaf_131_clk _00265_ VGND VGND VPWR VPWR cpuregs\[31\]\[5\] sky130_fd_sc_hd__dfxtp_1
X_16595_ clknet_leaf_122_clk _01162_ VGND VGND VPWR VPWR cpuregs\[9\]\[5\] sky130_fd_sc_hd__dfxtp_1
XTAP_1292 VGND VPWR sky130_fd_sc_hd__tapvpwrvgnd_1
XTAP_1281 VGND VPWR sky130_fd_sc_hd__tapvpwrvgnd_1
XTAP_1270 VGND VPWR sky130_fd_sc_hd__tapvpwrvgnd_1
X_12758_ net96 net129 VGND VGND VPWR VPWR _06291_ sky130_fd_sc_hd__or2_1
X_15546_ clknet_leaf_119_clk _00196_ VGND VGND VPWR VPWR cpuregs\[2\]\[0\] sky130_fd_sc_hd__dfxtp_1
X_15477_ clknet_leaf_80_clk _00127_ VGND VGND VPWR VPWR cpuregs\[12\]\[27\] sky130_fd_sc_hd__dfxtp_1
X_11709_ net842 _05211_ _05469_ VGND VGND VPWR VPWR _05474_ sky130_fd_sc_hd__mux2_1
XFILLER_0_71_225 VGND VGND VPWR VPWR sky130_fd_sc_hd__decap_8
XFILLER_0_71_203 VGND VGND VPWR VPWR sky130_fd_sc_hd__decap_3
X_12689_ _06232_ VGND VGND VPWR VPWR _00761_ sky130_fd_sc_hd__clkbuf_1
XFILLER_0_115_3 VGND VGND VPWR VPWR sky130_fd_sc_hd__decap_4
X_14428_ _03444_ _05373_ VGND VGND VPWR VPWR _01575_ sky130_fd_sc_hd__nor2_2
XFILLER_0_40_612 VGND VGND VPWR VPWR sky130_fd_sc_hd__fill_2
Xhold727 cpuregs\[15\]\[25\] VGND VGND VPWR VPWR net1085 sky130_fd_sc_hd__dlygate4sd3_1
XFILLER_0_12_325 VGND VGND VPWR VPWR sky130_fd_sc_hd__decap_4
Xhold705 cpuregs\[5\]\[6\] VGND VGND VPWR VPWR net1063 sky130_fd_sc_hd__dlygate4sd3_1
Xhold716 cpuregs\[27\]\[7\] VGND VGND VPWR VPWR net1074 sky130_fd_sc_hd__dlygate4sd3_1
X_14359_ _07614_ VGND VGND VPWR VPWR _01028_ sky130_fd_sc_hd__clkbuf_1
Xhold738 cpuregs\[2\]\[21\] VGND VGND VPWR VPWR net1096 sky130_fd_sc_hd__dlygate4sd3_1
XFILLER_0_110_500 VGND VGND VPWR VPWR sky130_fd_sc_hd__fill_1
XFILLER_0_97_57 VGND VGND VPWR VPWR sky130_fd_sc_hd__fill_1
Xhold749 cpuregs\[2\]\[0\] VGND VGND VPWR VPWR net1107 sky130_fd_sc_hd__dlygate4sd3_1
XFILLER_0_40_678 VGND VGND VPWR VPWR sky130_fd_sc_hd__fill_2
X_08920_ reg_out\[7\] reg_next_pc\[7\] _03225_ VGND VGND VPWR VPWR _03237_ sky130_fd_sc_hd__mux2_1
X_16029_ clknet_leaf_10_clk _00679_ VGND VGND VPWR VPWR reg_next_pc\[4\] sky130_fd_sc_hd__dfxtp_1
X_08851_ _03198_ _03200_ VGND VGND VPWR VPWR _03201_ sky130_fd_sc_hd__xnor2_1
X_07802_ net171 VGND VGND VPWR VPWR _02215_ sky130_fd_sc_hd__inv_2
X_08782_ net220 _03137_ VGND VGND VPWR VPWR _03138_ sky130_fd_sc_hd__xnor2_2
XFILLER_0_79_314 VGND VGND VPWR VPWR sky130_fd_sc_hd__decap_6
X_07733_ _02153_ net384 VGND VGND VPWR VPWR _02154_ sky130_fd_sc_hd__nand2_4
XFILLER_0_46_83 VGND VGND VPWR VPWR sky130_fd_sc_hd__fill_1
X_07664_ instr_lb instr_lbu VGND VGND VPWR VPWR _02094_ sky130_fd_sc_hd__or2_1
X_09403_ _03640_ VGND VGND VPWR VPWR _03641_ sky130_fd_sc_hd__buf_2
XFILLER_0_118_600 VGND VGND VPWR VPWR sky130_fd_sc_hd__decap_3
X_09334_ reg_pc\[21\] _03573_ VGND VGND VPWR VPWR _03581_ sky130_fd_sc_hd__nand2_1
XFILLER_0_8_831 VGND VGND VPWR VPWR sky130_fd_sc_hd__fill_1
X_09265_ reg_out\[12\] alu_out_q\[12\] _03435_ VGND VGND VPWR VPWR _03521_ sky130_fd_sc_hd__mux2_1
XFILLER_0_117_165 VGND VGND VPWR VPWR sky130_fd_sc_hd__decap_3
X_08216_ _02586_ _02591_ _02601_ VGND VGND VPWR VPWR _02602_ sky130_fd_sc_hd__a21o_1
X_09196_ reg_pc\[3\] reg_pc\[2\] _03460_ VGND VGND VPWR VPWR _03461_ sky130_fd_sc_hd__o21a_1
XFILLER_0_16_642 VGND VGND VPWR VPWR sky130_fd_sc_hd__fill_2
X_08147_ count_instr\[22\] _02236_ count_cycle\[54\] _02237_ VGND VGND VPWR VPWR _02538_
+ sky130_fd_sc_hd__a22o_1
X_08078_ count_cycle\[18\] _02454_ _02471_ _02472_ VGND VGND VPWR VPWR _02473_ sky130_fd_sc_hd__a211o_4
X_10040_ _02352_ _02391_ _02468_ _02416_ _03847_ _03916_ VGND VGND VPWR VPWR _04263_
+ sky130_fd_sc_hd__mux4_1
Xhold32 instr_lhu VGND VGND VPWR VPWR net390 sky130_fd_sc_hd__dlygate4sd3_1
Xhold54 count_cycle\[58\] VGND VGND VPWR VPWR net412 sky130_fd_sc_hd__dlygate4sd3_1
Xhold43 count_cycle\[63\] VGND VGND VPWR VPWR net401 sky130_fd_sc_hd__dlygate4sd3_1
Xhold65 _00855_ VGND VGND VPWR VPWR net423 sky130_fd_sc_hd__dlygate4sd3_1
Xhold76 reg_next_pc\[21\] VGND VGND VPWR VPWR net434 sky130_fd_sc_hd__dlygate4sd3_1
Xhold98 cpuregs\[0\]\[17\] VGND VGND VPWR VPWR net456 sky130_fd_sc_hd__dlygate4sd3_1
Xhold87 reg_next_pc\[6\] VGND VGND VPWR VPWR net445 sky130_fd_sc_hd__dlygate4sd3_1
X_11991_ _05660_ _05661_ _05662_ VGND VGND VPWR VPWR _05663_ sky130_fd_sc_hd__and3b_1
X_13730_ _07200_ net223 _06960_ VGND VGND VPWR VPWR _07201_ sky130_fd_sc_hd__mux2_1
XFILLER_0_98_645 VGND VGND VPWR VPWR sky130_fd_sc_hd__fill_2
XFILLER_0_97_111 VGND VGND VPWR VPWR sky130_fd_sc_hd__fill_1
X_10942_ _04902_ _04900_ _04901_ _04944_ VGND VGND VPWR VPWR _05051_ sky130_fd_sc_hd__or4_4
XFILLER_0_128_419 VGND VGND VPWR VPWR sky130_fd_sc_hd__fill_1
X_13661_ _06348_ _07131_ _07133_ _06417_ VGND VGND VPWR VPWR _07134_ sky130_fd_sc_hd__a211o_1
X_15400_ clknet_leaf_84_clk _00055_ VGND VGND VPWR VPWR cpuregs\[11\]\[18\] sky130_fd_sc_hd__dfxtp_1
X_10873_ _05004_ VGND VGND VPWR VPWR _00173_ sky130_fd_sc_hd__clkbuf_1
XFILLER_0_42_19 VGND VGND VPWR VPWR sky130_fd_sc_hd__fill_1
X_16380_ clknet_leaf_29_clk _00962_ VGND VGND VPWR VPWR net164 sky130_fd_sc_hd__dfxtp_1
X_13592_ _06392_ _07066_ VGND VGND VPWR VPWR _07067_ sky130_fd_sc_hd__nand2_1
X_12612_ _06175_ _06176_ _05523_ VGND VGND VPWR VPWR _06177_ sky130_fd_sc_hd__and3b_1
X_15331_ _02040_ VGND VGND VPWR VPWR _02052_ sky130_fd_sc_hd__buf_4
X_12543_ net34 VGND VGND VPWR VPWR _06128_ sky130_fd_sc_hd__buf_2
X_15262_ _02016_ VGND VGND VPWR VPWR _01485_ sky130_fd_sc_hd__clkbuf_1
XFILLER_0_19_480 VGND VGND VPWR VPWR sky130_fd_sc_hd__fill_2
X_14213_ _07531_ VGND VGND VPWR VPWR _00965_ sky130_fd_sc_hd__clkbuf_1
X_12474_ _06059_ _06074_ VGND VGND VPWR VPWR _06075_ sky130_fd_sc_hd__nor2_1
XFILLER_0_53_269 VGND VGND VPWR VPWR sky130_fd_sc_hd__decap_8
XANTENNA_7 _03264_ VGND VGND VPWR VPWR sky130_fd_sc_hd__diode_2
X_11425_ net1194 _05200_ _05313_ VGND VGND VPWR VPWR _05323_ sky130_fd_sc_hd__mux2_1
XFILLER_0_21_100 VGND VGND VPWR VPWR sky130_fd_sc_hd__decap_4
XFILLER_0_21_111 VGND VGND VPWR VPWR sky130_fd_sc_hd__fill_1
XFILLER_0_22_612 VGND VGND VPWR VPWR sky130_fd_sc_hd__fill_2
XFILLER_0_22_645 VGND VGND VPWR VPWR sky130_fd_sc_hd__fill_2
X_15193_ _03491_ net1028 _01973_ VGND VGND VPWR VPWR _01981_ sky130_fd_sc_hd__mux2_1
XFILLER_0_120_831 VGND VGND VPWR VPWR sky130_fd_sc_hd__fill_1
X_11356_ _05286_ VGND VGND VPWR VPWR _00374_ sky130_fd_sc_hd__clkbuf_1
X_14144_ _05024_ net1325 _07482_ VGND VGND VPWR VPWR _07492_ sky130_fd_sc_hd__mux2_1
X_10307_ _03878_ _04520_ _04522_ VGND VGND VPWR VPWR _04523_ sky130_fd_sc_hd__a21o_1
X_14075_ decoded_imm_j\[18\] _01111_ _03295_ VGND VGND VPWR VPWR _07454_ sky130_fd_sc_hd__mux2_1
XTAP_306 VGND VPWR sky130_fd_sc_hd__tapvpwrvgnd_1
XFILLER_0_21_166 VGND VGND VPWR VPWR sky130_fd_sc_hd__fill_2
XFILLER_0_21_177 VGND VGND VPWR VPWR sky130_fd_sc_hd__fill_1
X_11287_ _05249_ VGND VGND VPWR VPWR _00342_ sky130_fd_sc_hd__clkbuf_1
XTAP_339 VGND VPWR sky130_fd_sc_hd__tapvpwrvgnd_1
XTAP_317 VGND VPWR sky130_fd_sc_hd__tapvpwrvgnd_1
XTAP_328 VGND VPWR sky130_fd_sc_hd__tapvpwrvgnd_1
X_13026_ _03318_ VGND VGND VPWR VPWR _06518_ sky130_fd_sc_hd__clkbuf_4
X_10238_ _03739_ _04451_ _04455_ _03873_ VGND VGND VPWR VPWR _04456_ sky130_fd_sc_hd__o211a_1
X_10169_ _03979_ _04388_ _03731_ VGND VGND VPWR VPWR _04389_ sky130_fd_sc_hd__a21o_1
XFILLER_0_89_601 VGND VGND VPWR VPWR sky130_fd_sc_hd__fill_1
X_14977_ _03451_ net953 _01865_ VGND VGND VPWR VPWR _01867_ sky130_fd_sc_hd__mux2_1
X_16716_ clknet_leaf_93_clk _01283_ VGND VGND VPWR VPWR cpuregs\[3\]\[30\] sky130_fd_sc_hd__dfxtp_1
Xrebuffer19 _05628_ VGND VGND VPWR VPWR net377 sky130_fd_sc_hd__clkbuf_1
X_13928_ is_alu_reg_imm _07326_ VGND VGND VPWR VPWR _07363_ sky130_fd_sc_hd__and2_1
XFILLER_0_107_99 VGND VGND VPWR VPWR sky130_fd_sc_hd__fill_2
X_16647_ clknet_leaf_63_clk _01214_ VGND VGND VPWR VPWR cpuregs\[23\]\[25\] sky130_fd_sc_hd__dfxtp_1
X_13859_ net29 _02089_ VGND VGND VPWR VPWR _07315_ sky130_fd_sc_hd__or2b_1
X_16578_ clknet_leaf_58_clk _01155_ VGND VGND VPWR VPWR cpuregs\[24\]\[30\] sky130_fd_sc_hd__dfxtp_1
XFILLER_0_69_391 VGND VGND VPWR VPWR sky130_fd_sc_hd__fill_1
XFILLER_0_29_244 VPWR VGND VPWR VGND sky130_ef_sc_hd__decap_12
X_15529_ clknet_leaf_91_clk _00179_ VGND VGND VPWR VPWR cpuregs\[13\]\[15\] sky130_fd_sc_hd__dfxtp_1
XFILLER_0_72_512 VGND VGND VPWR VPWR sky130_fd_sc_hd__decap_4
XFILLER_0_45_726 VGND VGND VPWR VPWR sky130_fd_sc_hd__fill_2
XFILLER_0_8_149 VGND VGND VPWR VPWR sky130_fd_sc_hd__decap_3
XFILLER_0_8_138 VGND VGND VPWR VPWR sky130_fd_sc_hd__fill_2
XFILLER_0_127_452 VGND VGND VPWR VPWR sky130_fd_sc_hd__decap_6
XFILLER_0_96_7 VGND VGND VPWR VPWR sky130_fd_sc_hd__fill_2
XFILLER_0_44_225 VGND VGND VPWR VPWR sky130_fd_sc_hd__fill_1
X_09050_ cpuregs\[12\]\[2\] cpuregs\[13\]\[2\] cpuregs\[14\]\[2\] cpuregs\[15\]\[2\]
+ _03329_ _03330_ VGND VGND VPWR VPWR _03331_ sky130_fd_sc_hd__mux4_1
X_08001_ _02384_ _02387_ _02386_ VGND VGND VPWR VPWR _02401_ sky130_fd_sc_hd__o21ai_1
XFILLER_0_114_168 VGND VGND VPWR VPWR sky130_fd_sc_hd__fill_1
XFILLER_0_114_157 VGND VGND VPWR VPWR sky130_fd_sc_hd__fill_2
Xhold502 _01011_ VGND VGND VPWR VPWR net860 sky130_fd_sc_hd__dlygate4sd3_1
XFILLER_0_111_831 VGND VGND VPWR VPWR sky130_fd_sc_hd__fill_1
Xhold524 cpuregs\[8\]\[19\] VGND VGND VPWR VPWR net882 sky130_fd_sc_hd__dlygate4sd3_1
Xhold535 cpuregs\[3\]\[17\] VGND VGND VPWR VPWR net893 sky130_fd_sc_hd__dlygate4sd3_1
Xhold513 cpuregs\[3\]\[2\] VGND VGND VPWR VPWR net871 sky130_fd_sc_hd__dlygate4sd3_1
Xhold557 cpuregs\[2\]\[15\] VGND VGND VPWR VPWR net915 sky130_fd_sc_hd__dlygate4sd3_1
Xhold568 cpuregs\[28\]\[18\] VGND VGND VPWR VPWR net926 sky130_fd_sc_hd__dlygate4sd3_1
Xhold579 cpuregs\[28\]\[17\] VGND VGND VPWR VPWR net937 sky130_fd_sc_hd__dlygate4sd3_1
Xhold546 cpuregs\[30\]\[11\] VGND VGND VPWR VPWR net904 sky130_fd_sc_hd__dlygate4sd3_1
X_09952_ cpuregs\[24\]\[10\] cpuregs\[25\]\[10\] cpuregs\[26\]\[10\] cpuregs\[27\]\[10\]
+ _03935_ _03936_ VGND VGND VPWR VPWR _04178_ sky130_fd_sc_hd__mux4_1
X_08903_ _03224_ VGND VGND VPWR VPWR _03225_ sky130_fd_sc_hd__buf_4
X_09883_ decoded_imm\[9\] net202 VGND VGND VPWR VPWR _04110_ sky130_fd_sc_hd__or2_1
XTAP_840 VGND VPWR sky130_fd_sc_hd__tapvpwrvgnd_1
XTAP_851 VGND VPWR sky130_fd_sc_hd__tapvpwrvgnd_1
XTAP_862 VGND VPWR sky130_fd_sc_hd__tapvpwrvgnd_1
X_08834_ _02736_ _03177_ _03185_ _02867_ VGND VGND VPWR VPWR alu_out\[29\] sky130_fd_sc_hd__a22o_1
Xhold1213 cpuregs\[9\]\[13\] VGND VGND VPWR VPWR net1571 sky130_fd_sc_hd__dlygate4sd3_1
Xhold1224 cpuregs\[22\]\[1\] VGND VGND VPWR VPWR net1582 sky130_fd_sc_hd__dlygate4sd3_1
Xhold1202 cpuregs\[21\]\[1\] VGND VGND VPWR VPWR net1560 sky130_fd_sc_hd__dlygate4sd3_1
XTAP_884 VGND VPWR sky130_fd_sc_hd__tapvpwrvgnd_1
XTAP_873 VGND VPWR sky130_fd_sc_hd__tapvpwrvgnd_1
XTAP_895 VGND VPWR sky130_fd_sc_hd__tapvpwrvgnd_1
Xhold1246 cpuregs\[13\]\[27\] VGND VGND VPWR VPWR net1604 sky130_fd_sc_hd__dlygate4sd3_1
X_08765_ _03073_ VGND VGND VPWR VPWR _03122_ sky130_fd_sc_hd__inv_2
XFILLER_0_79_100 VGND VGND VPWR VPWR sky130_fd_sc_hd__decap_4
Xhold1235 decoded_imm\[20\] VGND VGND VPWR VPWR net1593 sky130_fd_sc_hd__dlygate4sd3_1
Xhold1257 cpuregs\[7\]\[13\] VGND VGND VPWR VPWR net1615 sky130_fd_sc_hd__dlygate4sd3_1
Xhold1268 cpuregs\[29\]\[26\] VGND VGND VPWR VPWR net1626 sky130_fd_sc_hd__dlygate4sd3_1
Xhold1279 cpuregs\[9\]\[27\] VGND VGND VPWR VPWR net1637 sky130_fd_sc_hd__dlygate4sd3_1
X_07716_ _02141_ VGND VGND VPWR VPWR _02142_ sky130_fd_sc_hd__clkbuf_4
X_08696_ net180 _03043_ VGND VGND VPWR VPWR _03058_ sky130_fd_sc_hd__nand2_1
XFILLER_0_95_615 VGND VGND VPWR VPWR sky130_fd_sc_hd__fill_1
XFILLER_0_138_739 VGND VGND VPWR VPWR sky130_fd_sc_hd__fill_1
XFILLER_0_94_169 VGND VGND VPWR VPWR sky130_fd_sc_hd__decap_8
XFILLER_0_137_238 VPWR VGND VPWR VGND sky130_ef_sc_hd__decap_12
X_09317_ reg_out\[19\] alu_out_q\[19\] _03436_ VGND VGND VPWR VPWR _03566_ sky130_fd_sc_hd__mux2_1
XFILLER_0_35_225 VGND VGND VPWR VPWR sky130_fd_sc_hd__decap_3
XFILLER_0_133_433 VGND VGND VPWR VPWR sky130_fd_sc_hd__fill_1
XFILLER_0_105_113 VGND VGND VPWR VPWR sky130_fd_sc_hd__decap_3
X_09248_ reg_out\[10\] alu_out_q\[10\] _03435_ VGND VGND VPWR VPWR _03506_ sky130_fd_sc_hd__mux2_1
XFILLER_0_8_694 VGND VGND VPWR VPWR sky130_fd_sc_hd__decap_6
XFILLER_0_7_160 VGND VGND VPWR VPWR sky130_fd_sc_hd__decap_8
X_09179_ net1234 _03440_ _03446_ VGND VGND VPWR VPWR _03447_ sky130_fd_sc_hd__mux2_1
Xclkbuf_4_10_0_clk clknet_0_clk VGND VGND VPWR VPWR clknet_4_10_0_clk sky130_fd_sc_hd__clkbuf_8
X_11210_ _05160_ VGND VGND VPWR VPWR _05203_ sky130_fd_sc_hd__buf_4
X_12190_ _05804_ _05814_ _05695_ VGND VGND VPWR VPWR _05815_ sky130_fd_sc_hd__o21ai_1
X_11141_ _05156_ VGND VGND VPWR VPWR _00289_ sky130_fd_sc_hd__clkbuf_1
Xoutput66 net66 VGND VGND VPWR VPWR mem_la_addr[10] sky130_fd_sc_hd__buf_2
Xoutput44 net44 VGND VGND VPWR VPWR mem_addr[19] sky130_fd_sc_hd__clkbuf_4
Xoutput55 net55 VGND VGND VPWR VPWR mem_addr[2] sky130_fd_sc_hd__clkbuf_4
Xoutput99 net99 VGND VGND VPWR VPWR mem_la_wdata[11] sky130_fd_sc_hd__clkbuf_4
Xoutput77 net77 VGND VGND VPWR VPWR mem_la_addr[21] sky130_fd_sc_hd__clkbuf_4
X_11072_ net600 _03635_ _05110_ VGND VGND VPWR VPWR _05120_ sky130_fd_sc_hd__mux2_1
Xoutput88 net88 VGND VGND VPWR VPWR mem_la_addr[31] sky130_fd_sc_hd__clkbuf_4
X_14900_ _01825_ VGND VGND VPWR VPWR _01314_ sky130_fd_sc_hd__clkbuf_1
X_15880_ clknet_leaf_136_clk _00530_ VGND VGND VPWR VPWR cpuregs\[20\]\[14\] sky130_fd_sc_hd__dfxtp_1
X_10023_ _03747_ _04240_ _04246_ VGND VGND VPWR VPWR _04247_ sky130_fd_sc_hd__or3_4
X_14831_ _01788_ VGND VGND VPWR VPWR _01282_ sky130_fd_sc_hd__clkbuf_1
X_16501_ clknet_leaf_46_clk _01083_ VGND VGND VPWR VPWR cpuregs\[19\]\[22\] sky130_fd_sc_hd__dfxtp_1
X_14762_ _05045_ net1444 _01742_ VGND VGND VPWR VPWR _01752_ sky130_fd_sc_hd__mux2_1
X_11974_ _05650_ VGND VGND VPWR VPWR _00628_ sky130_fd_sc_hd__clkbuf_1
X_13713_ _06911_ _07183_ VGND VGND VPWR VPWR _07184_ sky130_fd_sc_hd__or2_1
X_14693_ _01715_ VGND VGND VPWR VPWR _01217_ sky130_fd_sc_hd__clkbuf_1
X_10925_ _05039_ net1273 _05027_ VGND VGND VPWR VPWR _05040_ sky130_fd_sc_hd__mux2_1
X_13644_ cpuregs\[10\]\[26\] cpuregs\[11\]\[26\] _03347_ VGND VGND VPWR VPWR _07117_
+ sky130_fd_sc_hd__mux2_1
X_16432_ clknet_leaf_23_clk net1618 VGND VGND VPWR VPWR decoded_imm\[15\] sky130_fd_sc_hd__dfxtp_2
X_10856_ _03471_ VGND VGND VPWR VPWR _04993_ sky130_fd_sc_hd__buf_2
X_16363_ clknet_leaf_72_clk _00945_ VGND VGND VPWR VPWR cpuregs\[1\]\[28\] sky130_fd_sc_hd__dfxtp_1
XFILLER_0_85_169 VGND VGND VPWR VPWR sky130_fd_sc_hd__decap_4
XPHY_161 VGND VGND VPWR VPWR sky130_fd_sc_hd__decap_3
XPHY_150 VGND VGND VPWR VPWR sky130_fd_sc_hd__decap_3
XFILLER_0_137_783 VGND VGND VPWR VPWR sky130_fd_sc_hd__fill_1
XFILLER_0_136_260 VPWR VGND VPWR VGND sky130_ef_sc_hd__decap_12
X_13575_ _06794_ _07050_ VGND VGND VPWR VPWR _07051_ sky130_fd_sc_hd__and2_1
XPHY_194 VGND VGND VPWR VPWR sky130_fd_sc_hd__decap_3
XPHY_183 VGND VGND VPWR VPWR sky130_fd_sc_hd__decap_3
XPHY_172 VGND VGND VPWR VPWR sky130_fd_sc_hd__decap_3
XFILLER_0_66_383 VGND VGND VPWR VPWR sky130_fd_sc_hd__fill_2
X_15314_ _02043_ VGND VGND VPWR VPWR _01510_ sky130_fd_sc_hd__clkbuf_1
X_10787_ _04953_ VGND VGND VPWR VPWR _00138_ sky130_fd_sc_hd__clkbuf_1
XFILLER_0_54_589 VGND VGND VPWR VPWR sky130_fd_sc_hd__decap_3
X_12526_ _06114_ _05661_ _06115_ VGND VGND VPWR VPWR _06116_ sky130_fd_sc_hd__and3b_1
X_16294_ clknet_leaf_149_clk _00879_ VGND VGND VPWR VPWR instr_and sky130_fd_sc_hd__dfxtp_1
XFILLER_0_124_466 VGND VGND VPWR VPWR sky130_fd_sc_hd__decap_4
X_12457_ _06058_ _06059_ VGND VGND VPWR VPWR _06060_ sky130_fd_sc_hd__nand2_1
X_15245_ net524 VGND VGND VPWR VPWR _02008_ sky130_fd_sc_hd__clkbuf_1
X_15176_ _01971_ VGND VGND VPWR VPWR _01444_ sky130_fd_sc_hd__clkbuf_1
X_11408_ _05314_ VGND VGND VPWR VPWR _00398_ sky130_fd_sc_hd__clkbuf_1
XFILLER_0_34_291 VPWR VGND VPWR VGND sky130_ef_sc_hd__decap_12
X_12388_ _05995_ _05989_ VGND VGND VPWR VPWR _05997_ sky130_fd_sc_hd__and2b_1
XFILLER_0_22_475 VGND VGND VPWR VPWR sky130_fd_sc_hd__fill_1
X_14127_ _07483_ VGND VGND VPWR VPWR _00927_ sky130_fd_sc_hd__clkbuf_1
X_11339_ _05005_ net1540 _05277_ VGND VGND VPWR VPWR _05278_ sky130_fd_sc_hd__mux2_1
X_14058_ net618 VGND VGND VPWR VPWR _01102_ sky130_fd_sc_hd__clkbuf_1
X_13009_ _06501_ VGND VGND VPWR VPWR _00812_ sky130_fd_sc_hd__clkbuf_1
XFILLER_0_118_98 VGND VGND VPWR VPWR sky130_fd_sc_hd__decap_4
XFILLER_0_77_615 VGND VGND VPWR VPWR sky130_fd_sc_hd__fill_1
X_08550_ net249 _02923_ VGND VGND VPWR VPWR _02924_ sky130_fd_sc_hd__xnor2_1
XFILLER_0_134_53 VPWR VGND VPWR VGND sky130_ef_sc_hd__decap_12
XFILLER_0_77_626 VGND VGND VPWR VPWR sky130_fd_sc_hd__decap_3
XFILLER_0_76_103 VGND VGND VPWR VPWR sky130_fd_sc_hd__decap_4
X_08481_ net97 net108 instr_sub VGND VGND VPWR VPWR _02860_ sky130_fd_sc_hd__o21ba_1
XFILLER_0_134_97 VPWR VGND VPWR VGND sky130_ef_sc_hd__decap_12
XFILLER_0_92_629 VGND VGND VPWR VPWR sky130_fd_sc_hd__fill_1
XFILLER_0_85_670 VGND VGND VPWR VPWR sky130_fd_sc_hd__fill_2
XFILLER_0_64_309 VGND VGND VPWR VPWR sky130_fd_sc_hd__decap_4
XFILLER_0_134_208 VGND VGND VPWR VPWR sky130_fd_sc_hd__fill_2
XFILLER_0_72_331 VGND VGND VPWR VPWR sky130_fd_sc_hd__decap_4
X_09102_ _03346_ _03381_ _03310_ VGND VGND VPWR VPWR _03382_ sky130_fd_sc_hd__a21o_1
X_09033_ _00008_ VGND VGND VPWR VPWR _03314_ sky130_fd_sc_hd__clkbuf_8
XFILLER_0_4_141 VGND VGND VPWR VPWR sky130_fd_sc_hd__decap_4
XFILLER_0_32_228 VGND VGND VPWR VPWR sky130_fd_sc_hd__decap_3
XFILLER_0_4_185 VGND VGND VPWR VPWR sky130_fd_sc_hd__fill_2
Xhold310 cpuregs\[30\]\[9\] VGND VGND VPWR VPWR net668 sky130_fd_sc_hd__dlygate4sd3_1
Xhold343 cpuregs\[7\]\[27\] VGND VGND VPWR VPWR net701 sky130_fd_sc_hd__dlygate4sd3_1
XFILLER_0_102_138 VGND VGND VPWR VPWR sky130_fd_sc_hd__fill_2
Xhold321 cpuregs\[26\]\[31\] VGND VGND VPWR VPWR net679 sky130_fd_sc_hd__dlygate4sd3_1
XFILLER_0_13_475 VGND VGND VPWR VPWR sky130_fd_sc_hd__fill_1
Xhold332 cpuregs\[25\]\[5\] VGND VGND VPWR VPWR net690 sky130_fd_sc_hd__dlygate4sd3_1
Xhold387 cpuregs\[6\]\[30\] VGND VGND VPWR VPWR net745 sky130_fd_sc_hd__dlygate4sd3_1
Xhold365 cpuregs\[14\]\[13\] VGND VGND VPWR VPWR net723 sky130_fd_sc_hd__dlygate4sd3_1
Xhold376 cpuregs\[7\]\[12\] VGND VGND VPWR VPWR net734 sky130_fd_sc_hd__dlygate4sd3_1
Xhold354 cpuregs\[28\]\[6\] VGND VGND VPWR VPWR net712 sky130_fd_sc_hd__dlygate4sd3_1
Xhold398 cpuregs\[19\]\[21\] VGND VGND VPWR VPWR net756 sky130_fd_sc_hd__dlygate4sd3_1
X_09935_ _03364_ _04160_ VGND VGND VPWR VPWR _04161_ sky130_fd_sc_hd__or2_1
XTAP_670 VGND VPWR sky130_fd_sc_hd__tapvpwrvgnd_1
X_09866_ _03979_ _04093_ _04020_ VGND VGND VPWR VPWR _04094_ sky130_fd_sc_hd__a21o_1
Xhold1021 cpuregs\[1\]\[25\] VGND VGND VPWR VPWR net1379 sky130_fd_sc_hd__dlygate4sd3_1
X_08817_ _02934_ _03169_ VGND VGND VPWR VPWR _03170_ sky130_fd_sc_hd__and2_1
Xhold1032 cpuregs\[13\]\[15\] VGND VGND VPWR VPWR net1390 sky130_fd_sc_hd__dlygate4sd3_1
Xhold1010 cpuregs\[30\]\[0\] VGND VGND VPWR VPWR net1368 sky130_fd_sc_hd__dlygate4sd3_1
XTAP_692 VGND VPWR sky130_fd_sc_hd__tapvpwrvgnd_1
XTAP_681 VGND VPWR sky130_fd_sc_hd__tapvpwrvgnd_1
Xhold1054 decoded_imm\[16\] VGND VGND VPWR VPWR net1412 sky130_fd_sc_hd__dlygate4sd3_1
Xhold1065 cpuregs\[25\]\[15\] VGND VGND VPWR VPWR net1423 sky130_fd_sc_hd__dlygate4sd3_1
Xhold1043 cpuregs\[9\]\[11\] VGND VGND VPWR VPWR net1401 sky130_fd_sc_hd__dlygate4sd3_1
X_09797_ cpuregs\[20\]\[6\] cpuregs\[21\]\[6\] cpuregs\[22\]\[6\] cpuregs\[23\]\[6\]
+ _03938_ _03939_ VGND VGND VPWR VPWR _04027_ sky130_fd_sc_hd__mux4_1
Xhold1076 cpuregs\[18\]\[5\] VGND VGND VPWR VPWR net1434 sky130_fd_sc_hd__dlygate4sd3_1
X_08748_ _03088_ _03097_ _03104_ VGND VGND VPWR VPWR _03106_ sky130_fd_sc_hd__and3_1
Xhold1098 cpuregs\[1\]\[17\] VGND VGND VPWR VPWR net1456 sky130_fd_sc_hd__dlygate4sd3_1
Xhold1087 cpuregs\[5\]\[10\] VGND VGND VPWR VPWR net1445 sky130_fd_sc_hd__dlygate4sd3_1
X_08679_ net211 _02716_ _03022_ _02922_ VGND VGND VPWR VPWR _03042_ sky130_fd_sc_hd__o31a_1
XTAP_1825 VGND VPWR sky130_fd_sc_hd__tapvpwrvgnd_1
XTAP_1814 VGND VPWR sky130_fd_sc_hd__tapvpwrvgnd_1
XTAP_1803 VGND VPWR sky130_fd_sc_hd__tapvpwrvgnd_1
XFILLER_0_68_648 VGND VGND VPWR VPWR sky130_fd_sc_hd__fill_1
XFILLER_0_138_514 VGND VGND VPWR VPWR sky130_fd_sc_hd__decap_4
XTAP_1858 VGND VPWR sky130_fd_sc_hd__tapvpwrvgnd_1
XTAP_1847 VGND VPWR sky130_fd_sc_hd__tapvpwrvgnd_1
XTAP_1836 VGND VPWR sky130_fd_sc_hd__tapvpwrvgnd_1
X_10710_ _04911_ VGND VGND VPWR VPWR _00103_ sky130_fd_sc_hd__clkbuf_1
XTAP_1869 VGND VPWR sky130_fd_sc_hd__tapvpwrvgnd_1
X_11690_ net1257 _05192_ _05458_ VGND VGND VPWR VPWR _05464_ sky130_fd_sc_hd__mux2_1
X_10641_ _03823_ _04847_ _00014_ VGND VGND VPWR VPWR _04848_ sky130_fd_sc_hd__a21o_1
XFILLER_0_119_783 VGND VGND VPWR VPWR sky130_fd_sc_hd__fill_1
XFILLER_0_63_320 VGND VGND VPWR VPWR sky130_fd_sc_hd__fill_2
X_13360_ _06510_ VGND VGND VPWR VPWR _06842_ sky130_fd_sc_hd__buf_4
X_10572_ _03818_ _04776_ _04780_ _03806_ VGND VGND VPWR VPWR _04781_ sky130_fd_sc_hd__o211a_1
X_12311_ _05899_ _05925_ _05915_ VGND VGND VPWR VPWR _05926_ sky130_fd_sc_hd__o21a_1
X_13291_ _06773_ _06774_ VGND VGND VPWR VPWR _06775_ sky130_fd_sc_hd__and2_1
X_15030_ _01894_ VGND VGND VPWR VPWR _01375_ sky130_fd_sc_hd__clkbuf_1
XFILLER_0_106_477 VPWR VGND VPWR VGND sky130_ef_sc_hd__decap_12
XFILLER_0_90_194 VGND VGND VPWR VPWR sky130_fd_sc_hd__fill_2
X_12242_ _02153_ _05862_ _05773_ VGND VGND VPWR VPWR _05863_ sky130_fd_sc_hd__a21o_1
XFILLER_0_51_559 VGND VGND VPWR VPWR sky130_fd_sc_hd__fill_1
X_12173_ _05700_ _05787_ instr_jal VGND VGND VPWR VPWR _05799_ sky130_fd_sc_hd__a21oi_1
X_11124_ net1132 _03584_ _05146_ VGND VGND VPWR VPWR _05148_ sky130_fd_sc_hd__mux2_1
X_11055_ _05111_ VGND VGND VPWR VPWR _00248_ sky130_fd_sc_hd__clkbuf_1
X_15932_ clknet_leaf_3_clk _00582_ VGND VGND VPWR VPWR count_instr\[1\] sky130_fd_sc_hd__dfxtp_1
X_10006_ _04187_ _04228_ _04227_ VGND VGND VPWR VPWR _04230_ sky130_fd_sc_hd__a21o_1
X_15863_ clknet_leaf_64_clk _00513_ VGND VGND VPWR VPWR cpuregs\[25\]\[29\] sky130_fd_sc_hd__dfxtp_1
X_14814_ net818 _05205_ _01778_ VGND VGND VPWR VPWR _01780_ sky130_fd_sc_hd__mux2_1
X_15794_ clknet_leaf_62_clk _00444_ VGND VGND VPWR VPWR cpuregs\[26\]\[24\] sky130_fd_sc_hd__dfxtp_1
X_14745_ _01743_ VGND VGND VPWR VPWR _01241_ sky130_fd_sc_hd__clkbuf_1
XFILLER_0_98_272 VGND VGND VPWR VPWR sky130_fd_sc_hd__decap_3
X_11957_ count_instr\[43\] _05634_ VGND VGND VPWR VPWR _05638_ sky130_fd_sc_hd__or2_1
XFILLER_0_129_503 VGND VGND VPWR VPWR sky130_fd_sc_hd__fill_1
X_10908_ _05028_ VGND VGND VPWR VPWR _00184_ sky130_fd_sc_hd__clkbuf_1
XFILLER_0_80_27 VGND VGND VPWR VPWR sky130_fd_sc_hd__fill_1
XFILLER_0_58_125 VGND VGND VPWR VPWR sky130_fd_sc_hd__fill_2
XFILLER_0_129_547 VGND VGND VPWR VPWR sky130_fd_sc_hd__fill_2
X_14676_ net1330 _05202_ _01706_ VGND VGND VPWR VPWR _01707_ sky130_fd_sc_hd__mux2_1
XFILLER_0_46_309 VGND VGND VPWR VPWR sky130_fd_sc_hd__decap_4
X_11888_ net427 _05585_ _05533_ VGND VGND VPWR VPWR _05588_ sky130_fd_sc_hd__o21ai_1
X_16415_ clknet_leaf_140_clk _00997_ VGND VGND VPWR VPWR reg_sh\[1\] sky130_fd_sc_hd__dfxtp_1
X_13627_ _06849_ _07100_ VGND VGND VPWR VPWR _07101_ sky130_fd_sc_hd__or2_1
X_10839_ _04980_ VGND VGND VPWR VPWR _00163_ sky130_fd_sc_hd__clkbuf_1
X_13558_ cpuregs\[4\]\[23\] cpuregs\[5\]\[23\] _06906_ VGND VGND VPWR VPWR _07034_
+ sky130_fd_sc_hd__mux2_1
X_16346_ clknet_leaf_101_clk _00928_ VGND VGND VPWR VPWR cpuregs\[1\]\[11\] sky130_fd_sc_hd__dfxtp_1
XFILLER_0_14_228 VGND VGND VPWR VPWR sky130_fd_sc_hd__decap_6
X_12509_ count_cycle\[0\] count_cycle\[1\] count_cycle\[2\] count_cycle\[3\] VGND
+ VGND VPWR VPWR _06104_ sky130_fd_sc_hd__and4_2
X_16277_ clknet_leaf_141_clk _00862_ VGND VGND VPWR VPWR instr_slti sky130_fd_sc_hd__dfxtp_1
X_15228_ _01999_ VGND VGND VPWR VPWR _01468_ sky130_fd_sc_hd__clkbuf_1
X_13489_ _06868_ _06964_ _06966_ VGND VGND VPWR VPWR _06967_ sky130_fd_sc_hd__a21o_1
XFILLER_0_81_194 VGND VGND VPWR VPWR sky130_fd_sc_hd__decap_4
XFILLER_0_10_401 VGND VGND VPWR VPWR sky130_fd_sc_hd__fill_1
X_15159_ net823 _03596_ _01959_ VGND VGND VPWR VPWR _01963_ sky130_fd_sc_hd__mux2_1
XFILLER_0_1_166 VGND VGND VPWR VPWR sky130_fd_sc_hd__fill_2
X_07981_ _02372_ _02382_ VGND VGND VPWR VPWR _07620_ sky130_fd_sc_hd__nor2_1
X_09720_ _02213_ _02352_ _03651_ VGND VGND VPWR VPWR _03951_ sky130_fd_sc_hd__mux2_1
X_09651_ _03878_ _03879_ _03883_ VGND VGND VPWR VPWR _03884_ sky130_fd_sc_hd__a21o_1
X_08602_ net205 net247 net248 net233 VGND VGND VPWR VPWR _02971_ sky130_fd_sc_hd__or4_1
X_09582_ _03795_ _03807_ _03815_ VGND VGND VPWR VPWR _03816_ sky130_fd_sc_hd__or3_2
X_08533_ _02884_ _02907_ _02850_ VGND VGND VPWR VPWR _02908_ sky130_fd_sc_hd__o21a_1
XFILLER_0_49_169 VGND VGND VPWR VPWR sky130_fd_sc_hd__decap_4
X_08464_ instr_xor instr_xori VGND VGND VPWR VPWR _02845_ sky130_fd_sc_hd__or2_2
X_08395_ _02706_ _02775_ VGND VGND VPWR VPWR _02776_ sky130_fd_sc_hd__or2_1
XFILLER_0_57_180 VGND VGND VPWR VPWR sky130_fd_sc_hd__decap_4
XFILLER_0_45_353 VGND VGND VPWR VPWR sky130_fd_sc_hd__fill_2
X_09016_ mem_rdata_q\[18\] net10 _03292_ VGND VGND VPWR VPWR _03302_ sky130_fd_sc_hd__mux2_1
XFILLER_0_14_740 VGND VGND VPWR VPWR sky130_fd_sc_hd__fill_2
XFILLER_0_131_767 VGND VGND VPWR VPWR sky130_fd_sc_hd__fill_1
XFILLER_0_103_447 VGND VGND VPWR VPWR sky130_fd_sc_hd__fill_1
Xhold151 cpuregs\[0\]\[14\] VGND VGND VPWR VPWR net509 sky130_fd_sc_hd__dlygate4sd3_1
Xhold140 count_cycle\[15\] VGND VGND VPWR VPWR net498 sky130_fd_sc_hd__buf_1
Xhold162 net51 VGND VGND VPWR VPWR net520 sky130_fd_sc_hd__dlygate4sd3_1
Xhold184 net54 VGND VGND VPWR VPWR net542 sky130_fd_sc_hd__dlygate4sd3_1
Xhold173 count_instr\[10\] VGND VGND VPWR VPWR net531 sky130_fd_sc_hd__dlygate4sd3_1
Xhold195 count_instr\[60\] VGND VGND VPWR VPWR net553 sky130_fd_sc_hd__dlygate4sd3_1
X_09918_ _03738_ _04140_ _04144_ _03806_ VGND VGND VPWR VPWR _04145_ sky130_fd_sc_hd__o211a_1
X_09849_ _04068_ _04072_ _04069_ VGND VGND VPWR VPWR _04077_ sky130_fd_sc_hd__a21boi_2
XTAP_2301 VGND VPWR sky130_fd_sc_hd__tapvpwrvgnd_1
X_12860_ _06351_ _06356_ _06358_ VGND VGND VPWR VPWR _06359_ sky130_fd_sc_hd__a21o_1
XTAP_2334 VGND VPWR sky130_fd_sc_hd__tapvpwrvgnd_1
XTAP_2323 VGND VPWR sky130_fd_sc_hd__tapvpwrvgnd_1
XTAP_2312 VGND VPWR sky130_fd_sc_hd__tapvpwrvgnd_1
XTAP_1600 VGND VPWR sky130_fd_sc_hd__tapvpwrvgnd_1
X_11811_ _05529_ _05530_ _05531_ VGND VGND VPWR VPWR _05532_ sky130_fd_sc_hd__and3b_1
XTAP_2345 VGND VPWR sky130_fd_sc_hd__tapvpwrvgnd_1
XTAP_1633 VGND VPWR sky130_fd_sc_hd__tapvpwrvgnd_1
XTAP_1622 VGND VPWR sky130_fd_sc_hd__tapvpwrvgnd_1
XTAP_1611 VGND VPWR sky130_fd_sc_hd__tapvpwrvgnd_1
X_14530_ _01629_ VGND VGND VPWR VPWR _01140_ sky130_fd_sc_hd__clkbuf_1
X_12791_ net530 net72 _06302_ VGND VGND VPWR VPWR _06310_ sky130_fd_sc_hd__mux2_1
XFILLER_0_95_264 VGND VGND VPWR VPWR sky130_fd_sc_hd__fill_2
XFILLER_0_95_253 VGND VGND VPWR VPWR sky130_fd_sc_hd__decap_8
XTAP_1666 VGND VPWR sky130_fd_sc_hd__tapvpwrvgnd_1
XTAP_1644 VGND VPWR sky130_fd_sc_hd__tapvpwrvgnd_1
XTAP_1655 VGND VPWR sky130_fd_sc_hd__tapvpwrvgnd_1
XFILLER_0_68_489 VGND VGND VPWR VPWR sky130_fd_sc_hd__fill_2
X_11742_ _05491_ VGND VGND VPWR VPWR _00555_ sky130_fd_sc_hd__clkbuf_1
XTAP_1699 VGND VPWR sky130_fd_sc_hd__tapvpwrvgnd_1
XTAP_1688 VGND VPWR sky130_fd_sc_hd__tapvpwrvgnd_1
XFILLER_0_95_286 VGND VGND VPWR VPWR sky130_fd_sc_hd__fill_2
XTAP_1677 VGND VPWR sky130_fd_sc_hd__tapvpwrvgnd_1
X_14461_ net767 _05192_ _01587_ VGND VGND VPWR VPWR _01593_ sky130_fd_sc_hd__mux2_1
X_11673_ net962 _05175_ _05447_ VGND VGND VPWR VPWR _05455_ sky130_fd_sc_hd__mux2_1
X_10624_ decoded_imm\[29\] _02632_ VGND VGND VPWR VPWR _04831_ sky130_fd_sc_hd__nor2_1
X_13412_ _06794_ _06892_ VGND VGND VPWR VPWR _06893_ sky130_fd_sc_hd__and2_1
X_14392_ _01556_ VGND VGND VPWR VPWR _01043_ sky130_fd_sc_hd__clkbuf_1
X_16200_ clknet_leaf_137_clk _00817_ VGND VGND VPWR VPWR net205 sky130_fd_sc_hd__dfxtp_4
XFILLER_0_52_813 VGND VGND VPWR VPWR sky130_fd_sc_hd__fill_1
X_13343_ cpuregs\[28\]\[16\] cpuregs\[29\]\[16\] _06687_ VGND VGND VPWR VPWR _06826_
+ sky130_fd_sc_hd__mux2_1
X_16131_ clknet_leaf_12_clk _07649_ VGND VGND VPWR VPWR reg_out\[9\] sky130_fd_sc_hd__dfxtp_1
X_10555_ cpuregs\[2\]\[27\] cpuregs\[3\]\[27\] _03768_ VGND VGND VPWR VPWR _04764_
+ sky130_fd_sc_hd__mux2_1
XFILLER_0_106_263 VGND VGND VPWR VPWR sky130_fd_sc_hd__fill_2
Xpicorv32_309 VGND VGND VPWR VPWR picorv32_309/HI pcpi_insn[20] sky130_fd_sc_hd__conb_1
X_10486_ cpuregs\[4\]\[25\] cpuregs\[5\]\[25\] cpuregs\[6\]\[25\] cpuregs\[7\]\[25\]
+ _03875_ _03669_ VGND VGND VPWR VPWR _04697_ sky130_fd_sc_hd__mux4_1
X_13274_ _06441_ _06746_ _06750_ _06758_ _06468_ VGND VGND VPWR VPWR _06759_ sky130_fd_sc_hd__a311o_1
X_16062_ clknet_leaf_149_clk _00712_ VGND VGND VPWR VPWR count_cycle\[5\] sky130_fd_sc_hd__dfxtp_1
X_15013_ _01885_ VGND VGND VPWR VPWR _01367_ sky130_fd_sc_hd__clkbuf_1
X_12225_ _05846_ _05837_ VGND VGND VPWR VPWR _05847_ sky130_fd_sc_hd__nand2_1
X_12156_ decoded_imm_j\[2\] _05693_ _05782_ _05780_ VGND VGND VPWR VPWR _05783_ sky130_fd_sc_hd__a211o_1
X_11107_ net987 _03532_ _05135_ VGND VGND VPWR VPWR _05139_ sky130_fd_sc_hd__mux2_1
X_12087_ _05688_ _05728_ _05729_ _05730_ VGND VGND VPWR VPWR _00661_ sky130_fd_sc_hd__o211a_1
X_16964_ clknet_leaf_91_clk _01528_ VGND VGND VPWR VPWR cpuregs\[10\]\[19\] sky130_fd_sc_hd__dfxtp_1
X_15915_ clknet_leaf_98_clk _00565_ VGND VGND VPWR VPWR cpuregs\[17\]\[17\] sky130_fd_sc_hd__dfxtp_1
X_16895_ clknet_leaf_106_clk _01459_ VGND VGND VPWR VPWR cpuregs\[8\]\[14\] sky130_fd_sc_hd__dfxtp_1
X_11038_ _05102_ VGND VGND VPWR VPWR _00240_ sky130_fd_sc_hd__clkbuf_1
XFILLER_0_78_209 VGND VGND VPWR VPWR sky130_fd_sc_hd__fill_1
X_15846_ clknet_leaf_138_clk _00496_ VGND VGND VPWR VPWR cpuregs\[25\]\[12\] sky130_fd_sc_hd__dfxtp_1
XFILLER_0_59_423 VGND VGND VPWR VPWR sky130_fd_sc_hd__fill_1
XFILLER_0_129_300 VGND VGND VPWR VPWR sky130_fd_sc_hd__fill_2
XFILLER_0_86_220 VGND VGND VPWR VPWR sky130_fd_sc_hd__fill_1
X_12989_ _06434_ _06481_ VGND VGND VPWR VPWR _06482_ sky130_fd_sc_hd__and2_1
X_15777_ clknet_leaf_142_clk _00427_ VGND VGND VPWR VPWR cpuregs\[26\]\[7\] sky130_fd_sc_hd__dfxtp_1
XFILLER_0_86_253 VGND VGND VPWR VPWR sky130_fd_sc_hd__fill_1
X_14728_ _01734_ VGND VGND VPWR VPWR _01233_ sky130_fd_sc_hd__clkbuf_1
X_14659_ net1076 _05186_ _01695_ VGND VGND VPWR VPWR _01698_ sky130_fd_sc_hd__mux2_1
X_08180_ _02148_ _02564_ _02565_ _02568_ _02284_ VGND VGND VPWR VPWR _02569_ sky130_fd_sc_hd__a311o_1
XFILLER_0_6_214 VGND VGND VPWR VPWR sky130_fd_sc_hd__fill_2
XFILLER_0_125_561 VGND VGND VPWR VPWR sky130_fd_sc_hd__decap_3
XFILLER_0_70_654 VGND VGND VPWR VPWR sky130_fd_sc_hd__decap_3
XFILLER_0_54_194 VGND VGND VPWR VPWR sky130_fd_sc_hd__fill_2
XFILLER_0_6_269 VPWR VGND VPWR VGND sky130_ef_sc_hd__decap_12
X_16329_ clknet_leaf_2_clk _00913_ VGND VGND VPWR VPWR is_jalr_addi_slti_sltiu_xori_ori_andi
+ sky130_fd_sc_hd__dfxtp_1
XFILLER_0_40_96 VGND VGND VPWR VPWR sky130_fd_sc_hd__fill_1
XFILLER_0_140_531 VGND VGND VPWR VPWR sky130_fd_sc_hd__fill_1
Xoutput201 net201 VGND VGND VPWR VPWR pcpi_rs1[8] sky130_fd_sc_hd__clkbuf_4
XFILLER_0_2_453 VGND VGND VPWR VPWR sky130_fd_sc_hd__fill_2
Xoutput212 net246 VGND VGND VPWR VPWR pcpi_rs2[18] sky130_fd_sc_hd__clkbuf_4
Xoutput234 net248 VGND VGND VPWR VPWR pcpi_rs2[9] sky130_fd_sc_hd__clkbuf_4
Xoutput223 net223 VGND VGND VPWR VPWR pcpi_rs2[28] sky130_fd_sc_hd__clkbuf_4
XFILLER_0_49_72 VGND VGND VPWR VPWR sky130_fd_sc_hd__fill_2
XFILLER_0_10_286 VGND VGND VPWR VPWR sky130_fd_sc_hd__decap_3
X_07964_ count_instr\[42\] instr_rdinstrh count_cycle\[42\] _02237_ VGND VGND VPWR
+ VPWR _02367_ sky130_fd_sc_hd__a22o_1
X_09703_ _03798_ VGND VGND VPWR VPWR _03935_ sky130_fd_sc_hd__buf_6
X_07895_ net424 _02232_ _02301_ VGND VGND VPWR VPWR _02302_ sky130_fd_sc_hd__a21oi_2
X_09634_ cpuregs\[14\]\[3\] cpuregs\[15\]\[3\] _03751_ VGND VGND VPWR VPWR _03867_
+ sky130_fd_sc_hd__mux2_1
X_09565_ _00013_ VGND VGND VPWR VPWR _03799_ sky130_fd_sc_hd__buf_6
X_09496_ _03730_ VGND VGND VPWR VPWR _03731_ sky130_fd_sc_hd__clkbuf_8
X_08516_ _02838_ _02845_ _02668_ VGND VGND VPWR VPWR _02893_ sky130_fd_sc_hd__mux2_1
XFILLER_0_19_810 VGND VGND VPWR VPWR sky130_fd_sc_hd__fill_1
XFILLER_0_92_212 VGND VGND VPWR VPWR sky130_fd_sc_hd__fill_1
X_08447_ is_slti_blt_slt instr_bge _02827_ VGND VGND VPWR VPWR _02828_ sky130_fd_sc_hd__mux2_1
X_08378_ _02752_ _02754_ _02755_ _02758_ VGND VGND VPWR VPWR _02759_ sky130_fd_sc_hd__and4_2
XFILLER_0_33_334 VGND VGND VPWR VPWR sky130_fd_sc_hd__fill_2
X_10340_ cpuregs\[2\]\[21\] cpuregs\[3\]\[21\] _03768_ VGND VGND VPWR VPWR _04555_
+ sky130_fd_sc_hd__mux2_1
XFILLER_0_21_529 VGND VGND VPWR VPWR sky130_fd_sc_hd__fill_1
X_10271_ cpuregs\[0\]\[19\] cpuregs\[1\]\[19\] _03750_ VGND VGND VPWR VPWR _04488_
+ sky130_fd_sc_hd__mux2_1
XFILLER_0_60_197 VPWR VGND VPWR VGND sky130_ef_sc_hd__decap_12
X_12010_ _05674_ _05661_ _05675_ VGND VGND VPWR VPWR _05676_ sky130_fd_sc_hd__and3b_1
X_13961_ _07386_ VGND VGND VPWR VPWR _00870_ sky130_fd_sc_hd__clkbuf_1
X_16680_ clknet_leaf_66_clk _01247_ VGND VGND VPWR VPWR cpuregs\[29\]\[26\] sky130_fd_sc_hd__dfxtp_1
X_15700_ clknet_leaf_47_clk _00350_ VGND VGND VPWR VPWR cpuregs\[27\]\[26\] sky130_fd_sc_hd__dfxtp_1
X_12912_ _06408_ net252 _06375_ VGND VGND VPWR VPWR _06409_ sky130_fd_sc_hd__mux2_1
X_13892_ _07341_ VGND VGND VPWR VPWR _00849_ sky130_fd_sc_hd__clkbuf_1
XTAP_2153 VGND VPWR sky130_fd_sc_hd__tapvpwrvgnd_1
XTAP_2142 VGND VPWR sky130_fd_sc_hd__tapvpwrvgnd_1
XTAP_2120 VGND VPWR sky130_fd_sc_hd__tapvpwrvgnd_1
XTAP_2131 VGND VPWR sky130_fd_sc_hd__tapvpwrvgnd_1
X_15631_ clknet_leaf_61_clk _00281_ VGND VGND VPWR VPWR cpuregs\[31\]\[21\] sky130_fd_sc_hd__dfxtp_1
X_12843_ _03308_ VGND VGND VPWR VPWR _06342_ sky130_fd_sc_hd__buf_4
XTAP_2186 VGND VPWR sky130_fd_sc_hd__tapvpwrvgnd_1
XTAP_2175 VGND VPWR sky130_fd_sc_hd__tapvpwrvgnd_1
XTAP_2164 VGND VPWR sky130_fd_sc_hd__tapvpwrvgnd_1
XTAP_1441 VGND VPWR sky130_fd_sc_hd__tapvpwrvgnd_1
XTAP_1430 VGND VPWR sky130_fd_sc_hd__tapvpwrvgnd_1
X_15562_ clknet_leaf_87_clk _00212_ VGND VGND VPWR VPWR cpuregs\[2\]\[16\] sky130_fd_sc_hd__dfxtp_1
X_12774_ net63 net94 _06294_ VGND VGND VPWR VPWR _06301_ sky130_fd_sc_hd__mux2_1
XTAP_2197 VGND VPWR sky130_fd_sc_hd__tapvpwrvgnd_1
XFILLER_0_83_223 VGND VGND VPWR VPWR sky130_fd_sc_hd__fill_1
XFILLER_0_83_212 VGND VGND VPWR VPWR sky130_fd_sc_hd__decap_4
XTAP_1474 VGND VPWR sky130_fd_sc_hd__tapvpwrvgnd_1
XTAP_1452 VGND VPWR sky130_fd_sc_hd__tapvpwrvgnd_1
XTAP_1463 VGND VPWR sky130_fd_sc_hd__tapvpwrvgnd_1
X_15493_ clknet_leaf_100_clk _00143_ VGND VGND VPWR VPWR cpuregs\[30\]\[11\] sky130_fd_sc_hd__dfxtp_1
X_11725_ _04983_ _05373_ VGND VGND VPWR VPWR _05482_ sky130_fd_sc_hd__or2_2
X_14513_ _01620_ VGND VGND VPWR VPWR _01132_ sky130_fd_sc_hd__clkbuf_1
XFILLER_0_138_174 VGND VGND VPWR VPWR sky130_fd_sc_hd__fill_1
XFILLER_0_84_768 VGND VGND VPWR VPWR sky130_fd_sc_hd__fill_1
XFILLER_0_83_245 VGND VGND VPWR VPWR sky130_fd_sc_hd__decap_3
XTAP_1496 VGND VPWR sky130_fd_sc_hd__tapvpwrvgnd_1
XTAP_1485 VGND VPWR sky130_fd_sc_hd__tapvpwrvgnd_1
X_14444_ net721 _05175_ _01576_ VGND VGND VPWR VPWR _01584_ sky130_fd_sc_hd__mux2_1
X_11656_ _05445_ VGND VGND VPWR VPWR _00515_ sky130_fd_sc_hd__clkbuf_1
X_10607_ cpuregs\[20\]\[28\] cpuregs\[21\]\[28\] _03880_ VGND VGND VPWR VPWR _04815_
+ sky130_fd_sc_hd__mux2_1
X_11587_ _05049_ net942 _05374_ VGND VGND VPWR VPWR _05409_ sky130_fd_sc_hd__mux2_1
X_14375_ _01547_ VGND VGND VPWR VPWR _01035_ sky130_fd_sc_hd__clkbuf_1
XFILLER_0_36_194 VGND VGND VPWR VPWR sky130_fd_sc_hd__fill_2
XFILLER_0_122_531 VGND VGND VPWR VPWR sky130_fd_sc_hd__fill_1
X_10538_ reg_pc\[26\] _03992_ _04741_ _04747_ _03702_ VGND VGND VPWR VPWR _04748_
+ sky130_fd_sc_hd__a221o_1
XFILLER_0_101_57 VGND VGND VPWR VPWR sky130_fd_sc_hd__fill_2
Xhold909 cpuregs\[3\]\[19\] VGND VGND VPWR VPWR net1267 sky130_fd_sc_hd__dlygate4sd3_1
X_13326_ _06537_ _06806_ _06808_ VGND VGND VPWR VPWR _06809_ sky130_fd_sc_hd__a21o_1
XFILLER_0_51_164 VGND VGND VPWR VPWR sky130_fd_sc_hd__decap_4
X_16114_ clknet_leaf_154_clk _00764_ VGND VGND VPWR VPWR count_cycle\[57\] sky130_fd_sc_hd__dfxtp_1
XFILLER_0_40_805 VGND VGND VPWR VPWR sky130_fd_sc_hd__fill_1
X_16045_ clknet_leaf_33_clk _00695_ VGND VGND VPWR VPWR reg_next_pc\[20\] sky130_fd_sc_hd__dfxtp_1
X_13257_ _06580_ _06741_ VGND VGND VPWR VPWR _06742_ sky130_fd_sc_hd__or2_1
XFILLER_0_24_389 VGND VGND VPWR VPWR sky130_fd_sc_hd__fill_2
X_10469_ _02156_ _04678_ _04680_ cpu_state\[4\] VGND VGND VPWR VPWR _04681_ sky130_fd_sc_hd__o211a_1
X_12208_ _05830_ _05821_ _05820_ VGND VGND VPWR VPWR _05831_ sky130_fd_sc_hd__o21a_1
X_13188_ cpuregs\[0\]\[12\] cpuregs\[1\]\[12\] cpuregs\[2\]\[12\] cpuregs\[3\]\[12\]
+ _06364_ _03400_ VGND VGND VPWR VPWR _06675_ sky130_fd_sc_hd__mux4_1
X_12139_ _02141_ VGND VGND VPWR VPWR _05768_ sky130_fd_sc_hd__buf_4
X_16947_ clknet_leaf_101_clk _01511_ VGND VGND VPWR VPWR cpuregs\[10\]\[2\] sky130_fd_sc_hd__dfxtp_1
X_16878_ clknet_leaf_63_clk _01442_ VGND VGND VPWR VPWR cpuregs\[22\]\[29\] sky130_fd_sc_hd__dfxtp_1
X_07680_ net404 _02106_ _02107_ _02104_ _02109_ VGND VGND VPWR VPWR _00024_ sky130_fd_sc_hd__a221o_1
X_15829_ clknet_leaf_45_clk _00479_ VGND VGND VPWR VPWR cpuregs\[16\]\[27\] sky130_fd_sc_hd__dfxtp_1
X_09350_ reg_out\[23\] alu_out_q\[23\] _03436_ VGND VGND VPWR VPWR _03595_ sky130_fd_sc_hd__mux2_1
X_09281_ reg_pc\[14\] _03529_ _03460_ VGND VGND VPWR VPWR _03535_ sky130_fd_sc_hd__o21ai_1
XFILLER_0_87_595 VPWR VGND VPWR VGND sky130_ef_sc_hd__decap_12
X_08301_ _02680_ _02681_ VGND VGND VPWR VPWR _02682_ sky130_fd_sc_hd__nand2_1
XFILLER_0_59_275 VGND VGND VPWR VPWR sky130_fd_sc_hd__fill_1
XFILLER_0_129_185 VPWR VGND VPWR VGND sky130_ef_sc_hd__decap_12
X_08232_ _02615_ _02616_ VGND VGND VPWR VPWR _02617_ sky130_fd_sc_hd__nand2_1
Xclkbuf_leaf_153_clk clknet_4_0_0_clk VGND VGND VPWR VPWR clknet_leaf_153_clk sky130_fd_sc_hd__clkbuf_16
XFILLER_0_133_818 VPWR VGND VPWR VGND sky130_ef_sc_hd__decap_12
XFILLER_0_16_813 VPWR VGND VPWR VGND sky130_ef_sc_hd__decap_12
X_08163_ _02200_ _02546_ _02549_ _02552_ VGND VGND VPWR VPWR _07633_ sky130_fd_sc_hd__o31a_1
XFILLER_0_27_183 VGND VGND VPWR VPWR sky130_fd_sc_hd__decap_4
XFILLER_0_132_328 VGND VGND VPWR VPWR sky130_fd_sc_hd__fill_2
X_08094_ reg_pc\[19\] decoded_imm\[19\] VGND VGND VPWR VPWR _02488_ sky130_fd_sc_hd__nand2_1
XFILLER_0_15_389 VGND VGND VPWR VPWR sky130_fd_sc_hd__decap_3
X_08996_ reg_out\[31\] reg_next_pc\[31\] _03270_ VGND VGND VPWR VPWR _03289_ sky130_fd_sc_hd__mux2_1
XFILLER_0_11_595 VGND VGND VPWR VPWR sky130_fd_sc_hd__fill_2
X_07947_ _02349_ _02350_ VGND VGND VPWR VPWR _02351_ sky130_fd_sc_hd__xnor2_1
X_07878_ _02268_ VGND VGND VPWR VPWR _02286_ sky130_fd_sc_hd__clkbuf_4
XFILLER_0_92_80 VGND VGND VPWR VPWR sky130_fd_sc_hd__decap_4
X_09617_ _02083_ _03792_ _03850_ VGND VGND VPWR VPWR _03851_ sky130_fd_sc_hd__a21o_1
X_09548_ _03705_ _03782_ _02152_ VGND VGND VPWR VPWR _03783_ sky130_fd_sc_hd__a21oi_1
XFILLER_0_78_584 VGND VGND VPWR VPWR sky130_fd_sc_hd__fill_1
XFILLER_0_65_223 VGND VGND VPWR VPWR sky130_fd_sc_hd__fill_1
X_11510_ net1241 _05217_ _05360_ VGND VGND VPWR VPWR _05368_ sky130_fd_sc_hd__mux2_1
XFILLER_0_93_543 VGND VGND VPWR VPWR sky130_fd_sc_hd__fill_1
X_09479_ _03714_ VGND VGND VPWR VPWR _03715_ sky130_fd_sc_hd__clkbuf_4
Xclkbuf_leaf_144_clk clknet_4_2_0_clk VGND VGND VPWR VPWR clknet_leaf_144_clk sky130_fd_sc_hd__clkbuf_16
XFILLER_0_135_111 VGND VGND VPWR VPWR sky130_fd_sc_hd__fill_1
X_12490_ _06088_ _06089_ VGND VGND VPWR VPWR _06090_ sky130_fd_sc_hd__xnor2_1
XFILLER_0_124_807 VGND VGND VPWR VPWR sky130_fd_sc_hd__fill_2
XFILLER_0_108_336 VGND VGND VPWR VPWR sky130_fd_sc_hd__decap_4
XFILLER_0_53_429 VGND VGND VPWR VPWR sky130_fd_sc_hd__fill_1
XFILLER_0_136_689 VGND VGND VPWR VPWR sky130_fd_sc_hd__fill_2
X_11441_ _05331_ VGND VGND VPWR VPWR _00414_ sky130_fd_sc_hd__clkbuf_1
XFILLER_0_34_643 VGND VGND VPWR VPWR sky130_fd_sc_hd__fill_1
X_11372_ _05039_ net900 _05288_ VGND VGND VPWR VPWR _05295_ sky130_fd_sc_hd__mux2_1
X_14160_ _07500_ VGND VGND VPWR VPWR _00943_ sky130_fd_sc_hd__clkbuf_1
X_10323_ _03862_ _04518_ _04538_ VGND VGND VPWR VPWR _04539_ sky130_fd_sc_hd__o21a_1
X_13111_ cpuregs\[12\]\[10\] cpuregs\[13\]\[10\] cpuregs\[14\]\[10\] cpuregs\[15\]\[10\]
+ _06418_ _06419_ VGND VGND VPWR VPWR _06600_ sky130_fd_sc_hd__mux4_1
XFILLER_0_21_337 VGND VGND VPWR VPWR sky130_fd_sc_hd__fill_1
X_14091_ _02172_ _07306_ _07318_ _07463_ VGND VGND VPWR VPWR _00911_ sky130_fd_sc_hd__a22o_1
X_10254_ _04471_ _02480_ _04150_ VGND VGND VPWR VPWR _04472_ sky130_fd_sc_hd__mux2_1
X_13042_ _06533_ net249 _06375_ VGND VGND VPWR VPWR _06534_ sky130_fd_sc_hd__mux2_1
X_10185_ _04402_ _04403_ VGND VGND VPWR VPWR _04404_ sky130_fd_sc_hd__nand2_1
XFILLER_0_56_29 VGND VGND VPWR VPWR sky130_fd_sc_hd__decap_4
X_16801_ clknet_leaf_87_clk _01365_ VGND VGND VPWR VPWR cpuregs\[6\]\[16\] sky130_fd_sc_hd__dfxtp_1
X_14993_ _03504_ net911 _01865_ VGND VGND VPWR VPWR _01875_ sky130_fd_sc_hd__mux2_1
X_16732_ clknet_leaf_102_clk _01296_ VGND VGND VPWR VPWR cpuregs\[4\]\[11\] sky130_fd_sc_hd__dfxtp_1
X_13944_ instr_ori _07367_ _07346_ _07364_ VGND VGND VPWR VPWR _07375_ sky130_fd_sc_hd__a22o_1
X_13875_ mem_rdata_q\[14\] VGND VGND VPWR VPWR _07327_ sky130_fd_sc_hd__clkbuf_4
X_16663_ clknet_leaf_133_clk _01230_ VGND VGND VPWR VPWR cpuregs\[29\]\[9\] sky130_fd_sc_hd__dfxtp_1
X_12826_ _02092_ _06328_ VGND VGND VPWR VPWR _06329_ sky130_fd_sc_hd__and2_1
X_15614_ clknet_leaf_123_clk _00264_ VGND VGND VPWR VPWR cpuregs\[31\]\[4\] sky130_fd_sc_hd__dfxtp_1
XFILLER_0_84_521 VGND VGND VPWR VPWR sky130_fd_sc_hd__fill_1
X_16594_ clknet_leaf_123_clk _01161_ VGND VGND VPWR VPWR cpuregs\[9\]\[4\] sky130_fd_sc_hd__dfxtp_1
X_15545_ clknet_leaf_94_clk _00195_ VGND VGND VPWR VPWR cpuregs\[13\]\[31\] sky130_fd_sc_hd__dfxtp_1
XTAP_1293 VGND VPWR sky130_fd_sc_hd__tapvpwrvgnd_1
XTAP_1282 VGND VPWR sky130_fd_sc_hd__tapvpwrvgnd_1
XTAP_1260 VGND VPWR sky130_fd_sc_hd__tapvpwrvgnd_1
XTAP_1271 VGND VPWR sky130_fd_sc_hd__tapvpwrvgnd_1
Xclkbuf_leaf_135_clk clknet_4_9_0_clk VGND VGND VPWR VPWR clknet_leaf_135_clk sky130_fd_sc_hd__clkbuf_16
X_12757_ _06289_ VGND VGND VPWR VPWR _06290_ sky130_fd_sc_hd__clkbuf_4
X_11708_ _05473_ VGND VGND VPWR VPWR _00539_ sky130_fd_sc_hd__clkbuf_1
X_15476_ clknet_leaf_80_clk _00126_ VGND VGND VPWR VPWR cpuregs\[12\]\[26\] sky130_fd_sc_hd__dfxtp_1
XFILLER_0_84_598 VGND VGND VPWR VPWR sky130_fd_sc_hd__fill_2
XFILLER_0_84_587 VGND VGND VPWR VPWR sky130_fd_sc_hd__fill_1
X_12688_ _06230_ _06179_ _06231_ VGND VGND VPWR VPWR _06232_ sky130_fd_sc_hd__and3b_1
X_11639_ _05033_ net1651 _05433_ VGND VGND VPWR VPWR _05437_ sky130_fd_sc_hd__mux2_1
XFILLER_0_126_177 VGND VGND VPWR VPWR sky130_fd_sc_hd__fill_2
X_14427_ _01574_ VGND VGND VPWR VPWR _01060_ sky130_fd_sc_hd__clkbuf_1
XFILLER_0_21_54 VGND VGND VPWR VPWR sky130_fd_sc_hd__fill_2
XFILLER_0_108_3 VGND VGND VPWR VPWR sky130_fd_sc_hd__decap_4
X_14358_ decoded_imm\[1\] _07613_ _07359_ VGND VGND VPWR VPWR _07614_ sky130_fd_sc_hd__mux2_1
XFILLER_0_97_36 VPWR VGND VPWR VGND sky130_ef_sc_hd__decap_12
Xhold717 cpuregs\[16\]\[15\] VGND VGND VPWR VPWR net1075 sky130_fd_sc_hd__dlygate4sd3_1
X_13309_ cpuregs\[28\]\[15\] cpuregs\[29\]\[15\] _06687_ VGND VGND VPWR VPWR _06793_
+ sky130_fd_sc_hd__mux2_1
XFILLER_0_52_495 VGND VGND VPWR VPWR sky130_fd_sc_hd__fill_1
Xhold728 cpuregs\[24\]\[8\] VGND VGND VPWR VPWR net1086 sky130_fd_sc_hd__dlygate4sd3_1
XFILLER_0_24_175 VGND VGND VPWR VPWR sky130_fd_sc_hd__fill_2
Xhold706 cpuregs\[5\]\[8\] VGND VGND VPWR VPWR net1064 sky130_fd_sc_hd__dlygate4sd3_1
XFILLER_0_40_624 VGND VGND VPWR VPWR sky130_fd_sc_hd__decap_4
X_14289_ mem_rdata_q\[30\] _07570_ VGND VGND VPWR VPWR _07574_ sky130_fd_sc_hd__and2_1
Xhold739 cpuregs\[12\]\[1\] VGND VGND VPWR VPWR net1097 sky130_fd_sc_hd__dlygate4sd3_1
X_16028_ clknet_leaf_8_clk _00678_ VGND VGND VPWR VPWR reg_next_pc\[3\] sky130_fd_sc_hd__dfxtp_1
X_08850_ _02744_ _03199_ VGND VGND VPWR VPWR _03200_ sky130_fd_sc_hd__xnor2_1
XFILLER_0_137_31 VGND VGND VPWR VPWR sky130_fd_sc_hd__fill_1
X_07801_ net31 net17 _02213_ VGND VGND VPWR VPWR _02214_ sky130_fd_sc_hd__mux2_1
X_08781_ _02814_ _03127_ _02122_ VGND VGND VPWR VPWR _03137_ sky130_fd_sc_hd__a21o_1
X_07732_ instr_jal VGND VGND VPWR VPWR _02153_ sky130_fd_sc_hd__clkinv_4
X_07663_ instr_lh instr_lhu VGND VGND VPWR VPWR _02093_ sky130_fd_sc_hd__or2_1
X_09402_ _03546_ _03637_ _03638_ _03639_ VGND VGND VPWR VPWR _03640_ sky130_fd_sc_hd__a22o_2
XFILLER_0_94_318 VGND VGND VPWR VPWR sky130_fd_sc_hd__decap_4
XFILLER_0_1_64 VGND VGND VPWR VPWR sky130_fd_sc_hd__decap_3
X_09333_ reg_out\[21\] alu_out_q\[21\] _03436_ VGND VGND VPWR VPWR _03580_ sky130_fd_sc_hd__mux2_1
Xclkbuf_leaf_126_clk clknet_4_8_0_clk VGND VGND VPWR VPWR clknet_leaf_126_clk sky130_fd_sc_hd__clkbuf_16
XFILLER_0_106_807 VGND VGND VPWR VPWR sky130_fd_sc_hd__fill_2
X_09264_ _03520_ VGND VGND VPWR VPWR _00048_ sky130_fd_sc_hd__clkbuf_1
XFILLER_0_133_626 VGND VGND VPWR VPWR sky130_fd_sc_hd__fill_2
XFILLER_0_133_615 VGND VGND VPWR VPWR sky130_fd_sc_hd__fill_1
X_09195_ _03459_ VGND VGND VPWR VPWR _03460_ sky130_fd_sc_hd__clkbuf_4
X_08215_ _02599_ _02600_ VGND VGND VPWR VPWR _02601_ sky130_fd_sc_hd__or2b_1
X_08146_ _02222_ _02465_ _02535_ _02508_ _02536_ VGND VGND VPWR VPWR _02537_ sky130_fd_sc_hd__a32o_1
XFILLER_0_71_793 VPWR VGND VPWR VGND sky130_ef_sc_hd__decap_12
XFILLER_0_70_281 VGND VGND VPWR VPWR sky130_fd_sc_hd__fill_2
XFILLER_0_30_112 VGND VGND VPWR VPWR sky130_fd_sc_hd__fill_1
XFILLER_0_70_292 VPWR VGND VPWR VGND sky130_ef_sc_hd__decap_12
X_08077_ count_instr\[18\] _02201_ count_cycle\[50\] _02456_ VGND VGND VPWR VPWR _02472_
+ sky130_fd_sc_hd__a22o_1
XFILLER_0_101_589 VGND VGND VPWR VPWR sky130_fd_sc_hd__fill_1
X_08979_ _02578_ _03277_ _03268_ VGND VGND VPWR VPWR _03278_ sky130_fd_sc_hd__mux2_4
Xhold55 count_instr\[48\] VGND VGND VPWR VPWR net413 sky130_fd_sc_hd__dlygate4sd3_1
Xhold44 count_instr\[62\] VGND VGND VPWR VPWR net402 sky130_fd_sc_hd__dlygate4sd3_1
Xhold33 _00858_ VGND VGND VPWR VPWR net391 sky130_fd_sc_hd__dlygate4sd3_1
X_11990_ count_instr\[52\] _05657_ VGND VGND VPWR VPWR _05662_ sky130_fd_sc_hd__or2_1
Xhold77 count_cycle\[39\] VGND VGND VPWR VPWR net435 sky130_fd_sc_hd__dlygate4sd3_1
Xhold66 count_cycle\[6\] VGND VGND VPWR VPWR net424 sky130_fd_sc_hd__dlygate4sd3_1
Xhold99 count_instr\[38\] VGND VGND VPWR VPWR net457 sky130_fd_sc_hd__dlygate4sd3_1
Xhold88 count_cycle\[3\] VGND VGND VPWR VPWR net446 sky130_fd_sc_hd__dlygate4sd3_1
X_10941_ _05050_ VGND VGND VPWR VPWR _00195_ sky130_fd_sc_hd__clkbuf_1
X_13660_ _07013_ _07132_ VGND VGND VPWR VPWR _07133_ sky130_fd_sc_hd__and2_1
XFILLER_0_97_145 VGND VGND VPWR VPWR sky130_fd_sc_hd__fill_1
XFILLER_0_94_830 VGND VGND VPWR VPWR sky130_fd_sc_hd__fill_2
X_12611_ count_cycle\[32\] _06171_ count_cycle\[33\] VGND VGND VPWR VPWR _06176_ sky130_fd_sc_hd__a21o_1
X_10872_ _05003_ net1424 _04985_ VGND VGND VPWR VPWR _05004_ sky130_fd_sc_hd__mux2_1
X_13591_ cpuregs\[6\]\[24\] cpuregs\[7\]\[24\] _03313_ VGND VGND VPWR VPWR _07066_
+ sky130_fd_sc_hd__mux2_1
Xclkbuf_leaf_117_clk clknet_4_10_0_clk VGND VGND VPWR VPWR clknet_leaf_117_clk sky130_fd_sc_hd__clkbuf_16
XFILLER_0_108_133 VGND VGND VPWR VPWR sky130_fd_sc_hd__fill_1
X_12542_ count_cycle\[11\] count_cycle\[12\] count_cycle\[13\] _06119_ VGND VGND VPWR
+ VPWR _06127_ sky130_fd_sc_hd__and4_1
X_15330_ _02051_ VGND VGND VPWR VPWR _01518_ sky130_fd_sc_hd__clkbuf_1
X_12473_ _06057_ _06068_ VGND VGND VPWR VPWR _06074_ sky130_fd_sc_hd__nand2_1
XFILLER_0_108_144 VGND VGND VPWR VPWR sky130_fd_sc_hd__decap_6
X_15261_ net518 VGND VGND VPWR VPWR _02016_ sky130_fd_sc_hd__clkbuf_1
X_14212_ net571 net98 _07530_ VGND VGND VPWR VPWR _07531_ sky130_fd_sc_hd__mux2_1
XFILLER_0_108_177 VGND VGND VPWR VPWR sky130_fd_sc_hd__fill_2
X_11424_ _05322_ VGND VGND VPWR VPWR _00406_ sky130_fd_sc_hd__clkbuf_1
XFILLER_0_123_169 VGND VGND VPWR VPWR sky130_fd_sc_hd__decap_3
XFILLER_0_61_281 VPWR VGND VPWR VGND sky130_ef_sc_hd__decap_12
X_15192_ _01980_ VGND VGND VPWR VPWR _01451_ sky130_fd_sc_hd__clkbuf_1
XFILLER_0_34_495 VGND VGND VPWR VPWR sky130_fd_sc_hd__fill_1
XANTENNA_8 _03318_ VGND VGND VPWR VPWR sky130_fd_sc_hd__diode_2
X_14143_ _07491_ VGND VGND VPWR VPWR _00935_ sky130_fd_sc_hd__clkbuf_1
X_11355_ _05022_ net1486 _05277_ VGND VGND VPWR VPWR _05286_ sky130_fd_sc_hd__mux2_1
X_10306_ _03868_ _04521_ _03870_ VGND VGND VPWR VPWR _04522_ sky130_fd_sc_hd__a21o_1
X_11286_ net631 _05198_ _05240_ VGND VGND VPWR VPWR _05249_ sky130_fd_sc_hd__mux2_1
X_14074_ _07453_ VGND VGND VPWR VPWR _00904_ sky130_fd_sc_hd__clkbuf_1
XFILLER_0_21_189 VGND VGND VPWR VPWR sky130_fd_sc_hd__fill_1
X_10237_ _03878_ _04452_ _04454_ VGND VGND VPWR VPWR _04455_ sky130_fd_sc_hd__a21o_1
XTAP_329 VGND VPWR sky130_fd_sc_hd__tapvpwrvgnd_1
XTAP_318 VGND VPWR sky130_fd_sc_hd__tapvpwrvgnd_1
XTAP_307 VGND VPWR sky130_fd_sc_hd__tapvpwrvgnd_1
XFILLER_0_30_690 VGND VGND VPWR VPWR sky130_fd_sc_hd__fill_1
X_13025_ _03307_ _06507_ _06516_ VGND VGND VPWR VPWR _06517_ sky130_fd_sc_hd__or3_2
X_10168_ cpuregs\[0\]\[16\] cpuregs\[1\]\[16\] _03980_ VGND VGND VPWR VPWR _04388_
+ sky130_fd_sc_hd__mux2_1
X_10099_ _03690_ _04320_ _03959_ VGND VGND VPWR VPWR _04321_ sky130_fd_sc_hd__o21a_1
X_14976_ _01866_ VGND VGND VPWR VPWR _01349_ sky130_fd_sc_hd__clkbuf_1
X_16715_ clknet_leaf_68_clk _01282_ VGND VGND VPWR VPWR cpuregs\[3\]\[29\] sky130_fd_sc_hd__dfxtp_1
XFILLER_0_107_45 VGND VGND VPWR VPWR sky130_fd_sc_hd__decap_4
XFILLER_0_88_134 VGND VGND VPWR VPWR sky130_fd_sc_hd__decap_6
X_13927_ net469 _07358_ _07335_ _02189_ VGND VGND VPWR VPWR _00860_ sky130_fd_sc_hd__a22o_1
XFILLER_0_89_668 VGND VGND VPWR VPWR sky130_fd_sc_hd__decap_4
XFILLER_0_123_11 VGND VGND VPWR VPWR sky130_fd_sc_hd__decap_3
X_16646_ clknet_leaf_61_clk _01213_ VGND VGND VPWR VPWR cpuregs\[23\]\[24\] sky130_fd_sc_hd__dfxtp_1
XFILLER_0_76_329 VGND VGND VPWR VPWR sky130_fd_sc_hd__decap_6
XFILLER_0_57_521 VGND VGND VPWR VPWR sky130_fd_sc_hd__fill_2
X_13858_ _07314_ VGND VGND VPWR VPWR _01097_ sky130_fd_sc_hd__buf_1
X_12809_ _06319_ VGND VGND VPWR VPWR _00794_ sky130_fd_sc_hd__clkbuf_1
X_16577_ clknet_leaf_65_clk _01154_ VGND VGND VPWR VPWR cpuregs\[24\]\[29\] sky130_fd_sc_hd__dfxtp_1
X_13789_ _06415_ _07244_ _07257_ _02181_ decoded_imm\[30\] VGND VGND VPWR VPWR _07258_
+ sky130_fd_sc_hd__a32o_1
Xclkbuf_leaf_108_clk clknet_4_11_0_clk VGND VGND VPWR VPWR clknet_leaf_108_clk sky130_fd_sc_hd__clkbuf_16
XFILLER_0_29_223 VGND VGND VPWR VPWR sky130_fd_sc_hd__fill_1
XFILLER_0_32_20 VGND VGND VPWR VPWR sky130_fd_sc_hd__decap_4
XFILLER_0_84_362 VGND VGND VPWR VPWR sky130_fd_sc_hd__fill_2
X_15528_ clknet_leaf_105_clk _00178_ VGND VGND VPWR VPWR cpuregs\[13\]\[14\] sky130_fd_sc_hd__dfxtp_1
XTAP_1090 VGND VPWR sky130_fd_sc_hd__tapvpwrvgnd_1
XFILLER_0_29_256 VGND VGND VPWR VPWR sky130_fd_sc_hd__decap_8
XFILLER_0_32_42 VGND VGND VPWR VPWR sky130_fd_sc_hd__fill_1
XFILLER_0_5_813 VGND VGND VPWR VPWR sky130_fd_sc_hd__fill_2
XFILLER_0_127_497 VGND VGND VPWR VPWR sky130_fd_sc_hd__fill_1
X_08000_ _02398_ _02399_ VGND VGND VPWR VPWR _02400_ sky130_fd_sc_hd__nand2_1
X_15459_ clknet_leaf_111_clk _00109_ VGND VGND VPWR VPWR cpuregs\[12\]\[9\] sky130_fd_sc_hd__dfxtp_1
Xhold525 cpuregs\[24\]\[27\] VGND VGND VPWR VPWR net883 sky130_fd_sc_hd__dlygate4sd3_1
Xhold536 cpuregs\[5\]\[28\] VGND VGND VPWR VPWR net894 sky130_fd_sc_hd__dlygate4sd3_1
Xhold514 cpuregs\[31\]\[20\] VGND VGND VPWR VPWR net872 sky130_fd_sc_hd__dlygate4sd3_1
Xhold503 cpuregs\[18\]\[4\] VGND VGND VPWR VPWR net861 sky130_fd_sc_hd__dlygate4sd3_1
Xmax_cap244 _03710_ VGND VGND VPWR VPWR net244 sky130_fd_sc_hd__clkbuf_1
Xhold547 cpuregs\[7\]\[22\] VGND VGND VPWR VPWR net905 sky130_fd_sc_hd__dlygate4sd3_1
Xhold569 cpuregs\[15\]\[21\] VGND VGND VPWR VPWR net927 sky130_fd_sc_hd__dlygate4sd3_1
Xhold558 cpuregs\[23\]\[31\] VGND VGND VPWR VPWR net916 sky130_fd_sc_hd__dlygate4sd3_1
X_09951_ cpuregs\[28\]\[10\] cpuregs\[29\]\[10\] cpuregs\[30\]\[10\] cpuregs\[31\]\[10\]
+ _03865_ _03942_ VGND VGND VPWR VPWR _04177_ sky130_fd_sc_hd__mux4_1
XFILLER_0_12_178 VGND VGND VPWR VPWR sky130_fd_sc_hd__decap_6
X_08902_ _03223_ VGND VGND VPWR VPWR _03224_ sky130_fd_sc_hd__buf_4
X_09882_ decoded_imm\[9\] net202 VGND VGND VPWR VPWR _04109_ sky130_fd_sc_hd__nand2_1
XTAP_830 VGND VPWR sky130_fd_sc_hd__tapvpwrvgnd_1
XTAP_841 VGND VPWR sky130_fd_sc_hd__tapvpwrvgnd_1
XTAP_852 VGND VPWR sky130_fd_sc_hd__tapvpwrvgnd_1
X_08833_ _03182_ _03184_ VGND VGND VPWR VPWR _03185_ sky130_fd_sc_hd__xnor2_1
Xhold1203 cpuregs\[21\]\[21\] VGND VGND VPWR VPWR net1561 sky130_fd_sc_hd__dlygate4sd3_1
XFILLER_0_57_72 VGND VGND VPWR VPWR sky130_fd_sc_hd__decap_4
Xhold1225 cpuregs\[21\]\[12\] VGND VGND VPWR VPWR net1583 sky130_fd_sc_hd__dlygate4sd3_1
Xhold1214 cpuregs\[16\]\[4\] VGND VGND VPWR VPWR net1572 sky130_fd_sc_hd__dlygate4sd3_1
XTAP_863 VGND VPWR sky130_fd_sc_hd__tapvpwrvgnd_1
XTAP_885 VGND VPWR sky130_fd_sc_hd__tapvpwrvgnd_1
XTAP_874 VGND VPWR sky130_fd_sc_hd__tapvpwrvgnd_1
X_08764_ _03114_ _03116_ _03118_ _03120_ VGND VGND VPWR VPWR _03121_ sky130_fd_sc_hd__a31oi_2
Xhold1258 cpuregs\[6\]\[31\] VGND VGND VPWR VPWR net1616 sky130_fd_sc_hd__dlygate4sd3_1
Xhold1247 cpuregs\[19\]\[1\] VGND VGND VPWR VPWR net1605 sky130_fd_sc_hd__dlygate4sd3_1
Xhold1236 cpuregs\[9\]\[5\] VGND VGND VPWR VPWR net1594 sky130_fd_sc_hd__dlygate4sd3_1
XFILLER_0_32_3 VGND VGND VPWR VPWR sky130_fd_sc_hd__decap_4
XTAP_896 VGND VPWR sky130_fd_sc_hd__tapvpwrvgnd_1
Xhold1269 reg_next_pc\[18\] VGND VGND VPWR VPWR net1627 sky130_fd_sc_hd__dlygate4sd3_1
X_07715_ _02140_ VGND VGND VPWR VPWR _02141_ sky130_fd_sc_hd__buf_4
X_08695_ net181 _03056_ VGND VGND VPWR VPWR _03057_ sky130_fd_sc_hd__xnor2_1
XFILLER_0_68_808 VGND VGND VPWR VPWR sky130_fd_sc_hd__fill_1
XFILLER_0_94_115 VGND VGND VPWR VPWR sky130_fd_sc_hd__fill_1
XFILLER_0_138_729 VGND VGND VPWR VPWR sky130_fd_sc_hd__fill_1
XFILLER_0_137_206 VPWR VGND VPWR VGND sky130_ef_sc_hd__decap_12
X_09316_ _03565_ VGND VGND VPWR VPWR _00055_ sky130_fd_sc_hd__clkbuf_1
X_09247_ _03505_ VGND VGND VPWR VPWR _00046_ sky130_fd_sc_hd__clkbuf_1
XFILLER_0_35_248 VGND VGND VPWR VPWR sky130_fd_sc_hd__fill_1
XFILLER_0_36_749 VGND VGND VPWR VPWR sky130_fd_sc_hd__fill_1
XFILLER_0_90_365 VGND VGND VPWR VPWR sky130_fd_sc_hd__decap_4
XFILLER_0_50_218 VGND VGND VPWR VPWR sky130_fd_sc_hd__fill_1
X_09178_ _03445_ VGND VGND VPWR VPWR _03446_ sky130_fd_sc_hd__buf_4
X_08129_ _02497_ _02505_ _02519_ _02170_ VGND VGND VPWR VPWR _02521_ sky130_fd_sc_hd__a31o_1
XFILLER_0_43_281 VGND VGND VPWR VPWR sky130_fd_sc_hd__decap_6
XFILLER_0_113_180 VGND VGND VPWR VPWR sky130_fd_sc_hd__decap_3
X_11140_ net1117 _03635_ _05146_ VGND VGND VPWR VPWR _05156_ sky130_fd_sc_hd__mux2_1
XFILLER_0_101_320 VPWR VGND VPWR VGND sky130_ef_sc_hd__decap_12
Xoutput67 net67 VGND VGND VPWR VPWR mem_la_addr[11] sky130_fd_sc_hd__clkbuf_4
XFILLER_0_101_353 VGND VGND VPWR VPWR sky130_fd_sc_hd__fill_1
Xoutput56 net56 VGND VGND VPWR VPWR mem_addr[30] sky130_fd_sc_hd__clkbuf_4
Xoutput45 net45 VGND VGND VPWR VPWR mem_addr[20] sky130_fd_sc_hd__clkbuf_4
X_11071_ _05119_ VGND VGND VPWR VPWR _00256_ sky130_fd_sc_hd__clkbuf_1
Xoutput78 net78 VGND VGND VPWR VPWR mem_la_addr[22] sky130_fd_sc_hd__clkbuf_4
Xoutput89 net89 VGND VGND VPWR VPWR mem_la_addr[3] sky130_fd_sc_hd__clkbuf_4
X_10022_ _03677_ _04241_ _04245_ _03660_ VGND VGND VPWR VPWR _04246_ sky130_fd_sc_hd__o211a_1
X_14830_ net1254 _05221_ _01778_ VGND VGND VPWR VPWR _01788_ sky130_fd_sc_hd__mux2_1
X_14761_ _01751_ VGND VGND VPWR VPWR _01249_ sky130_fd_sc_hd__clkbuf_1
X_16500_ clknet_leaf_43_clk _01082_ VGND VGND VPWR VPWR cpuregs\[19\]\[21\] sky130_fd_sc_hd__dfxtp_1
XFILLER_0_98_465 VGND VGND VPWR VPWR sky130_fd_sc_hd__decap_3
X_11973_ _05648_ _05620_ _05649_ VGND VGND VPWR VPWR _05650_ sky130_fd_sc_hd__and3b_1
X_13712_ cpuregs\[0\]\[28\] cpuregs\[1\]\[28\] cpuregs\[2\]\[28\] cpuregs\[3\]\[28\]
+ _06344_ _06345_ VGND VGND VPWR VPWR _07183_ sky130_fd_sc_hd__mux4_1
X_14692_ net1082 _05219_ _01706_ VGND VGND VPWR VPWR _01715_ sky130_fd_sc_hd__mux2_1
X_10924_ _03615_ VGND VGND VPWR VPWR _05039_ sky130_fd_sc_hd__clkbuf_4
X_13643_ cpuregs\[8\]\[26\] cpuregs\[9\]\[26\] _03343_ VGND VGND VPWR VPWR _07116_
+ sky130_fd_sc_hd__mux2_1
X_16431_ clknet_leaf_23_clk net1413 VGND VGND VPWR VPWR decoded_imm\[16\] sky130_fd_sc_hd__dfxtp_2
X_10855_ _04992_ VGND VGND VPWR VPWR _00167_ sky130_fd_sc_hd__clkbuf_1
X_16362_ clknet_leaf_73_clk _00944_ VGND VGND VPWR VPWR cpuregs\[1\]\[27\] sky130_fd_sc_hd__dfxtp_1
X_13574_ cpuregs\[30\]\[23\] cpuregs\[31\]\[23\] _06754_ VGND VGND VPWR VPWR _07050_
+ sky130_fd_sc_hd__mux2_1
XFILLER_0_82_811 VGND VGND VPWR VPWR sky130_fd_sc_hd__fill_1
XPHY_151 VGND VGND VPWR VPWR sky130_fd_sc_hd__decap_3
XPHY_140 VGND VGND VPWR VPWR sky130_fd_sc_hd__decap_3
XPHY_184 VGND VGND VPWR VPWR sky130_fd_sc_hd__decap_3
XPHY_173 VGND VGND VPWR VPWR sky130_fd_sc_hd__decap_3
XFILLER_0_81_332 VGND VGND VPWR VPWR sky130_fd_sc_hd__decap_4
XPHY_162 VGND VGND VPWR VPWR sky130_fd_sc_hd__decap_3
XFILLER_0_5_109 VGND VGND VPWR VPWR sky130_fd_sc_hd__decap_3
X_15313_ _03451_ net1198 _02041_ VGND VGND VPWR VPWR _02043_ sky130_fd_sc_hd__mux2_1
X_12525_ count_cycle\[7\] _06110_ count_cycle\[8\] VGND VGND VPWR VPWR _06115_ sky130_fd_sc_hd__a21o_1
X_10786_ net977 _03484_ _04946_ VGND VGND VPWR VPWR _04953_ sky130_fd_sc_hd__mux2_1
XFILLER_0_136_272 VGND VGND VPWR VPWR sky130_fd_sc_hd__fill_2
XPHY_195 VGND VGND VPWR VPWR sky130_fd_sc_hd__decap_3
X_16293_ clknet_leaf_149_clk _00878_ VGND VGND VPWR VPWR instr_or sky130_fd_sc_hd__dfxtp_1
X_12456_ _06035_ _06037_ _06041_ _06047_ VGND VGND VPWR VPWR _06059_ sky130_fd_sc_hd__o211ai_2
XFILLER_0_81_387 VGND VGND VPWR VPWR sky130_fd_sc_hd__fill_2
X_15244_ _02007_ VGND VGND VPWR VPWR _01476_ sky130_fd_sc_hd__clkbuf_1
XFILLER_0_2_805 VGND VGND VPWR VPWR sky130_fd_sc_hd__decap_6
X_12387_ _05989_ _05995_ VGND VGND VPWR VPWR _05996_ sky130_fd_sc_hd__and2b_1
X_15175_ net855 _03645_ _01936_ VGND VGND VPWR VPWR _01971_ sky130_fd_sc_hd__mux2_1
X_11407_ net876 _05181_ _05313_ VGND VGND VPWR VPWR _05314_ sky130_fd_sc_hd__mux2_1
XFILLER_0_1_304 VGND VGND VPWR VPWR sky130_fd_sc_hd__fill_2
XFILLER_0_22_421 VGND VGND VPWR VPWR sky130_fd_sc_hd__decap_6
XFILLER_0_22_443 VGND VGND VPWR VPWR sky130_fd_sc_hd__decap_3
XFILLER_0_111_128 VGND VGND VPWR VPWR sky130_fd_sc_hd__fill_1
X_11338_ _05265_ VGND VGND VPWR VPWR _05277_ sky130_fd_sc_hd__buf_4
X_14126_ _05005_ net1205 _07482_ VGND VGND VPWR VPWR _07483_ sky130_fd_sc_hd__mux2_1
XFILLER_0_1_337 VGND VGND VPWR VPWR sky130_fd_sc_hd__fill_1
XFILLER_0_10_605 VGND VGND VPWR VPWR sky130_fd_sc_hd__fill_1
X_11269_ _05228_ VGND VGND VPWR VPWR _05240_ sky130_fd_sc_hd__buf_4
X_14057_ mem_rdata_q\[9\] net32 _07422_ VGND VGND VPWR VPWR _07445_ sky130_fd_sc_hd__mux2_1
XFILLER_0_94_48 VGND VGND VPWR VPWR sky130_fd_sc_hd__fill_1
X_13008_ _06500_ _02664_ _06375_ VGND VGND VPWR VPWR _06501_ sky130_fd_sc_hd__mux2_1
XFILLER_0_27_53 VGND VGND VPWR VPWR sky130_fd_sc_hd__decap_3
X_14959_ _03610_ net1322 _01851_ VGND VGND VPWR VPWR _01857_ sky130_fd_sc_hd__mux2_1
XFILLER_0_89_465 VGND VGND VPWR VPWR sky130_fd_sc_hd__fill_2
XFILLER_0_77_649 VGND VGND VPWR VPWR sky130_fd_sc_hd__fill_1
X_08480_ _02849_ _02856_ _02859_ VGND VGND VPWR VPWR alu_out\[1\] sky130_fd_sc_hd__a21o_1
XFILLER_0_49_318 VGND VGND VPWR VPWR sky130_fd_sc_hd__decap_6
XFILLER_0_134_65 VPWR VGND VPWR VGND sky130_ef_sc_hd__decap_12
XFILLER_0_58_830 VGND VGND VPWR VPWR sky130_fd_sc_hd__fill_2
X_16629_ clknet_leaf_129_clk _01196_ VGND VGND VPWR VPWR cpuregs\[23\]\[7\] sky130_fd_sc_hd__dfxtp_1
XFILLER_0_128_740 VGND VGND VPWR VPWR sky130_fd_sc_hd__decap_3
XFILLER_0_85_693 VGND VGND VPWR VPWR sky130_fd_sc_hd__fill_2
XFILLER_0_17_237 VGND VGND VPWR VPWR sky130_fd_sc_hd__fill_2
X_09101_ cpuregs\[28\]\[3\] cpuregs\[29\]\[3\] _03342_ VGND VGND VPWR VPWR _03381_
+ sky130_fd_sc_hd__mux2_1
XFILLER_0_17_248 VGND VGND VPWR VPWR sky130_fd_sc_hd__fill_1
X_09032_ _03312_ VGND VGND VPWR VPWR _03313_ sky130_fd_sc_hd__buf_6
XFILLER_0_4_120 VGND VGND VPWR VPWR sky130_fd_sc_hd__fill_1
Xhold311 cpuregs\[30\]\[25\] VGND VGND VPWR VPWR net669 sky130_fd_sc_hd__dlygate4sd3_1
Xhold300 cpuregs\[27\]\[19\] VGND VGND VPWR VPWR net658 sky130_fd_sc_hd__dlygate4sd3_1
XFILLER_0_13_432 VGND VGND VPWR VPWR sky130_fd_sc_hd__fill_1
XFILLER_0_25_281 VGND VGND VPWR VPWR sky130_fd_sc_hd__decap_4
Xhold344 net159 VGND VGND VPWR VPWR net702 sky130_fd_sc_hd__dlygate4sd3_1
Xhold333 cpuregs\[12\]\[14\] VGND VGND VPWR VPWR net691 sky130_fd_sc_hd__dlygate4sd3_1
Xhold322 cpuregs\[14\]\[9\] VGND VGND VPWR VPWR net680 sky130_fd_sc_hd__dlygate4sd3_1
Xhold377 cpuregs\[27\]\[12\] VGND VGND VPWR VPWR net735 sky130_fd_sc_hd__dlygate4sd3_1
Xhold355 cpuregs\[30\]\[3\] VGND VGND VPWR VPWR net713 sky130_fd_sc_hd__dlygate4sd3_1
Xhold366 cpuregs\[16\]\[2\] VGND VGND VPWR VPWR net724 sky130_fd_sc_hd__dlygate4sd3_1
Xhold399 cpuregs\[6\]\[16\] VGND VGND VPWR VPWR net757 sky130_fd_sc_hd__dlygate4sd3_1
X_09934_ _02310_ _02416_ _03650_ VGND VGND VPWR VPWR _04160_ sky130_fd_sc_hd__mux2_1
Xhold388 cpuregs\[25\]\[12\] VGND VGND VPWR VPWR net746 sky130_fd_sc_hd__dlygate4sd3_1
XFILLER_0_110_194 VGND VGND VPWR VPWR sky130_fd_sc_hd__fill_2
Xhold1000 cpuregs\[21\]\[16\] VGND VGND VPWR VPWR net1358 sky130_fd_sc_hd__dlygate4sd3_1
XTAP_660 VGND VPWR sky130_fd_sc_hd__tapvpwrvgnd_1
X_09865_ cpuregs\[0\]\[8\] cpuregs\[1\]\[8\] _03980_ VGND VGND VPWR VPWR _04093_ sky130_fd_sc_hd__mux2_1
X_08816_ net222 _03157_ VGND VGND VPWR VPWR _03169_ sky130_fd_sc_hd__or2_1
Xhold1022 cpuregs\[8\]\[21\] VGND VGND VPWR VPWR net1380 sky130_fd_sc_hd__dlygate4sd3_1
Xhold1033 cpuregs\[4\]\[18\] VGND VGND VPWR VPWR net1391 sky130_fd_sc_hd__dlygate4sd3_1
Xhold1011 cpuregs\[7\]\[31\] VGND VGND VPWR VPWR net1369 sky130_fd_sc_hd__dlygate4sd3_1
XTAP_671 VGND VPWR sky130_fd_sc_hd__tapvpwrvgnd_1
XTAP_693 VGND VPWR sky130_fd_sc_hd__tapvpwrvgnd_1
XTAP_682 VGND VPWR sky130_fd_sc_hd__tapvpwrvgnd_1
Xhold1044 cpuregs\[8\]\[25\] VGND VGND VPWR VPWR net1402 sky130_fd_sc_hd__dlygate4sd3_1
Xhold1055 _01013_ VGND VGND VPWR VPWR net1413 sky130_fd_sc_hd__dlygate4sd3_1
XFILLER_0_84_70 VGND VGND VPWR VPWR sky130_fd_sc_hd__fill_2
X_09796_ cpuregs\[24\]\[6\] cpuregs\[25\]\[6\] cpuregs\[26\]\[6\] cpuregs\[27\]\[6\]
+ _03935_ _03936_ VGND VGND VPWR VPWR _04026_ sky130_fd_sc_hd__mux4_1
Xhold1066 cpuregs\[13\]\[9\] VGND VGND VPWR VPWR net1424 sky130_fd_sc_hd__dlygate4sd3_1
X_08747_ _03088_ _03097_ _03104_ VGND VGND VPWR VPWR _03105_ sky130_fd_sc_hd__a21oi_1
XFILLER_0_68_605 VGND VGND VPWR VPWR sky130_fd_sc_hd__fill_2
Xhold1099 cpuregs\[8\]\[2\] VGND VGND VPWR VPWR net1457 sky130_fd_sc_hd__dlygate4sd3_1
Xhold1077 cpuregs\[17\]\[4\] VGND VGND VPWR VPWR net1435 sky130_fd_sc_hd__dlygate4sd3_1
Xhold1088 cpuregs\[22\]\[3\] VGND VGND VPWR VPWR net1446 sky130_fd_sc_hd__dlygate4sd3_1
X_08678_ _02714_ _03033_ _03041_ _03020_ VGND VGND VPWR VPWR alu_out\[17\] sky130_fd_sc_hd__a22o_1
XTAP_1815 VGND VPWR sky130_fd_sc_hd__tapvpwrvgnd_1
XTAP_1804 VGND VPWR sky130_fd_sc_hd__tapvpwrvgnd_1
XTAP_1848 VGND VPWR sky130_fd_sc_hd__tapvpwrvgnd_1
XTAP_1826 VGND VPWR sky130_fd_sc_hd__tapvpwrvgnd_1
XTAP_1837 VGND VPWR sky130_fd_sc_hd__tapvpwrvgnd_1
XFILLER_0_138_559 VGND VGND VPWR VPWR sky130_fd_sc_hd__fill_2
X_10640_ cpuregs\[0\]\[29\] cpuregs\[1\]\[29\] _03824_ VGND VGND VPWR VPWR _04847_
+ sky130_fd_sc_hd__mux2_1
XTAP_1859 VGND VPWR sky130_fd_sc_hd__tapvpwrvgnd_1
X_10571_ _04127_ _04777_ _04779_ VGND VGND VPWR VPWR _04780_ sky130_fd_sc_hd__a21o_1
XFILLER_0_36_557 VGND VGND VPWR VPWR sky130_fd_sc_hd__fill_2
XFILLER_0_133_231 VPWR VGND VPWR VGND sky130_ef_sc_hd__decap_12
X_12310_ decoded_imm_j\[14\] _05720_ VGND VGND VPWR VPWR _05925_ sky130_fd_sc_hd__nor2_1
X_13290_ cpuregs\[6\]\[15\] cpuregs\[7\]\[15\] _06511_ VGND VGND VPWR VPWR _06774_
+ sky130_fd_sc_hd__mux2_1
XFILLER_0_23_218 VGND VGND VPWR VPWR sky130_fd_sc_hd__fill_1
XFILLER_0_106_489 VPWR VGND VPWR VGND sky130_ef_sc_hd__decap_12
X_12241_ _05710_ _05848_ VGND VGND VPWR VPWR _05862_ sky130_fd_sc_hd__nand2_1
XFILLER_0_121_459 VGND VGND VPWR VPWR sky130_fd_sc_hd__decap_8
XFILLER_0_102_662 VGND VGND VPWR VPWR sky130_fd_sc_hd__fill_2
X_12172_ _05778_ _05781_ _05795_ VGND VGND VPWR VPWR _05798_ sky130_fd_sc_hd__a21bo_1
XFILLER_0_48_19 VGND VGND VPWR VPWR sky130_fd_sc_hd__fill_1
X_11123_ _05147_ VGND VGND VPWR VPWR _00280_ sky130_fd_sc_hd__clkbuf_1
X_11054_ net599 _03577_ _05110_ VGND VGND VPWR VPWR _05111_ sky130_fd_sc_hd__mux2_1
X_15931_ clknet_leaf_3_clk _00581_ VGND VGND VPWR VPWR count_instr\[0\] sky130_fd_sc_hd__dfxtp_1
X_10005_ _04187_ _04227_ _04228_ VGND VGND VPWR VPWR _04229_ sky130_fd_sc_hd__nand3_1
X_15862_ clknet_leaf_65_clk _00512_ VGND VGND VPWR VPWR cpuregs\[25\]\[28\] sky130_fd_sc_hd__dfxtp_1
X_15793_ clknet_leaf_45_clk _00443_ VGND VGND VPWR VPWR cpuregs\[26\]\[23\] sky130_fd_sc_hd__dfxtp_1
X_14813_ _01779_ VGND VGND VPWR VPWR _01273_ sky130_fd_sc_hd__clkbuf_1
X_14744_ _05026_ net1485 _01742_ VGND VGND VPWR VPWR _01743_ sky130_fd_sc_hd__mux2_1
X_11956_ count_instr\[43\] count_instr\[42\] count_instr\[41\] _05628_ VGND VGND VPWR
+ VPWR _05637_ sky130_fd_sc_hd__and4_1
X_10907_ _05026_ net1145 _05027_ VGND VGND VPWR VPWR _05028_ sky130_fd_sc_hd__mux2_1
X_14675_ _01683_ VGND VGND VPWR VPWR _01706_ sky130_fd_sc_hd__buf_4
X_11887_ _05587_ VGND VGND VPWR VPWR _00604_ sky130_fd_sc_hd__clkbuf_1
X_16414_ clknet_leaf_14_clk _00996_ VGND VGND VPWR VPWR reg_sh\[0\] sky130_fd_sc_hd__dfxtp_1
X_13626_ cpuregs\[16\]\[25\] cpuregs\[17\]\[25\] cpuregs\[18\]\[25\] cpuregs\[19\]\[25\]
+ _06945_ _06979_ VGND VGND VPWR VPWR _07100_ sky130_fd_sc_hd__mux4_1
X_10838_ net1394 _03646_ _04945_ VGND VGND VPWR VPWR _04980_ sky130_fd_sc_hd__mux2_1
XFILLER_0_6_407 VGND VGND VPWR VPWR sky130_fd_sc_hd__decap_3
X_13557_ _06866_ _07028_ _07032_ _06873_ VGND VGND VPWR VPWR _07033_ sky130_fd_sc_hd__o211a_1
XFILLER_0_54_354 VGND VGND VPWR VPWR sky130_fd_sc_hd__fill_1
X_10769_ _04902_ _04900_ _04901_ VGND VGND VPWR VPWR _04942_ sky130_fd_sc_hd__nand3_2
X_16345_ clknet_leaf_109_clk _00927_ VGND VGND VPWR VPWR cpuregs\[1\]\[10\] sky130_fd_sc_hd__dfxtp_1
X_13488_ _06699_ _06965_ _06667_ VGND VGND VPWR VPWR _06966_ sky130_fd_sc_hd__a21o_1
XFILLER_0_89_48 VGND VGND VPWR VPWR sky130_fd_sc_hd__fill_1
XFILLER_0_81_162 VGND VGND VPWR VPWR sky130_fd_sc_hd__fill_1
X_12508_ _06103_ VGND VGND VPWR VPWR _00709_ sky130_fd_sc_hd__clkbuf_1
X_16276_ clknet_leaf_149_clk _00861_ VGND VGND VPWR VPWR instr_addi sky130_fd_sc_hd__dfxtp_1
XFILLER_0_120_56 VGND VGND VPWR VPWR sky130_fd_sc_hd__fill_1
X_12439_ _05792_ _06034_ _06042_ _06043_ _05520_ VGND VGND VPWR VPWR _06044_ sky130_fd_sc_hd__o221a_1
X_15227_ _03597_ net940 _01995_ VGND VGND VPWR VPWR _01999_ sky130_fd_sc_hd__mux2_1
XFILLER_0_23_752 VGND VGND VPWR VPWR sky130_fd_sc_hd__fill_2
XFILLER_0_50_560 VGND VGND VPWR VPWR sky130_fd_sc_hd__fill_1
XFILLER_0_22_251 VGND VGND VPWR VPWR sky130_fd_sc_hd__fill_1
X_15158_ _01962_ VGND VGND VPWR VPWR _01435_ sky130_fd_sc_hd__clkbuf_1
XFILLER_0_66_9 VGND VGND VPWR VPWR sky130_fd_sc_hd__fill_1
X_15089_ net905 _05207_ _01923_ VGND VGND VPWR VPWR _01926_ sky130_fd_sc_hd__mux2_1
X_07980_ _02197_ _02377_ _02381_ VGND VGND VPWR VPWR _02382_ sky130_fd_sc_hd__a21oi_1
X_14109_ _04989_ net1389 _07471_ VGND VGND VPWR VPWR _07474_ sky130_fd_sc_hd__mux2_1
XFILLER_0_129_54 VGND VGND VPWR VPWR sky130_fd_sc_hd__fill_2
X_09650_ _03868_ _03882_ _03731_ VGND VGND VPWR VPWR _03883_ sky130_fd_sc_hd__a21o_1
X_08601_ _02681_ _02962_ _02970_ _02849_ VGND VGND VPWR VPWR alu_out\[11\] sky130_fd_sc_hd__a22o_1
X_09581_ _03662_ _03808_ _03814_ VGND VGND VPWR VPWR _03815_ sky130_fd_sc_hd__o21ba_1
X_08532_ net250 net251 VGND VGND VPWR VPWR _02907_ sky130_fd_sc_hd__or2_1
X_08463_ _02215_ _02751_ VGND VGND VPWR VPWR _02844_ sky130_fd_sc_hd__or2_1
XFILLER_0_49_126 VGND VGND VPWR VPWR sky130_fd_sc_hd__fill_1
XFILLER_0_9_234 VGND VGND VPWR VPWR sky130_fd_sc_hd__fill_1
X_08394_ net184 _02773_ _02774_ net183 VGND VGND VPWR VPWR _02775_ sky130_fd_sc_hd__o22a_1
XFILLER_0_92_438 VGND VGND VPWR VPWR sky130_fd_sc_hd__fill_2
XFILLER_0_45_321 VGND VGND VPWR VPWR sky130_fd_sc_hd__fill_1
XFILLER_0_18_524 VGND VGND VPWR VPWR sky130_fd_sc_hd__fill_1
XFILLER_0_70_83 VGND VGND VPWR VPWR sky130_fd_sc_hd__fill_1
XFILLER_0_57_192 VGND VGND VPWR VPWR sky130_fd_sc_hd__fill_1
Xclkbuf_leaf_30_clk clknet_4_4_0_clk VGND VGND VPWR VPWR clknet_leaf_30_clk sky130_fd_sc_hd__clkbuf_16
XFILLER_0_103_404 VGND VGND VPWR VPWR sky130_fd_sc_hd__fill_2
X_09015_ _03301_ VGND VGND VPWR VPWR _00034_ sky130_fd_sc_hd__clkbuf_1
XFILLER_0_115_297 VGND VGND VPWR VPWR sky130_fd_sc_hd__decap_6
Xhold141 net36 VGND VGND VPWR VPWR net499 sky130_fd_sc_hd__dlygate4sd3_1
Xhold130 cpuregs\[0\]\[11\] VGND VGND VPWR VPWR net488 sky130_fd_sc_hd__dlygate4sd3_1
Xhold152 cpuregs\[0\]\[5\] VGND VGND VPWR VPWR net510 sky130_fd_sc_hd__dlygate4sd3_1
Xhold185 net64 VGND VGND VPWR VPWR net543 sky130_fd_sc_hd__dlygate4sd3_1
XFILLER_0_130_289 VGND VGND VPWR VPWR sky130_fd_sc_hd__decap_8
Xhold163 count_instr\[1\] VGND VGND VPWR VPWR net521 sky130_fd_sc_hd__dlygate4sd3_1
Xhold174 cpuregs\[0\]\[10\] VGND VGND VPWR VPWR net532 sky130_fd_sc_hd__dlygate4sd3_1
Xhold196 net146 VGND VGND VPWR VPWR net554 sky130_fd_sc_hd__dlygate4sd3_1
X_09917_ _03834_ _04141_ _04143_ VGND VGND VPWR VPWR _04144_ sky130_fd_sc_hd__a21o_1
Xclkbuf_leaf_97_clk clknet_4_9_0_clk VGND VGND VPWR VPWR clknet_leaf_97_clk sky130_fd_sc_hd__clkbuf_16
X_09848_ _04076_ VGND VGND VPWR VPWR _00076_ sky130_fd_sc_hd__clkbuf_1
XTAP_490 VGND VPWR sky130_fd_sc_hd__tapvpwrvgnd_1
XTAP_2302 VGND VPWR sky130_fd_sc_hd__tapvpwrvgnd_1
X_09779_ _02152_ _04007_ _04008_ VGND VGND VPWR VPWR _04009_ sky130_fd_sc_hd__or3_1
XTAP_2335 VGND VPWR sky130_fd_sc_hd__tapvpwrvgnd_1
XTAP_2324 VGND VPWR sky130_fd_sc_hd__tapvpwrvgnd_1
XTAP_2313 VGND VPWR sky130_fd_sc_hd__tapvpwrvgnd_1
XFILLER_0_96_722 VGND VGND VPWR VPWR sky130_fd_sc_hd__decap_4
X_12790_ _06309_ VGND VGND VPWR VPWR _00785_ sky130_fd_sc_hd__clkbuf_1
X_11810_ count_instr\[2\] _05525_ count_instr\[3\] VGND VGND VPWR VPWR _05531_ sky130_fd_sc_hd__a21o_1
XTAP_2346 VGND VPWR sky130_fd_sc_hd__tapvpwrvgnd_1
XFILLER_0_139_824 VGND VGND VPWR VPWR sky130_fd_sc_hd__fill_2
XTAP_1623 VGND VPWR sky130_fd_sc_hd__tapvpwrvgnd_1
XTAP_1612 VGND VPWR sky130_fd_sc_hd__tapvpwrvgnd_1
XTAP_1601 VGND VPWR sky130_fd_sc_hd__tapvpwrvgnd_1
X_11741_ _04999_ net1224 _05483_ VGND VGND VPWR VPWR _05491_ sky130_fd_sc_hd__mux2_1
XTAP_1667 VGND VPWR sky130_fd_sc_hd__tapvpwrvgnd_1
XTAP_1656 VGND VPWR sky130_fd_sc_hd__tapvpwrvgnd_1
XTAP_1634 VGND VPWR sky130_fd_sc_hd__tapvpwrvgnd_1
XTAP_1645 VGND VPWR sky130_fd_sc_hd__tapvpwrvgnd_1
XFILLER_0_83_405 VGND VGND VPWR VPWR sky130_fd_sc_hd__decap_4
XFILLER_0_49_671 VGND VGND VPWR VPWR sky130_fd_sc_hd__fill_1
XTAP_1689 VGND VPWR sky130_fd_sc_hd__tapvpwrvgnd_1
XTAP_1678 VGND VPWR sky130_fd_sc_hd__tapvpwrvgnd_1
X_14460_ _01592_ VGND VGND VPWR VPWR _01075_ sky130_fd_sc_hd__clkbuf_1
XFILLER_0_55_118 VGND VGND VPWR VPWR sky130_fd_sc_hd__decap_8
X_11672_ _05454_ VGND VGND VPWR VPWR _00522_ sky130_fd_sc_hd__clkbuf_1
XFILLER_0_37_822 VGND VGND VPWR VPWR sky130_fd_sc_hd__fill_2
X_10623_ _04795_ _04796_ _04797_ VGND VGND VPWR VPWR _04830_ sky130_fd_sc_hd__o21ai_1
XFILLER_0_107_721 VGND VGND VPWR VPWR sky130_fd_sc_hd__fill_1
X_13411_ cpuregs\[30\]\[18\] cpuregs\[31\]\[18\] _06754_ VGND VGND VPWR VPWR _06892_
+ sky130_fd_sc_hd__mux2_1
X_14391_ _05014_ net1280 _01551_ VGND VGND VPWR VPWR _01556_ sky130_fd_sc_hd__mux2_1
XFILLER_0_64_641 VGND VGND VPWR VPWR sky130_fd_sc_hd__decap_3
X_10554_ cpuregs\[4\]\[27\] cpuregs\[5\]\[27\] cpuregs\[6\]\[27\] cpuregs\[7\]\[27\]
+ _03864_ _03820_ VGND VGND VPWR VPWR _04763_ sky130_fd_sc_hd__mux4_1
Xclkbuf_leaf_21_clk clknet_4_6_0_clk VGND VGND VPWR VPWR clknet_leaf_21_clk sky130_fd_sc_hd__clkbuf_16
X_13342_ cpuregs\[24\]\[16\] cpuregs\[25\]\[16\] cpuregs\[26\]\[16\] cpuregs\[27\]\[16\]
+ _06525_ _06558_ VGND VGND VPWR VPWR _06825_ sky130_fd_sc_hd__mux4_1
X_16130_ clknet_leaf_11_clk _07648_ VGND VGND VPWR VPWR reg_out\[8\] sky130_fd_sc_hd__dfxtp_1
XFILLER_0_24_527 VGND VGND VPWR VPWR sky130_fd_sc_hd__fill_1
XFILLER_0_106_253 VGND VGND VPWR VPWR sky130_fd_sc_hd__fill_2
XFILLER_0_122_735 VGND VGND VPWR VPWR sky130_fd_sc_hd__decap_3
X_10485_ _03738_ _04691_ _04695_ _03684_ VGND VGND VPWR VPWR _04696_ sky130_fd_sc_hd__o211a_1
X_13273_ _06751_ _06752_ _06757_ _06466_ VGND VGND VPWR VPWR _06758_ sky130_fd_sc_hd__o211a_1
XFILLER_0_51_357 VGND VGND VPWR VPWR sky130_fd_sc_hd__fill_1
X_16061_ clknet_leaf_149_clk _00711_ VGND VGND VPWR VPWR count_cycle\[4\] sky130_fd_sc_hd__dfxtp_1
X_15012_ _03564_ net1036 _01876_ VGND VGND VPWR VPWR _01885_ sky130_fd_sc_hd__mux2_1
X_12224_ reg_next_pc\[8\] _03224_ _05845_ VGND VGND VPWR VPWR _05846_ sky130_fd_sc_hd__a21oi_1
X_12155_ _05772_ VGND VGND VPWR VPWR _05782_ sky130_fd_sc_hd__inv_2
X_11106_ _05138_ VGND VGND VPWR VPWR _00272_ sky130_fd_sc_hd__clkbuf_1
X_12086_ _02141_ VGND VGND VPWR VPWR _05730_ sky130_fd_sc_hd__clkbuf_4
X_16963_ clknet_leaf_84_clk _01527_ VGND VGND VPWR VPWR cpuregs\[10\]\[18\] sky130_fd_sc_hd__dfxtp_1
Xclkbuf_leaf_88_clk clknet_4_14_0_clk VGND VGND VPWR VPWR clknet_leaf_88_clk sky130_fd_sc_hd__clkbuf_16
X_15914_ clknet_leaf_19_clk _00564_ VGND VGND VPWR VPWR cpuregs\[17\]\[16\] sky130_fd_sc_hd__dfxtp_1
X_11037_ net604 _03525_ _05099_ VGND VGND VPWR VPWR _05102_ sky130_fd_sc_hd__mux2_1
X_16894_ clknet_leaf_104_clk _01458_ VGND VGND VPWR VPWR cpuregs\[8\]\[13\] sky130_fd_sc_hd__dfxtp_1
X_15845_ clknet_leaf_132_clk _00495_ VGND VGND VPWR VPWR cpuregs\[25\]\[11\] sky130_fd_sc_hd__dfxtp_1
XFILLER_0_91_27 VGND VGND VPWR VPWR sky130_fd_sc_hd__fill_1
XFILLER_0_115_45 VGND VGND VPWR VPWR sky130_fd_sc_hd__fill_2
X_15776_ clknet_leaf_144_clk _00426_ VGND VGND VPWR VPWR cpuregs\[26\]\[6\] sky130_fd_sc_hd__dfxtp_1
X_12988_ cpuregs\[6\]\[6\] cpuregs\[7\]\[6\] _06386_ VGND VGND VPWR VPWR _06481_ sky130_fd_sc_hd__mux2_1
XFILLER_0_115_67 VGND VGND VPWR VPWR sky130_fd_sc_hd__decap_3
X_14727_ _05010_ net1150 _01731_ VGND VGND VPWR VPWR _01734_ sky130_fd_sc_hd__mux2_1
X_11939_ net457 _05619_ _05624_ VGND VGND VPWR VPWR _00619_ sky130_fd_sc_hd__o21a_1
XFILLER_0_138_3 VGND VGND VPWR VPWR sky130_fd_sc_hd__fill_2
X_14658_ _01697_ VGND VGND VPWR VPWR _01200_ sky130_fd_sc_hd__clkbuf_1
XFILLER_0_131_11 VGND VGND VPWR VPWR sky130_fd_sc_hd__fill_2
X_13609_ _06762_ _07070_ _07083_ _06802_ decoded_imm\[24\] VGND VGND VPWR VPWR _07084_
+ sky130_fd_sc_hd__a32o_1
XFILLER_0_7_738 VGND VGND VPWR VPWR sky130_fd_sc_hd__fill_2
XFILLER_0_7_727 VGND VGND VPWR VPWR sky130_fd_sc_hd__fill_1
XFILLER_0_27_332 VGND VGND VPWR VPWR sky130_fd_sc_hd__decap_4
XFILLER_0_39_181 VPWR VGND VPWR VGND sky130_ef_sc_hd__decap_12
Xclkbuf_leaf_12_clk clknet_4_1_0_clk VGND VGND VPWR VPWR clknet_leaf_12_clk sky130_fd_sc_hd__clkbuf_16
X_14589_ _05008_ net1401 _01659_ VGND VGND VPWR VPWR _01661_ sky130_fd_sc_hd__mux2_1
XFILLER_0_15_505 VGND VGND VPWR VPWR sky130_fd_sc_hd__decap_4
XFILLER_0_27_365 VGND VGND VPWR VPWR sky130_fd_sc_hd__fill_2
X_16328_ clknet_leaf_3_clk _00912_ VGND VGND VPWR VPWR is_slli_srli_srai sky130_fd_sc_hd__dfxtp_2
XFILLER_0_131_77 VGND VGND VPWR VPWR sky130_fd_sc_hd__decap_4
XFILLER_0_125_595 VGND VGND VPWR VPWR sky130_fd_sc_hd__fill_1
X_16259_ clknet_leaf_2_clk _00844_ VGND VGND VPWR VPWR instr_lui sky130_fd_sc_hd__dfxtp_1
Xoutput235 net235 VGND VGND VPWR VPWR trap sky130_fd_sc_hd__clkbuf_4
Xoutput202 net202 VGND VGND VPWR VPWR pcpi_rs1[9] sky130_fd_sc_hd__clkbuf_4
Xoutput213 net213 VGND VGND VPWR VPWR pcpi_rs2[19] sky130_fd_sc_hd__clkbuf_4
Xoutput224 net224 VGND VGND VPWR VPWR pcpi_rs2[29] sky130_fd_sc_hd__clkbuf_4
Xclkbuf_leaf_79_clk clknet_4_15_0_clk VGND VGND VPWR VPWR clknet_leaf_79_clk sky130_fd_sc_hd__clkbuf_16
X_07963_ net172 VGND VGND VPWR VPWR _02366_ sky130_fd_sc_hd__buf_2
X_09702_ cpuregs\[0\]\[4\] cpuregs\[1\]\[4\] cpuregs\[2\]\[4\] cpuregs\[3\]\[4\] _03865_
+ _03727_ VGND VGND VPWR VPWR _03934_ sky130_fd_sc_hd__mux4_1
X_07894_ count_instr\[38\] _02269_ _02268_ _02300_ VGND VGND VPWR VPWR _02301_ sky130_fd_sc_hd__a211o_1
XFILLER_0_97_508 VGND VGND VPWR VPWR sky130_fd_sc_hd__decap_3
XFILLER_0_65_72 VGND VGND VPWR VPWR sky130_fd_sc_hd__fill_1
X_09633_ cpuregs\[8\]\[3\] cpuregs\[9\]\[3\] cpuregs\[10\]\[3\] cpuregs\[11\]\[3\]
+ _03865_ _03727_ VGND VGND VPWR VPWR _03866_ sky130_fd_sc_hd__mux4_1
X_09564_ _03797_ VGND VGND VPWR VPWR _03798_ sky130_fd_sc_hd__buf_8
XFILLER_0_77_221 VGND VGND VPWR VPWR sky130_fd_sc_hd__decap_3
X_08515_ _02883_ _02877_ _02889_ VGND VGND VPWR VPWR _02892_ sky130_fd_sc_hd__nand3_1
X_09495_ _00014_ VGND VGND VPWR VPWR _03730_ sky130_fd_sc_hd__buf_4
X_08446_ _02760_ _02761_ _02826_ VGND VGND VPWR VPWR _02827_ sky130_fd_sc_hd__or3_4
XFILLER_0_78_799 VGND VGND VPWR VPWR sky130_fd_sc_hd__fill_1
X_08377_ _02756_ _02757_ VGND VGND VPWR VPWR _02758_ sky130_fd_sc_hd__nand2_1
XFILLER_0_135_337 VGND VGND VPWR VPWR sky130_fd_sc_hd__decap_6
XFILLER_0_92_279 VGND VGND VPWR VPWR sky130_fd_sc_hd__decap_3
XFILLER_0_18_365 VGND VGND VPWR VPWR sky130_fd_sc_hd__decap_3
XFILLER_0_104_757 VGND VGND VPWR VPWR sky130_fd_sc_hd__fill_1
XFILLER_0_131_576 VGND VGND VPWR VPWR sky130_fd_sc_hd__decap_8
X_10270_ cpuregs\[2\]\[19\] cpuregs\[3\]\[19\] _04194_ VGND VGND VPWR VPWR _04487_
+ sky130_fd_sc_hd__mux2_1
XFILLER_0_14_571 VGND VGND VPWR VPWR sky130_fd_sc_hd__decap_8
XFILLER_0_103_278 VGND VGND VPWR VPWR sky130_fd_sc_hd__fill_2
XFILLER_0_41_390 VGND VGND VPWR VPWR sky130_fd_sc_hd__fill_2
X_13960_ _07377_ _07385_ VGND VGND VPWR VPWR _07386_ sky130_fd_sc_hd__and2_1
X_12911_ decoded_imm\[2\] _03361_ _02171_ VGND VGND VPWR VPWR _06408_ sky130_fd_sc_hd__mux2_1
XTAP_2110 VGND VPWR sky130_fd_sc_hd__tapvpwrvgnd_1
X_15630_ clknet_leaf_59_clk _00280_ VGND VGND VPWR VPWR cpuregs\[31\]\[20\] sky130_fd_sc_hd__dfxtp_1
X_13891_ _07332_ _07340_ VGND VGND VPWR VPWR _07341_ sky130_fd_sc_hd__and2_1
XTAP_2143 VGND VPWR sky130_fd_sc_hd__tapvpwrvgnd_1
XTAP_2121 VGND VPWR sky130_fd_sc_hd__tapvpwrvgnd_1
XTAP_2132 VGND VPWR sky130_fd_sc_hd__tapvpwrvgnd_1
X_12842_ _03357_ VGND VGND VPWR VPWR _06341_ sky130_fd_sc_hd__buf_4
XTAP_2176 VGND VPWR sky130_fd_sc_hd__tapvpwrvgnd_1
XTAP_2165 VGND VPWR sky130_fd_sc_hd__tapvpwrvgnd_1
XTAP_2154 VGND VPWR sky130_fd_sc_hd__tapvpwrvgnd_1
X_12773_ _06300_ VGND VGND VPWR VPWR _00777_ sky130_fd_sc_hd__clkbuf_1
X_15561_ clknet_leaf_82_clk _00211_ VGND VGND VPWR VPWR cpuregs\[2\]\[15\] sky130_fd_sc_hd__dfxtp_1
XTAP_1442 VGND VPWR sky130_fd_sc_hd__tapvpwrvgnd_1
XTAP_1431 VGND VPWR sky130_fd_sc_hd__tapvpwrvgnd_1
XTAP_1420 VGND VPWR sky130_fd_sc_hd__tapvpwrvgnd_1
XTAP_2198 VGND VPWR sky130_fd_sc_hd__tapvpwrvgnd_1
XTAP_2187 VGND VPWR sky130_fd_sc_hd__tapvpwrvgnd_1
XFILLER_0_84_725 VGND VGND VPWR VPWR sky130_fd_sc_hd__decap_4
XTAP_1475 VGND VPWR sky130_fd_sc_hd__tapvpwrvgnd_1
XTAP_1453 VGND VPWR sky130_fd_sc_hd__tapvpwrvgnd_1
XTAP_1464 VGND VPWR sky130_fd_sc_hd__tapvpwrvgnd_1
X_11724_ _05481_ VGND VGND VPWR VPWR _00547_ sky130_fd_sc_hd__clkbuf_1
X_15492_ clknet_leaf_134_clk _00142_ VGND VGND VPWR VPWR cpuregs\[30\]\[10\] sky130_fd_sc_hd__dfxtp_1
XFILLER_0_28_129 VGND VGND VPWR VPWR sky130_fd_sc_hd__decap_4
X_14512_ net797 _05175_ _01612_ VGND VGND VPWR VPWR _01620_ sky130_fd_sc_hd__mux2_1
XFILLER_0_124_9 VGND VGND VPWR VPWR sky130_fd_sc_hd__fill_2
XTAP_1497 VGND VPWR sky130_fd_sc_hd__tapvpwrvgnd_1
XTAP_1486 VGND VPWR sky130_fd_sc_hd__tapvpwrvgnd_1
X_11655_ _05049_ net1047 _05410_ VGND VGND VPWR VPWR _05445_ sky130_fd_sc_hd__mux2_1
X_14443_ _01583_ VGND VGND VPWR VPWR _01067_ sky130_fd_sc_hd__clkbuf_1
XFILLER_0_24_302 VGND VGND VPWR VPWR sky130_fd_sc_hd__decap_6
X_10606_ cpuregs\[22\]\[28\] cpuregs\[23\]\[28\] _03755_ VGND VGND VPWR VPWR _04814_
+ sky130_fd_sc_hd__mux2_1
X_11586_ _05408_ VGND VGND VPWR VPWR _00482_ sky130_fd_sc_hd__clkbuf_1
XFILLER_0_91_290 VGND VGND VPWR VPWR sky130_fd_sc_hd__fill_2
XFILLER_0_3_218 VGND VGND VPWR VPWR sky130_fd_sc_hd__fill_1
X_14374_ _04997_ net1530 _07616_ VGND VGND VPWR VPWR _01547_ sky130_fd_sc_hd__mux2_1
X_10537_ _03690_ _04746_ _03959_ VGND VGND VPWR VPWR _04747_ sky130_fd_sc_hd__o21a_1
XFILLER_0_101_36 VGND VGND VPWR VPWR sky130_fd_sc_hd__fill_2
X_13325_ _06699_ _06807_ _06667_ VGND VGND VPWR VPWR _06808_ sky130_fd_sc_hd__a21o_1
XFILLER_0_10_45 VGND VGND VPWR VPWR sky130_fd_sc_hd__decap_3
X_16113_ clknet_leaf_154_clk _00763_ VGND VGND VPWR VPWR count_cycle\[56\] sky130_fd_sc_hd__dfxtp_1
X_16044_ clknet_leaf_29_clk _00694_ VGND VGND VPWR VPWR reg_next_pc\[19\] sky130_fd_sc_hd__dfxtp_1
X_10468_ _03364_ _04679_ VGND VGND VPWR VPWR _04680_ sky130_fd_sc_hd__or2_1
X_13256_ cpuregs\[0\]\[14\] cpuregs\[1\]\[14\] cpuregs\[2\]\[14\] cpuregs\[3\]\[14\]
+ _06740_ _06708_ VGND VGND VPWR VPWR _06741_ sky130_fd_sc_hd__mux4_1
XFILLER_0_110_727 VGND VGND VPWR VPWR sky130_fd_sc_hd__fill_1
X_12207_ decoded_imm_j\[6\] _05704_ VGND VGND VPWR VPWR _05830_ sky130_fd_sc_hd__and2_1
X_10399_ decoded_imm\[23\] net186 VGND VGND VPWR VPWR _04612_ sky130_fd_sc_hd__nand2_1
X_13187_ _06434_ _06673_ VGND VGND VPWR VPWR _06674_ sky130_fd_sc_hd__and2_1
XFILLER_0_20_585 VGND VGND VPWR VPWR sky130_fd_sc_hd__decap_3
X_12138_ _05689_ _05765_ _05687_ VGND VGND VPWR VPWR _05767_ sky130_fd_sc_hd__a21o_1
XFILLER_0_19_43 VGND VGND VPWR VPWR sky130_fd_sc_hd__fill_1
X_12069_ _05696_ net1653 _05697_ _05717_ VGND VGND VPWR VPWR _00656_ sky130_fd_sc_hd__o211a_1
X_16946_ clknet_leaf_123_clk _01510_ VGND VGND VPWR VPWR cpuregs\[10\]\[1\] sky130_fd_sc_hd__dfxtp_1
Xclkbuf_leaf_1_clk clknet_4_0_0_clk VGND VGND VPWR VPWR clknet_leaf_1_clk sky130_fd_sc_hd__clkbuf_16
X_16877_ clknet_leaf_65_clk _01441_ VGND VGND VPWR VPWR cpuregs\[22\]\[28\] sky130_fd_sc_hd__dfxtp_1
X_15828_ clknet_leaf_44_clk _00478_ VGND VGND VPWR VPWR cpuregs\[16\]\[26\] sky130_fd_sc_hd__dfxtp_1
XFILLER_0_35_64 VGND VGND VPWR VPWR sky130_fd_sc_hd__decap_4
XFILLER_0_35_75 VGND VGND VPWR VPWR sky130_fd_sc_hd__fill_2
X_15759_ clknet_leaf_79_clk _00409_ VGND VGND VPWR VPWR cpuregs\[15\]\[21\] sky130_fd_sc_hd__dfxtp_1
XFILLER_0_35_86 VGND VGND VPWR VPWR sky130_fd_sc_hd__decap_3
X_09280_ reg_pc\[14\] _03529_ VGND VGND VPWR VPWR _03534_ sky130_fd_sc_hd__and2_1
X_08300_ net173 net205 VGND VGND VPWR VPWR _02681_ sky130_fd_sc_hd__or2_1
XFILLER_0_75_747 VGND VGND VPWR VPWR sky130_fd_sc_hd__decap_4
XFILLER_0_59_298 VGND VGND VPWR VPWR sky130_fd_sc_hd__decap_8
XFILLER_0_129_164 VGND VGND VPWR VPWR sky130_fd_sc_hd__decap_4
X_08231_ reg_pc\[28\] decoded_imm\[28\] VGND VGND VPWR VPWR _02616_ sky130_fd_sc_hd__nand2_1
XFILLER_0_129_197 VGND VGND VPWR VPWR sky130_fd_sc_hd__decap_8
XFILLER_0_117_337 VGND VGND VPWR VPWR sky130_fd_sc_hd__decap_6
XFILLER_0_16_825 VGND VGND VPWR VPWR sky130_fd_sc_hd__decap_4
X_08162_ count_cycle\[23\] _02454_ _02551_ VGND VGND VPWR VPWR _02552_ sky130_fd_sc_hd__a21o_2
X_08093_ reg_pc\[19\] decoded_imm\[19\] VGND VGND VPWR VPWR _02487_ sky130_fd_sc_hd__or2_1
XFILLER_0_70_485 VGND VGND VPWR VPWR sky130_fd_sc_hd__decap_6
XFILLER_0_101_727 VGND VGND VPWR VPWR sky130_fd_sc_hd__fill_1
XFILLER_0_3_785 VPWR VGND VPWR VGND sky130_ef_sc_hd__decap_12
X_08995_ _03288_ VGND VGND VPWR VPWR net87 sky130_fd_sc_hd__buf_1
X_07946_ _02331_ _02334_ _02333_ VGND VGND VPWR VPWR _02350_ sky130_fd_sc_hd__o21ai_1
X_07877_ _02268_ _02272_ _02279_ _02285_ VGND VGND VPWR VPWR _07644_ sky130_fd_sc_hd__o22a_1
XFILLER_0_78_530 VGND VGND VPWR VPWR sky130_fd_sc_hd__fill_2
X_09616_ _03793_ _03844_ _03849_ _02241_ VGND VGND VPWR VPWR _03850_ sky130_fd_sc_hd__a22o_1
X_09547_ net182 decoded_imm\[1\] VGND VGND VPWR VPWR _03782_ sky130_fd_sc_hd__xnor2_1
X_09478_ mem_do_prefetch _02101_ _02081_ _03713_ _02105_ VGND VGND VPWR VPWR _03714_
+ sky130_fd_sc_hd__a311o_4
X_08429_ _02778_ _02809_ _02747_ VGND VGND VPWR VPWR _02810_ sky130_fd_sc_hd__o21ai_1
X_11440_ net1526 _05215_ _05324_ VGND VGND VPWR VPWR _05331_ sky130_fd_sc_hd__mux2_1
XFILLER_0_135_189 VGND VGND VPWR VPWR sky130_fd_sc_hd__fill_2
X_11371_ _05294_ VGND VGND VPWR VPWR _00381_ sky130_fd_sc_hd__clkbuf_1
XFILLER_0_104_521 VGND VGND VPWR VPWR sky130_fd_sc_hd__decap_4
XFILLER_0_116_392 VGND VGND VPWR VPWR sky130_fd_sc_hd__fill_2
X_10322_ reg_pc\[20\] _03992_ _04531_ _04537_ _03946_ VGND VGND VPWR VPWR _04538_
+ sky130_fd_sc_hd__a221o_1
X_14090_ _01097_ _07316_ net236 VGND VGND VPWR VPWR _07463_ sky130_fd_sc_hd__and3b_1
XFILLER_0_34_699 VGND VGND VPWR VPWR sky130_fd_sc_hd__fill_1
X_13110_ _06599_ VGND VGND VPWR VPWR _00815_ sky130_fd_sc_hd__clkbuf_1
X_13041_ _06416_ _06517_ _06532_ _06470_ decoded_imm\[7\] VGND VGND VPWR VPWR _06533_
+ sky130_fd_sc_hd__a32o_1
X_10253_ _03717_ _04446_ _04450_ _04470_ VGND VGND VPWR VPWR _04471_ sky130_fd_sc_hd__o31a_1
XFILLER_0_100_760 VGND VGND VPWR VPWR sky130_fd_sc_hd__fill_2
X_10184_ decoded_imm\[17\] net179 VGND VGND VPWR VPWR _04403_ sky130_fd_sc_hd__or2_1
XFILLER_0_56_19 VGND VGND VPWR VPWR sky130_fd_sc_hd__decap_8
X_16800_ clknet_leaf_88_clk _01364_ VGND VGND VPWR VPWR cpuregs\[6\]\[15\] sky130_fd_sc_hd__dfxtp_1
X_16731_ clknet_leaf_108_clk _01295_ VGND VGND VPWR VPWR cpuregs\[4\]\[10\] sky130_fd_sc_hd__dfxtp_1
X_14992_ _01874_ VGND VGND VPWR VPWR _01357_ sky130_fd_sc_hd__clkbuf_1
X_13943_ _07374_ VGND VGND VPWR VPWR _00864_ sky130_fd_sc_hd__clkbuf_1
X_16662_ clknet_leaf_143_clk _01229_ VGND VGND VPWR VPWR cpuregs\[29\]\[8\] sky130_fd_sc_hd__dfxtp_1
X_13874_ _02165_ decoder_pseudo_trigger VGND VGND VPWR VPWR _07326_ sky130_fd_sc_hd__nor2_2
X_12825_ mem_do_prefetch _06327_ _02167_ VGND VGND VPWR VPWR _06328_ sky130_fd_sc_hd__mux2_1
X_16593_ clknet_leaf_121_clk _01160_ VGND VGND VPWR VPWR cpuregs\[9\]\[3\] sky130_fd_sc_hd__dfxtp_1
X_15613_ clknet_leaf_130_clk _00263_ VGND VGND VPWR VPWR cpuregs\[31\]\[3\] sky130_fd_sc_hd__dfxtp_1
X_15544_ clknet_leaf_92_clk _00194_ VGND VGND VPWR VPWR cpuregs\[13\]\[30\] sky130_fd_sc_hd__dfxtp_1
XTAP_1250 VGND VPWR sky130_fd_sc_hd__tapvpwrvgnd_1
XFILLER_0_84_533 VGND VGND VPWR VPWR sky130_fd_sc_hd__decap_6
XTAP_1283 VGND VPWR sky130_fd_sc_hd__tapvpwrvgnd_1
XTAP_1261 VGND VPWR sky130_fd_sc_hd__tapvpwrvgnd_1
XTAP_1272 VGND VPWR sky130_fd_sc_hd__tapvpwrvgnd_1
X_12756_ _02084_ net235 VGND VGND VPWR VPWR _06289_ sky130_fd_sc_hd__or2_1
X_15475_ clknet_leaf_71_clk _00125_ VGND VGND VPWR VPWR cpuregs\[12\]\[25\] sky130_fd_sc_hd__dfxtp_1
XFILLER_0_122_6 VPWR VGND VPWR VGND sky130_ef_sc_hd__decap_12
X_11707_ net603 _05209_ _05469_ VGND VGND VPWR VPWR _05473_ sky130_fd_sc_hd__mux2_1
XTAP_1294 VGND VPWR sky130_fd_sc_hd__tapvpwrvgnd_1
X_12687_ count_cycle\[53\] _06225_ count_cycle\[54\] VGND VGND VPWR VPWR _06231_ sky130_fd_sc_hd__a21o_1
X_11638_ _05436_ VGND VGND VPWR VPWR _00506_ sky130_fd_sc_hd__clkbuf_1
X_14426_ _05049_ net1160 _07615_ VGND VGND VPWR VPWR _01574_ sky130_fd_sc_hd__mux2_1
XFILLER_0_37_493 VGND VGND VPWR VPWR sky130_fd_sc_hd__decap_8
X_14357_ mem_rdata_q\[21\] _07460_ _07567_ mem_rdata_q\[8\] _05764_ VGND VGND VPWR
+ VPWR _07613_ sky130_fd_sc_hd__a221o_1
XFILLER_0_25_666 VGND VGND VPWR VPWR sky130_fd_sc_hd__decap_3
X_11569_ _05031_ net917 _05397_ VGND VGND VPWR VPWR _05400_ sky130_fd_sc_hd__mux2_1
X_13308_ _03346_ VGND VGND VPWR VPWR _06792_ sky130_fd_sc_hd__clkbuf_4
Xhold707 cpuregs\[16\]\[16\] VGND VGND VPWR VPWR net1065 sky130_fd_sc_hd__dlygate4sd3_1
Xhold718 cpuregs\[23\]\[12\] VGND VGND VPWR VPWR net1076 sky130_fd_sc_hd__dlygate4sd3_1
XFILLER_0_97_48 VGND VGND VPWR VPWR sky130_fd_sc_hd__decap_8
Xhold729 cpuregs\[20\]\[18\] VGND VGND VPWR VPWR net1087 sky130_fd_sc_hd__dlygate4sd3_1
X_14288_ _07572_ VGND VGND VPWR VPWR _07573_ sky130_fd_sc_hd__buf_2
X_13239_ _06441_ _06714_ _06718_ _06724_ _06468_ VGND VGND VPWR VPWR _06725_ sky130_fd_sc_hd__a311o_1
X_16027_ clknet_leaf_8_clk _00677_ VGND VGND VPWR VPWR reg_next_pc\[2\] sky130_fd_sc_hd__dfxtp_1
XFILLER_0_0_755 VGND VGND VPWR VPWR sky130_fd_sc_hd__fill_1
XFILLER_0_0_799 VGND VGND VPWR VPWR sky130_fd_sc_hd__fill_2
X_08780_ _02725_ _02986_ _03135_ VGND VGND VPWR VPWR _03136_ sky130_fd_sc_hd__a21o_1
X_07800_ _02134_ VGND VGND VPWR VPWR _02213_ sky130_fd_sc_hd__clkbuf_4
XFILLER_0_46_52 VGND VGND VPWR VPWR sky130_fd_sc_hd__fill_1
X_07731_ net1437 _02101_ _02152_ VGND VGND VPWR VPWR _00841_ sky130_fd_sc_hd__nor3_1
X_16929_ clknet_leaf_86_clk _01493_ VGND VGND VPWR VPWR cpuregs\[0\]\[16\] sky130_fd_sc_hd__dfxtp_1
XFILLER_0_46_85 VGND VGND VPWR VPWR sky130_fd_sc_hd__decap_3
XFILLER_0_79_349 VGND VGND VPWR VPWR sky130_fd_sc_hd__decap_8
X_07662_ _02085_ _02091_ VGND VGND VPWR VPWR _02092_ sky130_fd_sc_hd__nor2_1
X_09401_ reg_pc\[30\] _03631_ _03459_ VGND VGND VPWR VPWR _03639_ sky130_fd_sc_hd__o21a_1
X_09332_ _03579_ VGND VGND VPWR VPWR _00057_ sky130_fd_sc_hd__clkbuf_1
XFILLER_0_62_51 VGND VGND VPWR VPWR sky130_fd_sc_hd__fill_1
XFILLER_0_47_202 VGND VGND VPWR VPWR sky130_fd_sc_hd__fill_2
XFILLER_0_1_87 VGND VGND VPWR VPWR sky130_fd_sc_hd__fill_2
XFILLER_0_87_393 VGND VGND VPWR VPWR sky130_fd_sc_hd__fill_2
XFILLER_0_75_555 VGND VGND VPWR VPWR sky130_fd_sc_hd__fill_1
XFILLER_0_75_544 VGND VGND VPWR VPWR sky130_fd_sc_hd__fill_2
XFILLER_0_8_811 VGND VGND VPWR VPWR sky130_fd_sc_hd__fill_1
XFILLER_0_90_514 VGND VGND VPWR VPWR sky130_fd_sc_hd__fill_1
X_09263_ net846 _03519_ _03512_ VGND VGND VPWR VPWR _03520_ sky130_fd_sc_hd__mux2_1
XFILLER_0_47_279 VGND VGND VPWR VPWR sky130_fd_sc_hd__fill_1
XFILLER_0_47_268 VGND VGND VPWR VPWR sky130_fd_sc_hd__decap_4
XFILLER_0_35_408 VGND VGND VPWR VPWR sky130_fd_sc_hd__fill_2
XFILLER_0_118_668 VGND VGND VPWR VPWR sky130_fd_sc_hd__decap_4
X_08214_ reg_pc\[27\] decoded_imm\[27\] VGND VGND VPWR VPWR _02600_ sky130_fd_sc_hd__nand2_1
X_09194_ latched_branch latched_store VGND VGND VPWR VPWR _03459_ sky130_fd_sc_hd__nand2b_4
XFILLER_0_133_649 VGND VGND VPWR VPWR sky130_fd_sc_hd__fill_1
X_08145_ net185 VGND VGND VPWR VPWR _02536_ sky130_fd_sc_hd__clkbuf_4
XFILLER_0_90_569 VGND VGND VPWR VPWR sky130_fd_sc_hd__fill_2
XFILLER_0_71_761 VGND VGND VPWR VPWR sky130_fd_sc_hd__decap_3
XFILLER_0_132_137 VGND VGND VPWR VPWR sky130_fd_sc_hd__decap_3
XFILLER_0_70_260 VGND VGND VPWR VPWR sky130_fd_sc_hd__decap_6
XFILLER_0_16_699 VGND VGND VPWR VPWR sky130_fd_sc_hd__fill_1
X_08076_ count_instr\[50\] _02233_ VGND VGND VPWR VPWR _02471_ sky130_fd_sc_hd__and2_1
XFILLER_0_101_535 VGND VGND VPWR VPWR sky130_fd_sc_hd__fill_1
XFILLER_0_87_81 VGND VGND VPWR VPWR sky130_fd_sc_hd__fill_2
X_08978_ reg_out\[25\] reg_next_pc\[25\] _03270_ VGND VGND VPWR VPWR _03277_ sky130_fd_sc_hd__mux2_1
Xhold34 decoded_rd\[4\] VGND VGND VPWR VPWR net392 sky130_fd_sc_hd__dlygate4sd3_1
Xhold45 instr_lui VGND VGND VPWR VPWR net403 sky130_fd_sc_hd__dlygate4sd3_1
Xhold56 cpu_state\[0\] VGND VGND VPWR VPWR net414 sky130_fd_sc_hd__dlygate4sd3_1
Xhold67 reg_next_pc\[30\] VGND VGND VPWR VPWR net425 sky130_fd_sc_hd__dlygate4sd3_1
X_07929_ _02332_ _02333_ VGND VGND VPWR VPWR _02334_ sky130_fd_sc_hd__nand2_1
Xhold78 reg_next_pc\[2\] VGND VGND VPWR VPWR net436 sky130_fd_sc_hd__dlygate4sd3_1
Xhold89 instr_sb VGND VGND VPWR VPWR net447 sky130_fd_sc_hd__dlygate4sd3_1
X_10940_ _05049_ net1355 _04984_ VGND VGND VPWR VPWR _05050_ sky130_fd_sc_hd__mux2_1
XFILLER_0_97_157 VGND VGND VPWR VPWR sky130_fd_sc_hd__fill_2
X_12610_ count_cycle\[32\] count_cycle\[33\] _06171_ VGND VGND VPWR VPWR _06175_ sky130_fd_sc_hd__and3_1
X_10871_ _03503_ VGND VGND VPWR VPWR _05003_ sky130_fd_sc_hd__clkbuf_4
X_13590_ _07027_ _04654_ _07064_ _03330_ VGND VGND VPWR VPWR _07065_ sky130_fd_sc_hd__a211o_1
XFILLER_0_81_503 VGND VGND VPWR VPWR sky130_fd_sc_hd__fill_1
X_12541_ _06126_ VGND VGND VPWR VPWR _00719_ sky130_fd_sc_hd__clkbuf_1
XFILLER_0_26_419 VGND VGND VPWR VPWR sky130_fd_sc_hd__fill_1
XFILLER_0_38_279 VGND VGND VPWR VPWR sky130_fd_sc_hd__fill_1
X_12472_ _05755_ _05757_ _06062_ VGND VGND VPWR VPWR _06073_ sky130_fd_sc_hd__and3_1
XFILLER_0_124_605 VGND VGND VPWR VPWR sky130_fd_sc_hd__decap_4
XFILLER_0_109_668 VGND VGND VPWR VPWR sky130_fd_sc_hd__decap_4
XFILLER_0_81_558 VGND VGND VPWR VPWR sky130_fd_sc_hd__fill_2
X_15260_ _02015_ VGND VGND VPWR VPWR _01484_ sky130_fd_sc_hd__clkbuf_1
X_14211_ _07518_ VGND VGND VPWR VPWR _07530_ sky130_fd_sc_hd__buf_8
X_11423_ net925 _05198_ _05313_ VGND VGND VPWR VPWR _05322_ sky130_fd_sc_hd__mux2_1
XANTENNA_9 _03609_ VGND VGND VPWR VPWR sky130_fd_sc_hd__diode_2
X_15191_ _03484_ net1416 _01973_ VGND VGND VPWR VPWR _01980_ sky130_fd_sc_hd__mux2_1
X_14142_ _05022_ net1338 _07482_ VGND VGND VPWR VPWR _07491_ sky130_fd_sc_hd__mux2_1
X_11354_ _05285_ VGND VGND VPWR VPWR _00373_ sky130_fd_sc_hd__clkbuf_1
XFILLER_0_21_146 VGND VGND VPWR VPWR sky130_fd_sc_hd__decap_8
X_10305_ cpuregs\[12\]\[20\] cpuregs\[13\]\[20\] _03976_ VGND VGND VPWR VPWR _04521_
+ sky130_fd_sc_hd__mux2_1
X_14073_ decoded_imm_j\[17\] _01110_ _03295_ VGND VGND VPWR VPWR _07453_ sky130_fd_sc_hd__mux2_1
X_11285_ _05248_ VGND VGND VPWR VPWR _00341_ sky130_fd_sc_hd__clkbuf_1
XFILLER_0_67_18 VPWR VGND VPWR VGND sky130_ef_sc_hd__decap_12
X_10236_ _03868_ _04453_ _03870_ VGND VGND VPWR VPWR _04454_ sky130_fd_sc_hd__a21o_1
XTAP_319 VGND VPWR sky130_fd_sc_hd__tapvpwrvgnd_1
XTAP_308 VGND VPWR sky130_fd_sc_hd__tapvpwrvgnd_1
X_13024_ _06430_ _06509_ _06513_ _06342_ _06515_ VGND VGND VPWR VPWR _06516_ sky130_fd_sc_hd__o311a_1
X_10167_ cpuregs\[2\]\[16\] cpuregs\[3\]\[16\] _03977_ VGND VGND VPWR VPWR _04387_
+ sky130_fd_sc_hd__mux2_1
X_10098_ _04316_ _04317_ _04318_ _04319_ _04030_ _04103_ VGND VGND VPWR VPWR _04320_
+ sky130_fd_sc_hd__mux4_1
X_14975_ _03440_ net1112 _01865_ VGND VGND VPWR VPWR _01866_ sky130_fd_sc_hd__mux2_1
X_16714_ clknet_leaf_67_clk _01281_ VGND VGND VPWR VPWR cpuregs\[3\]\[28\] sky130_fd_sc_hd__dfxtp_1
XFILLER_0_89_658 VGND VGND VPWR VPWR sky130_fd_sc_hd__fill_1
X_13926_ net447 _07358_ _07329_ _02189_ VGND VGND VPWR VPWR _00859_ sky130_fd_sc_hd__a22o_1
X_16645_ clknet_leaf_63_clk _01212_ VGND VGND VPWR VPWR cpuregs\[23\]\[23\] sky130_fd_sc_hd__dfxtp_1
XFILLER_0_57_500 VGND VGND VPWR VPWR sky130_fd_sc_hd__decap_4
X_13857_ mem_rdata_q\[4\] net27 _02089_ VGND VGND VPWR VPWR _07314_ sky130_fd_sc_hd__mux2_1
X_12808_ net49 net80 _06313_ VGND VGND VPWR VPWR _06319_ sky130_fd_sc_hd__mux2_1
X_16576_ clknet_leaf_65_clk _01153_ VGND VGND VPWR VPWR cpuregs\[24\]\[28\] sky130_fd_sc_hd__dfxtp_1
X_13788_ _06377_ _07246_ _07250_ _07256_ _06341_ VGND VGND VPWR VPWR _07257_ sky130_fd_sc_hd__a311o_1
XFILLER_0_29_235 VGND VGND VPWR VPWR sky130_fd_sc_hd__fill_1
XFILLER_0_127_421 VGND VGND VPWR VPWR sky130_fd_sc_hd__fill_1
XFILLER_0_123_45 VGND VGND VPWR VPWR sky130_fd_sc_hd__decap_8
X_12739_ cpuregs\[22\]\[31\] cpuregs\[23\]\[31\] _03665_ VGND VGND VPWR VPWR _06273_
+ sky130_fd_sc_hd__mux2_1
X_15527_ clknet_leaf_104_clk _00177_ VGND VGND VPWR VPWR cpuregs\[13\]\[13\] sky130_fd_sc_hd__dfxtp_1
XTAP_1091 VGND VPWR sky130_fd_sc_hd__tapvpwrvgnd_1
XTAP_1080 VGND VPWR sky130_fd_sc_hd__tapvpwrvgnd_1
XFILLER_0_120_3 VGND VGND VPWR VPWR sky130_fd_sc_hd__fill_2
X_15458_ clknet_leaf_113_clk _00108_ VGND VGND VPWR VPWR cpuregs\[12\]\[8\] sky130_fd_sc_hd__dfxtp_1
X_14409_ _01565_ VGND VGND VPWR VPWR _01051_ sky130_fd_sc_hd__clkbuf_1
XFILLER_0_80_580 VGND VGND VPWR VPWR sky130_fd_sc_hd__fill_2
XFILLER_0_12_102 VPWR VGND VPWR VGND sky130_ef_sc_hd__decap_12
XFILLER_0_13_636 VGND VGND VPWR VPWR sky130_fd_sc_hd__decap_3
X_15389_ clknet_leaf_113_clk _00044_ VGND VGND VPWR VPWR cpuregs\[11\]\[7\] sky130_fd_sc_hd__dfxtp_1
Xhold515 cpuregs\[3\]\[23\] VGND VGND VPWR VPWR net873 sky130_fd_sc_hd__dlygate4sd3_1
Xhold526 cpuregs\[18\]\[15\] VGND VGND VPWR VPWR net884 sky130_fd_sc_hd__dlygate4sd3_1
Xhold504 cpuregs\[15\]\[9\] VGND VGND VPWR VPWR net862 sky130_fd_sc_hd__dlygate4sd3_1
Xhold537 cpuregs\[30\]\[27\] VGND VGND VPWR VPWR net895 sky130_fd_sc_hd__dlygate4sd3_1
Xhold559 cpuregs\[16\]\[22\] VGND VGND VPWR VPWR net917 sky130_fd_sc_hd__dlygate4sd3_1
X_09950_ _03747_ _04169_ _04175_ VGND VGND VPWR VPWR _04176_ sky130_fd_sc_hd__or3_2
XFILLER_0_0_530 VGND VGND VPWR VPWR sky130_fd_sc_hd__fill_2
Xhold548 cpuregs\[27\]\[3\] VGND VGND VPWR VPWR net906 sky130_fd_sc_hd__dlygate4sd3_1
X_08901_ _03222_ VGND VGND VPWR VPWR _03223_ sky130_fd_sc_hd__clkbuf_4
X_09881_ _04108_ VGND VGND VPWR VPWR _00077_ sky130_fd_sc_hd__clkbuf_1
XTAP_820 VGND VPWR sky130_fd_sc_hd__tapvpwrvgnd_1
XTAP_831 VGND VPWR sky130_fd_sc_hd__tapvpwrvgnd_1
XTAP_842 VGND VPWR sky130_fd_sc_hd__tapvpwrvgnd_1
XTAP_853 VGND VPWR sky130_fd_sc_hd__tapvpwrvgnd_1
X_08832_ _03168_ _03183_ _03172_ VGND VGND VPWR VPWR _03184_ sky130_fd_sc_hd__o21ai_1
Xhold1215 cpuregs\[9\]\[25\] VGND VGND VPWR VPWR net1573 sky130_fd_sc_hd__dlygate4sd3_1
Xhold1204 cpuregs\[13\]\[25\] VGND VGND VPWR VPWR net1562 sky130_fd_sc_hd__dlygate4sd3_1
XTAP_864 VGND VPWR sky130_fd_sc_hd__tapvpwrvgnd_1
XTAP_886 VGND VPWR sky130_fd_sc_hd__tapvpwrvgnd_1
XTAP_875 VGND VPWR sky130_fd_sc_hd__tapvpwrvgnd_1
X_08763_ _03091_ _03119_ VGND VGND VPWR VPWR _03120_ sky130_fd_sc_hd__or2_1
Xhold1237 cpuregs\[8\]\[20\] VGND VGND VPWR VPWR net1595 sky130_fd_sc_hd__dlygate4sd3_1
Xhold1226 cpuregs\[20\]\[21\] VGND VGND VPWR VPWR net1584 sky130_fd_sc_hd__dlygate4sd3_1
Xhold1248 count_instr\[2\] VGND VGND VPWR VPWR net1606 sky130_fd_sc_hd__dlygate4sd3_1
XTAP_897 VGND VPWR sky130_fd_sc_hd__tapvpwrvgnd_1
Xhold1259 decoded_imm\[15\] VGND VGND VPWR VPWR net1617 sky130_fd_sc_hd__dlygate4sd3_1
X_07714_ net34 VGND VGND VPWR VPWR _02140_ sky130_fd_sc_hd__clkbuf_4
X_08694_ _02763_ _03055_ VGND VGND VPWR VPWR _03056_ sky130_fd_sc_hd__xnor2_2
XFILLER_0_79_157 VGND VGND VPWR VPWR sky130_fd_sc_hd__decap_4
XFILLER_0_94_138 VGND VGND VPWR VPWR sky130_fd_sc_hd__fill_2
XFILLER_0_48_544 VGND VGND VPWR VPWR sky130_fd_sc_hd__fill_1
X_09315_ net1088 _03564_ _03512_ VGND VGND VPWR VPWR _03565_ sky130_fd_sc_hd__mux2_1
XFILLER_0_29_791 VGND VGND VPWR VPWR sky130_fd_sc_hd__fill_1
X_09246_ net1069 _03504_ _03446_ VGND VGND VPWR VPWR _03505_ sky130_fd_sc_hd__mux2_1
XFILLER_0_63_558 VGND VGND VPWR VPWR sky130_fd_sc_hd__fill_2
XFILLER_0_133_446 VGND VGND VPWR VPWR sky130_fd_sc_hd__fill_2
X_09177_ _03441_ _03444_ VGND VGND VPWR VPWR _03445_ sky130_fd_sc_hd__nor2_4
XFILLER_0_16_474 VGND VGND VPWR VPWR sky130_fd_sc_hd__fill_2
X_08128_ _02497_ _02505_ _02519_ VGND VGND VPWR VPWR _02520_ sky130_fd_sc_hd__a21oi_1
XFILLER_0_71_591 VGND VGND VPWR VPWR sky130_fd_sc_hd__fill_2
XFILLER_0_101_332 VGND VGND VPWR VPWR sky130_fd_sc_hd__decap_4
X_08059_ count_instr\[49\] _02233_ VGND VGND VPWR VPWR _02455_ sky130_fd_sc_hd__and2_1
Xpicorv32_290 VGND VGND VPWR VPWR picorv32_290/HI pcpi_insn[1] sky130_fd_sc_hd__conb_1
X_11070_ net614 _03629_ _05110_ VGND VGND VPWR VPWR _05119_ sky130_fd_sc_hd__mux2_1
Xoutput57 net57 VGND VGND VPWR VPWR mem_addr[31] sky130_fd_sc_hd__clkbuf_4
Xoutput35 net35 VGND VGND VPWR VPWR mem_addr[10] sky130_fd_sc_hd__clkbuf_4
Xoutput46 net46 VGND VGND VPWR VPWR mem_addr[21] sky130_fd_sc_hd__clkbuf_4
Xoutput79 net79 VGND VGND VPWR VPWR mem_la_addr[23] sky130_fd_sc_hd__clkbuf_4
Xoutput68 net68 VGND VGND VPWR VPWR mem_la_addr[12] sky130_fd_sc_hd__clkbuf_4
X_10021_ _03720_ _04242_ _04244_ VGND VGND VPWR VPWR _04245_ sky130_fd_sc_hd__a21o_1
X_14760_ _05043_ net1550 _01742_ VGND VGND VPWR VPWR _01751_ sky130_fd_sc_hd__mux2_1
X_13711_ _06457_ _07181_ VGND VGND VPWR VPWR _07182_ sky130_fd_sc_hd__and2_1
X_11972_ count_instr\[47\] _05645_ VGND VGND VPWR VPWR _05649_ sky130_fd_sc_hd__or2_1
X_10923_ _05038_ VGND VGND VPWR VPWR _00189_ sky130_fd_sc_hd__clkbuf_1
X_14691_ _01714_ VGND VGND VPWR VPWR _01216_ sky130_fd_sc_hd__clkbuf_1
XFILLER_0_98_477 VGND VGND VPWR VPWR sky130_fd_sc_hd__decap_4
X_13642_ cpuregs\[12\]\[26\] cpuregs\[13\]\[26\] cpuregs\[14\]\[26\] cpuregs\[15\]\[26\]
+ _07027_ _06392_ VGND VGND VPWR VPWR _07115_ sky130_fd_sc_hd__mux4_1
X_16430_ clknet_leaf_25_clk net563 VGND VGND VPWR VPWR decoded_imm\[17\] sky130_fd_sc_hd__dfxtp_2
XFILLER_0_67_831 VGND VGND VPWR VPWR sky130_fd_sc_hd__fill_1
X_10854_ _04991_ net1499 _04985_ VGND VGND VPWR VPWR _04992_ sky130_fd_sc_hd__mux2_1
X_13573_ cpuregs\[28\]\[23\] cpuregs\[29\]\[23\] _07018_ VGND VGND VPWR VPWR _07049_
+ sky130_fd_sc_hd__mux2_1
X_16361_ clknet_leaf_82_clk _00943_ VGND VGND VPWR VPWR cpuregs\[1\]\[26\] sky130_fd_sc_hd__dfxtp_1
XPHY_152 VGND VGND VPWR VPWR sky130_fd_sc_hd__decap_3
XPHY_141 VGND VGND VPWR VPWR sky130_fd_sc_hd__decap_3
XPHY_130 VGND VGND VPWR VPWR sky130_fd_sc_hd__decap_3
XFILLER_0_27_706 VGND VGND VPWR VPWR sky130_fd_sc_hd__fill_1
XFILLER_0_136_251 VGND VGND VPWR VPWR sky130_fd_sc_hd__fill_1
XFILLER_0_109_465 VGND VGND VPWR VPWR sky130_fd_sc_hd__fill_2
XPHY_185 VGND VGND VPWR VPWR sky130_fd_sc_hd__decap_3
XPHY_174 VGND VGND VPWR VPWR sky130_fd_sc_hd__decap_3
XPHY_163 VGND VGND VPWR VPWR sky130_fd_sc_hd__decap_3
X_15312_ _02042_ VGND VGND VPWR VPWR _01509_ sky130_fd_sc_hd__clkbuf_1
X_12524_ count_cycle\[7\] count_cycle\[8\] _06110_ VGND VGND VPWR VPWR _06114_ sky130_fd_sc_hd__and3_1
X_10785_ _04952_ VGND VGND VPWR VPWR _00137_ sky130_fd_sc_hd__clkbuf_1
XFILLER_0_136_284 VGND VGND VPWR VPWR sky130_fd_sc_hd__decap_8
XPHY_196 VGND VGND VPWR VPWR sky130_fd_sc_hd__decap_3
X_16292_ clknet_leaf_4_clk _00877_ VGND VGND VPWR VPWR instr_sra sky130_fd_sc_hd__dfxtp_1
XFILLER_0_124_446 VGND VGND VPWR VPWR sky130_fd_sc_hd__fill_2
X_12455_ _05749_ _05751_ _06005_ VGND VGND VPWR VPWR _06058_ sky130_fd_sc_hd__o21ai_1
X_15243_ _03646_ net1418 _01972_ VGND VGND VPWR VPWR _02007_ sky130_fd_sc_hd__mux2_1
XFILLER_0_34_260 VGND VGND VPWR VPWR sky130_fd_sc_hd__fill_2
XFILLER_0_35_783 VGND VGND VPWR VPWR sky130_fd_sc_hd__fill_1
X_12386_ _05954_ _05962_ _05990_ _05994_ VGND VGND VPWR VPWR _05995_ sky130_fd_sc_hd__a31oi_2
X_15174_ _01970_ VGND VGND VPWR VPWR _01443_ sky130_fd_sc_hd__clkbuf_1
X_11406_ _05301_ VGND VGND VPWR VPWR _05313_ sky130_fd_sc_hd__buf_4
X_14125_ _07470_ VGND VGND VPWR VPWR _07482_ sky130_fd_sc_hd__clkbuf_8
XFILLER_0_22_477 VGND VGND VPWR VPWR sky130_fd_sc_hd__decap_4
X_11337_ _05276_ VGND VGND VPWR VPWR _00365_ sky130_fd_sc_hd__clkbuf_1
XFILLER_0_94_27 VGND VGND VPWR VPWR sky130_fd_sc_hd__fill_1
X_11268_ _05239_ VGND VGND VPWR VPWR _00333_ sky130_fd_sc_hd__clkbuf_1
X_14056_ _07444_ VGND VGND VPWR VPWR _00898_ sky130_fd_sc_hd__clkbuf_1
X_10219_ _04437_ _02468_ _04150_ VGND VGND VPWR VPWR _04438_ sky130_fd_sc_hd__mux2_1
X_11199_ _05195_ VGND VGND VPWR VPWR _00308_ sky130_fd_sc_hd__clkbuf_1
X_13007_ _06416_ _06486_ _06499_ _06470_ decoded_imm\[6\] VGND VGND VPWR VPWR _06500_
+ sky130_fd_sc_hd__a32o_1
XFILLER_0_118_89 VGND VGND VPWR VPWR sky130_fd_sc_hd__fill_1
X_14958_ _01856_ VGND VGND VPWR VPWR _01341_ sky130_fd_sc_hd__clkbuf_1
XFILLER_0_89_444 VGND VGND VPWR VPWR sky130_fd_sc_hd__fill_1
X_14889_ _03603_ net1632 _01815_ VGND VGND VPWR VPWR _01820_ sky130_fd_sc_hd__mux2_1
X_13909_ mem_rdata_q\[12\] net4 _03291_ VGND VGND VPWR VPWR _07354_ sky130_fd_sc_hd__mux2_1
XFILLER_0_134_77 VGND VGND VPWR VPWR sky130_fd_sc_hd__decap_6
X_16628_ clknet_leaf_141_clk _01195_ VGND VGND VPWR VPWR cpuregs\[23\]\[6\] sky130_fd_sc_hd__dfxtp_1
X_16559_ clknet_leaf_100_clk _01136_ VGND VGND VPWR VPWR cpuregs\[24\]\[11\] sky130_fd_sc_hd__dfxtp_1
XFILLER_0_43_86 VGND VGND VPWR VPWR sky130_fd_sc_hd__fill_1
XFILLER_0_128_752 VGND VGND VPWR VPWR sky130_fd_sc_hd__decap_4
X_09100_ cpuregs\[30\]\[3\] cpuregs\[31\]\[3\] _03343_ VGND VGND VPWR VPWR _03380_
+ sky130_fd_sc_hd__mux2_1
X_09031_ _00007_ VGND VGND VPWR VPWR _03312_ sky130_fd_sc_hd__buf_6
XFILLER_0_5_600 VGND VGND VPWR VPWR sky130_fd_sc_hd__fill_1
XFILLER_0_25_260 VGND VGND VPWR VPWR sky130_fd_sc_hd__decap_3
Xhold301 cpuregs\[14\]\[20\] VGND VGND VPWR VPWR net659 sky130_fd_sc_hd__dlygate4sd3_1
XFILLER_0_5_677 VGND VGND VPWR VPWR sky130_fd_sc_hd__fill_1
Xhold312 cpuregs\[23\]\[22\] VGND VGND VPWR VPWR net670 sky130_fd_sc_hd__dlygate4sd3_1
Xhold334 cpuregs\[30\]\[20\] VGND VGND VPWR VPWR net692 sky130_fd_sc_hd__dlygate4sd3_1
Xhold323 cpuregs\[10\]\[11\] VGND VGND VPWR VPWR net681 sky130_fd_sc_hd__dlygate4sd3_1
XFILLER_0_111_641 VGND VGND VPWR VPWR sky130_fd_sc_hd__fill_1
Xhold378 cpuregs\[14\]\[18\] VGND VGND VPWR VPWR net736 sky130_fd_sc_hd__dlygate4sd3_1
Xhold345 cpuregs\[30\]\[16\] VGND VGND VPWR VPWR net703 sky130_fd_sc_hd__dlygate4sd3_1
Xhold367 cpuregs\[14\]\[12\] VGND VGND VPWR VPWR net725 sky130_fd_sc_hd__dlygate4sd3_1
Xhold356 cpuregs\[14\]\[10\] VGND VGND VPWR VPWR net714 sky130_fd_sc_hd__dlygate4sd3_1
X_09933_ _02352_ _02378_ _03997_ VGND VGND VPWR VPWR _04159_ sky130_fd_sc_hd__mux2_1
Xhold389 cpuregs\[4\]\[8\] VGND VGND VPWR VPWR net747 sky130_fd_sc_hd__dlygate4sd3_1
XFILLER_0_0_393 VGND VGND VPWR VPWR sky130_fd_sc_hd__decap_4
XTAP_650 VGND VPWR sky130_fd_sc_hd__tapvpwrvgnd_1
XTAP_661 VGND VPWR sky130_fd_sc_hd__tapvpwrvgnd_1
X_09864_ cpuregs\[2\]\[8\] cpuregs\[3\]\[8\] _03977_ VGND VGND VPWR VPWR _04092_ sky130_fd_sc_hd__mux2_1
X_08815_ _03161_ _03164_ _03160_ VGND VGND VPWR VPWR _03168_ sky130_fd_sc_hd__a21oi_1
Xhold1001 cpuregs\[8\]\[15\] VGND VGND VPWR VPWR net1359 sky130_fd_sc_hd__dlygate4sd3_1
Xhold1012 count_cycle\[55\] VGND VGND VPWR VPWR net1370 sky130_fd_sc_hd__dlygate4sd3_1
XTAP_672 VGND VPWR sky130_fd_sc_hd__tapvpwrvgnd_1
XTAP_694 VGND VPWR sky130_fd_sc_hd__tapvpwrvgnd_1
XTAP_683 VGND VPWR sky130_fd_sc_hd__tapvpwrvgnd_1
Xhold1023 cpuregs\[17\]\[5\] VGND VGND VPWR VPWR net1381 sky130_fd_sc_hd__dlygate4sd3_1
Xhold1067 cpuregs\[19\]\[28\] VGND VGND VPWR VPWR net1425 sky130_fd_sc_hd__dlygate4sd3_1
Xhold1034 cpuregs\[4\]\[26\] VGND VGND VPWR VPWR net1392 sky130_fd_sc_hd__dlygate4sd3_1
Xhold1045 cpuregs\[9\]\[16\] VGND VGND VPWR VPWR net1403 sky130_fd_sc_hd__dlygate4sd3_1
X_09795_ cpuregs\[28\]\[6\] cpuregs\[29\]\[6\] cpuregs\[30\]\[6\] cpuregs\[31\]\[6\]
+ _03865_ _03727_ VGND VGND VPWR VPWR _04025_ sky130_fd_sc_hd__mux4_1
Xhold1056 cpuregs\[4\]\[7\] VGND VGND VPWR VPWR net1414 sky130_fd_sc_hd__dlygate4sd3_1
Xhold1078 cpuregs\[31\]\[28\] VGND VGND VPWR VPWR net1436 sky130_fd_sc_hd__dlygate4sd3_1
X_08746_ net186 _03103_ VGND VGND VPWR VPWR _03104_ sky130_fd_sc_hd__xor2_1
Xhold1089 cpuregs\[29\]\[16\] VGND VGND VPWR VPWR net1447 sky130_fd_sc_hd__dlygate4sd3_1
X_08677_ _03038_ _03040_ VGND VGND VPWR VPWR _03041_ sky130_fd_sc_hd__xnor2_1
XTAP_1816 VGND VPWR sky130_fd_sc_hd__tapvpwrvgnd_1
XTAP_1805 VGND VPWR sky130_fd_sc_hd__tapvpwrvgnd_1
XTAP_1849 VGND VPWR sky130_fd_sc_hd__tapvpwrvgnd_1
XTAP_1827 VGND VPWR sky130_fd_sc_hd__tapvpwrvgnd_1
XTAP_1838 VGND VPWR sky130_fd_sc_hd__tapvpwrvgnd_1
XFILLER_0_76_661 VGND VGND VPWR VPWR sky130_fd_sc_hd__decap_4
XFILLER_0_64_801 VGND VGND VPWR VPWR sky130_fd_sc_hd__fill_2
XFILLER_0_134_722 VGND VGND VPWR VPWR sky130_fd_sc_hd__decap_4
X_10570_ _03837_ _04778_ _03826_ VGND VGND VPWR VPWR _04779_ sky130_fd_sc_hd__a21o_1
XFILLER_0_119_785 VGND VGND VPWR VPWR sky130_fd_sc_hd__fill_1
XFILLER_0_90_130 VGND VGND VPWR VPWR sky130_fd_sc_hd__decap_3
XFILLER_0_133_243 VPWR VGND VPWR VGND sky130_ef_sc_hd__decap_12
X_09229_ _03488_ _03489_ _03467_ VGND VGND VPWR VPWR _03490_ sky130_fd_sc_hd__mux2_4
XFILLER_0_17_783 VGND VGND VPWR VPWR sky130_fd_sc_hd__fill_1
XFILLER_0_133_265 VGND VGND VPWR VPWR sky130_fd_sc_hd__decap_4
X_12240_ _05854_ _05856_ _05858_ _05859_ VGND VGND VPWR VPWR _05861_ sky130_fd_sc_hd__a31o_1
XFILLER_0_121_449 VGND VGND VPWR VPWR sky130_fd_sc_hd__decap_6
X_12171_ _05795_ _05796_ VGND VGND VPWR VPWR _05797_ sky130_fd_sc_hd__or2_1
X_11122_ net872 _03577_ _05146_ VGND VGND VPWR VPWR _05147_ sky130_fd_sc_hd__mux2_1
Xhold890 cpuregs\[25\]\[19\] VGND VGND VPWR VPWR net1248 sky130_fd_sc_hd__dlygate4sd3_1
X_11053_ _05087_ VGND VGND VPWR VPWR _05110_ sky130_fd_sc_hd__buf_4
X_15930_ clknet_leaf_6_clk _00580_ VGND VGND VPWR VPWR net235 sky130_fd_sc_hd__dfxtp_4
X_15861_ clknet_leaf_45_clk _00511_ VGND VGND VPWR VPWR cpuregs\[25\]\[27\] sky130_fd_sc_hd__dfxtp_1
X_10004_ _04153_ _04158_ _04186_ VGND VGND VPWR VPWR _04228_ sky130_fd_sc_hd__a21o_1
X_14812_ net1515 _05202_ _01778_ VGND VGND VPWR VPWR _01779_ sky130_fd_sc_hd__mux2_1
X_15792_ clknet_leaf_47_clk _00442_ VGND VGND VPWR VPWR cpuregs\[26\]\[22\] sky130_fd_sc_hd__dfxtp_1
XFILLER_0_99_764 VGND VGND VPWR VPWR sky130_fd_sc_hd__fill_2
X_14743_ _01719_ VGND VGND VPWR VPWR _01742_ sky130_fd_sc_hd__buf_4
XFILLER_0_99_775 VGND VGND VPWR VPWR sky130_fd_sc_hd__fill_1
X_11955_ _05636_ VGND VGND VPWR VPWR _00623_ sky130_fd_sc_hd__clkbuf_1
X_10906_ _04984_ VGND VGND VPWR VPWR _05027_ sky130_fd_sc_hd__buf_4
X_14674_ _01705_ VGND VGND VPWR VPWR _01208_ sky130_fd_sc_hd__clkbuf_1
XFILLER_0_80_29 VPWR VGND VPWR VGND sky130_ef_sc_hd__decap_12
X_13625_ _06962_ _07091_ _07098_ VGND VGND VPWR VPWR _07099_ sky130_fd_sc_hd__or3_1
X_16413_ clknet_leaf_139_clk _00995_ VGND VGND VPWR VPWR latched_rd\[4\] sky130_fd_sc_hd__dfxtp_1
X_11886_ _05585_ _05576_ _05586_ VGND VGND VPWR VPWR _05587_ sky130_fd_sc_hd__and3b_1
XFILLER_0_39_352 VGND VGND VPWR VPWR sky130_fd_sc_hd__fill_1
X_10837_ _04979_ VGND VGND VPWR VPWR _00162_ sky130_fd_sc_hd__clkbuf_1
XFILLER_0_125_722 VGND VGND VPWR VPWR sky130_fd_sc_hd__decap_6
X_13556_ _06868_ _07029_ _07031_ VGND VGND VPWR VPWR _07032_ sky130_fd_sc_hd__a21o_1
XFILLER_0_109_273 VGND VGND VPWR VPWR sky130_fd_sc_hd__decap_6
XFILLER_0_81_130 VGND VGND VPWR VPWR sky130_fd_sc_hd__decap_3
X_10768_ _04941_ VGND VGND VPWR VPWR _00131_ sky130_fd_sc_hd__clkbuf_1
XFILLER_0_66_182 VGND VGND VPWR VPWR sky130_fd_sc_hd__fill_1
XFILLER_0_6_419 VGND VGND VPWR VPWR sky130_fd_sc_hd__fill_1
X_16344_ clknet_leaf_109_clk _00926_ VGND VGND VPWR VPWR cpuregs\[1\]\[9\] sky130_fd_sc_hd__dfxtp_1
X_13487_ cpuregs\[10\]\[21\] cpuregs\[11\]\[21\] _06766_ VGND VGND VPWR VPWR _06965_
+ sky130_fd_sc_hd__mux2_1
XFILLER_0_89_38 VGND VGND VPWR VPWR sky130_fd_sc_hd__decap_6
XFILLER_0_14_219 VGND VGND VPWR VPWR sky130_fd_sc_hd__fill_1
X_12507_ _06101_ _06102_ _05523_ VGND VGND VPWR VPWR _06103_ sky130_fd_sc_hd__and3b_1
X_16275_ clknet_leaf_4_clk _00860_ VGND VGND VPWR VPWR instr_sh sky130_fd_sc_hd__dfxtp_1
XFILLER_0_42_506 VGND VGND VPWR VPWR sky130_fd_sc_hd__fill_2
X_12438_ _06038_ _06041_ VGND VGND VPWR VPWR _06043_ sky130_fd_sc_hd__nor2_1
X_15226_ _01998_ VGND VGND VPWR VPWR _01467_ sky130_fd_sc_hd__clkbuf_1
X_10699_ latched_rd\[0\] latched_rd\[1\] _03442_ VGND VGND VPWR VPWR _04904_ sky130_fd_sc_hd__or3_1
XFILLER_0_42_539 VGND VGND VPWR VPWR sky130_fd_sc_hd__fill_1
X_15157_ net1126 _03590_ _01959_ VGND VGND VPWR VPWR _01962_ sky130_fd_sc_hd__mux2_1
X_12369_ _05731_ _05733_ _05736_ _05956_ VGND VGND VPWR VPWR _05979_ sky130_fd_sc_hd__and4_1
X_15088_ _01925_ VGND VGND VPWR VPWR _01402_ sky130_fd_sc_hd__clkbuf_1
X_14108_ _07473_ VGND VGND VPWR VPWR _00918_ sky130_fd_sc_hd__clkbuf_1
XFILLER_0_129_66 VGND VGND VPWR VPWR sky130_fd_sc_hd__decap_3
X_14039_ decoded_imm_j\[13\] _01106_ _03430_ VGND VGND VPWR VPWR _07436_ sky130_fd_sc_hd__mux2_1
X_08600_ _02968_ _02969_ VGND VGND VPWR VPWR _02970_ sky130_fd_sc_hd__xnor2_1
XFILLER_0_89_241 VGND VGND VPWR VPWR sky130_fd_sc_hd__fill_2
X_09580_ _03661_ _03810_ _03813_ _00015_ VGND VGND VPWR VPWR _03814_ sky130_fd_sc_hd__a31o_1
X_08531_ _02888_ _02890_ _02901_ _02900_ VGND VGND VPWR VPWR _02906_ sky130_fd_sc_hd__o31a_1
X_08462_ _02132_ _02751_ _02839_ _02842_ VGND VGND VPWR VPWR _02843_ sky130_fd_sc_hd__a31o_1
XFILLER_0_92_406 VGND VGND VPWR VPWR sky130_fd_sc_hd__fill_2
X_08393_ net215 _02709_ VGND VGND VPWR VPWR _02774_ sky130_fd_sc_hd__nand2_1
XFILLER_0_70_62 VGND VGND VPWR VPWR sky130_fd_sc_hd__fill_1
XFILLER_0_116_755 VGND VGND VPWR VPWR sky130_fd_sc_hd__fill_1
XFILLER_0_72_163 VGND VGND VPWR VPWR sky130_fd_sc_hd__fill_1
X_09014_ decoded_imm_j\[17\] _01110_ _03296_ VGND VGND VPWR VPWR _03301_ sky130_fd_sc_hd__mux2_2
XFILLER_0_130_224 VGND VGND VPWR VPWR sky130_fd_sc_hd__fill_1
XFILLER_0_13_252 VGND VGND VPWR VPWR sky130_fd_sc_hd__fill_1
XFILLER_0_41_561 VGND VGND VPWR VPWR sky130_fd_sc_hd__fill_1
Xhold153 cpuregs\[0\]\[20\] VGND VGND VPWR VPWR net511 sky130_fd_sc_hd__dlygate4sd3_1
Xhold142 net163 VGND VGND VPWR VPWR net500 sky130_fd_sc_hd__dlygate4sd3_1
Xhold120 net37 VGND VGND VPWR VPWR net478 sky130_fd_sc_hd__dlygate4sd3_1
Xhold131 cpuregs\[0\]\[3\] VGND VGND VPWR VPWR net489 sky130_fd_sc_hd__dlygate4sd3_1
XFILLER_0_110_90 VGND VGND VPWR VPWR sky130_fd_sc_hd__decap_4
Xhold164 cpuregs\[0\]\[31\] VGND VGND VPWR VPWR net522 sky130_fd_sc_hd__dlygate4sd3_1
Xhold186 reg_next_pc\[3\] VGND VGND VPWR VPWR net544 sky130_fd_sc_hd__dlygate4sd3_1
Xhold175 net45 VGND VGND VPWR VPWR net533 sky130_fd_sc_hd__dlygate4sd3_1
Xhold197 net167 VGND VGND VPWR VPWR net555 sky130_fd_sc_hd__dlygate4sd3_1
X_09916_ _03837_ _04142_ _03839_ VGND VGND VPWR VPWR _04143_ sky130_fd_sc_hd__a21o_1
X_09847_ _04075_ _02325_ _03715_ VGND VGND VPWR VPWR _04076_ sky130_fd_sc_hd__mux2_1
XTAP_480 VGND VPWR sky130_fd_sc_hd__tapvpwrvgnd_1
XTAP_491 VGND VPWR sky130_fd_sc_hd__tapvpwrvgnd_1
X_09778_ _04003_ _04006_ VGND VGND VPWR VPWR _04008_ sky130_fd_sc_hd__and2_1
XTAP_2325 VGND VPWR sky130_fd_sc_hd__tapvpwrvgnd_1
XTAP_2303 VGND VPWR sky130_fd_sc_hd__tapvpwrvgnd_1
XTAP_2314 VGND VPWR sky130_fd_sc_hd__tapvpwrvgnd_1
X_08729_ net185 _03087_ VGND VGND VPWR VPWR _03088_ sky130_fd_sc_hd__nand2_1
XFILLER_0_96_712 VGND VGND VPWR VPWR sky130_fd_sc_hd__fill_1
XTAP_2347 VGND VPWR sky130_fd_sc_hd__tapvpwrvgnd_1
XTAP_2336 VGND VPWR sky130_fd_sc_hd__tapvpwrvgnd_1
XFILLER_0_95_233 VGND VGND VPWR VPWR sky130_fd_sc_hd__decap_8
XFILLER_0_95_222 VGND VGND VPWR VPWR sky130_fd_sc_hd__fill_2
XTAP_1624 VGND VPWR sky130_fd_sc_hd__tapvpwrvgnd_1
XTAP_1613 VGND VPWR sky130_fd_sc_hd__tapvpwrvgnd_1
XTAP_1602 VGND VPWR sky130_fd_sc_hd__tapvpwrvgnd_1
X_11740_ _05490_ VGND VGND VPWR VPWR _00554_ sky130_fd_sc_hd__clkbuf_1
XTAP_1657 VGND VPWR sky130_fd_sc_hd__tapvpwrvgnd_1
XTAP_1635 VGND VPWR sky130_fd_sc_hd__tapvpwrvgnd_1
XTAP_1646 VGND VPWR sky130_fd_sc_hd__tapvpwrvgnd_1
XFILLER_0_138_346 VGND VGND VPWR VPWR sky130_fd_sc_hd__fill_1
XTAP_1679 VGND VPWR sky130_fd_sc_hd__tapvpwrvgnd_1
XTAP_1668 VGND VPWR sky130_fd_sc_hd__tapvpwrvgnd_1
X_11671_ net1469 _05173_ _05447_ VGND VGND VPWR VPWR _05454_ sky130_fd_sc_hd__mux2_1
X_10622_ _04829_ VGND VGND VPWR VPWR _00097_ sky130_fd_sc_hd__clkbuf_1
XFILLER_0_107_700 VGND VGND VPWR VPWR sky130_fd_sc_hd__decap_3
X_13410_ cpuregs\[28\]\[18\] cpuregs\[29\]\[18\] _06687_ VGND VGND VPWR VPWR _06891_
+ sky130_fd_sc_hd__mux2_1
X_14390_ _01555_ VGND VGND VPWR VPWR _01042_ sky130_fd_sc_hd__clkbuf_1
XFILLER_0_63_130 VGND VGND VPWR VPWR sky130_fd_sc_hd__decap_4
XFILLER_0_9_780 VGND VGND VPWR VPWR sky130_fd_sc_hd__decap_4
X_10553_ _04116_ _04757_ _04761_ _04063_ VGND VGND VPWR VPWR _04762_ sky130_fd_sc_hd__o211a_1
X_13341_ _06783_ _06821_ _06823_ _06789_ VGND VGND VPWR VPWR _06824_ sky130_fd_sc_hd__a211o_1
XFILLER_0_51_314 VPWR VGND VPWR VGND sky130_ef_sc_hd__decap_12
X_16060_ clknet_leaf_150_clk _00710_ VGND VGND VPWR VPWR count_cycle\[3\] sky130_fd_sc_hd__dfxtp_1
X_10484_ _03834_ _04692_ _04694_ VGND VGND VPWR VPWR _04695_ sky130_fd_sc_hd__a21o_1
X_15011_ _01884_ VGND VGND VPWR VPWR _01366_ sky130_fd_sc_hd__clkbuf_1
X_13272_ _06459_ _06753_ _06756_ _06563_ VGND VGND VPWR VPWR _06757_ sky130_fd_sc_hd__a211o_1
XFILLER_0_59_19 VGND VGND VPWR VPWR sky130_fd_sc_hd__fill_2
X_12223_ latched_branch latched_store _03493_ VGND VGND VPWR VPWR _05845_ sky130_fd_sc_hd__and3_1
XFILLER_0_121_279 VGND VGND VPWR VPWR sky130_fd_sc_hd__fill_1
X_12154_ _05777_ _05772_ _05780_ VGND VGND VPWR VPWR _05781_ sky130_fd_sc_hd__a21bo_1
XFILLER_0_75_18 VGND VGND VPWR VPWR sky130_fd_sc_hd__decap_8
X_11105_ net985 _03525_ _05135_ VGND VGND VPWR VPWR _05138_ sky130_fd_sc_hd__mux2_1
X_12085_ _05690_ reg_pc\[17\] VGND VGND VPWR VPWR _05729_ sky130_fd_sc_hd__or2_1
X_16962_ clknet_leaf_104_clk _01526_ VGND VGND VPWR VPWR cpuregs\[10\]\[17\] sky130_fd_sc_hd__dfxtp_1
X_15913_ clknet_leaf_53_clk _00563_ VGND VGND VPWR VPWR cpuregs\[17\]\[15\] sky130_fd_sc_hd__dfxtp_1
X_16893_ clknet_leaf_106_clk _01457_ VGND VGND VPWR VPWR cpuregs\[8\]\[12\] sky130_fd_sc_hd__dfxtp_1
X_11036_ _05101_ VGND VGND VPWR VPWR _00239_ sky130_fd_sc_hd__clkbuf_1
X_15844_ clknet_leaf_138_clk _00494_ VGND VGND VPWR VPWR cpuregs\[25\]\[10\] sky130_fd_sc_hd__dfxtp_1
XFILLER_0_91_17 VGND VGND VPWR VPWR sky130_fd_sc_hd__fill_2
X_15775_ clknet_leaf_128_clk _00425_ VGND VGND VPWR VPWR cpuregs\[26\]\[5\] sky130_fd_sc_hd__dfxtp_1
X_14726_ _01733_ VGND VGND VPWR VPWR _01232_ sky130_fd_sc_hd__clkbuf_1
XFILLER_0_24_11 VGND VGND VPWR VPWR sky130_fd_sc_hd__fill_1
X_12987_ _06431_ _06479_ VGND VGND VPWR VPWR _06480_ sky130_fd_sc_hd__and2_1
XFILLER_0_115_57 VGND VGND VPWR VPWR sky130_fd_sc_hd__fill_2
X_11938_ _05539_ _05623_ VGND VGND VPWR VPWR _05624_ sky130_fd_sc_hd__nor2_1
XFILLER_0_129_346 VGND VGND VPWR VPWR sky130_fd_sc_hd__fill_2
X_14657_ net1197 _05184_ _01695_ VGND VGND VPWR VPWR _01697_ sky130_fd_sc_hd__mux2_1
XFILLER_0_46_119 VGND VGND VPWR VPWR sky130_fd_sc_hd__fill_2
X_11869_ _05572_ _05530_ _05573_ VGND VGND VPWR VPWR _05574_ sky130_fd_sc_hd__and3b_1
X_13608_ _06780_ _07072_ _07076_ _07082_ _06800_ VGND VGND VPWR VPWR _07083_ sky130_fd_sc_hd__a311o_1
X_14588_ _01660_ VGND VGND VPWR VPWR _01167_ sky130_fd_sc_hd__clkbuf_1
X_13539_ _06783_ _07012_ _07015_ _06789_ VGND VGND VPWR VPWR _07016_ sky130_fd_sc_hd__a211o_1
XFILLER_0_54_163 VGND VGND VPWR VPWR sky130_fd_sc_hd__decap_6
XFILLER_0_54_141 VGND VGND VPWR VPWR sky130_fd_sc_hd__fill_2
X_16327_ clknet_leaf_2_clk _00911_ VGND VGND VPWR VPWR is_lb_lh_lw_lbu_lhu sky130_fd_sc_hd__dfxtp_1
XFILLER_0_140_511 VGND VGND VPWR VPWR sky130_fd_sc_hd__fill_1
X_16258_ clknet_leaf_39_clk alu_out\[31\] VGND VGND VPWR VPWR alu_out_q\[31\] sky130_fd_sc_hd__dfxtp_1
XFILLER_0_2_400 VGND VGND VPWR VPWR sky130_fd_sc_hd__fill_1
XFILLER_0_23_550 VGND VGND VPWR VPWR sky130_fd_sc_hd__fill_1
Xoutput225 net225 VGND VGND VPWR VPWR pcpi_rs2[2] sky130_fd_sc_hd__clkbuf_4
XFILLER_0_140_544 VGND VGND VPWR VPWR sky130_fd_sc_hd__fill_2
XFILLER_0_112_257 VGND VGND VPWR VPWR sky130_fd_sc_hd__fill_2
X_15209_ _01989_ VGND VGND VPWR VPWR _01459_ sky130_fd_sc_hd__clkbuf_1
Xoutput203 net203 VGND VGND VPWR VPWR pcpi_rs2[0] sky130_fd_sc_hd__clkbuf_4
Xoutput214 net214 VGND VGND VPWR VPWR pcpi_rs2[1] sky130_fd_sc_hd__clkbuf_4
XFILLER_0_23_561 VGND VGND VPWR VPWR sky130_fd_sc_hd__fill_1
X_16189_ clknet_leaf_139_clk _00806_ VGND VGND VPWR VPWR net97 sky130_fd_sc_hd__dfxtp_4
XFILLER_0_10_222 VGND VGND VPWR VPWR sky130_fd_sc_hd__fill_1
XFILLER_0_2_477 VGND VGND VPWR VPWR sky130_fd_sc_hd__fill_1
XFILLER_0_10_266 VGND VGND VPWR VPWR sky130_fd_sc_hd__fill_1
X_07962_ _02336_ _02364_ _02338_ VGND VGND VPWR VPWR _02365_ sky130_fd_sc_hd__a21o_1
XFILLER_0_4_21 VGND VGND VPWR VPWR sky130_fd_sc_hd__decap_6
X_09701_ _03688_ _03924_ _03932_ VGND VGND VPWR VPWR _03933_ sky130_fd_sc_hd__or3b_2
X_07893_ count_instr\[6\] _02270_ count_cycle\[38\] _02204_ VGND VGND VPWR VPWR _02300_
+ sky130_fd_sc_hd__a22o_1
X_09632_ _03864_ VGND VGND VPWR VPWR _03865_ sky130_fd_sc_hd__buf_6
XFILLER_0_65_62 VGND VGND VPWR VPWR sky130_fd_sc_hd__decap_4
X_09563_ _03664_ VGND VGND VPWR VPWR _03797_ sky130_fd_sc_hd__clkbuf_8
XFILLER_0_77_211 VGND VGND VPWR VPWR sky130_fd_sc_hd__decap_3
X_08514_ _02890_ VGND VGND VPWR VPWR _02891_ sky130_fd_sc_hd__inv_2
XFILLER_0_81_50 VGND VGND VPWR VPWR sky130_fd_sc_hd__decap_6
X_09494_ _03727_ _03728_ VGND VGND VPWR VPWR _03729_ sky130_fd_sc_hd__or2_1
XFILLER_0_136_817 VGND VGND VPWR VPWR sky130_fd_sc_hd__fill_2
X_08445_ _02744_ _02825_ VGND VGND VPWR VPWR _02826_ sky130_fd_sc_hd__nor2_1
XFILLER_0_93_726 VGND VGND VPWR VPWR sky130_fd_sc_hd__fill_2
XFILLER_0_136_828 VGND VGND VPWR VPWR sky130_fd_sc_hd__fill_1
X_08376_ _02243_ net252 VGND VGND VPWR VPWR _02757_ sky130_fd_sc_hd__nand2_1
XFILLER_0_18_333 VGND VGND VPWR VPWR sky130_fd_sc_hd__fill_1
XFILLER_0_116_541 VGND VGND VPWR VPWR sky130_fd_sc_hd__fill_2
XFILLER_0_6_761 VGND VGND VPWR VPWR sky130_fd_sc_hd__fill_1
XFILLER_0_131_500 VGND VGND VPWR VPWR sky130_fd_sc_hd__decap_4
XFILLER_0_103_202 VGND VGND VPWR VPWR sky130_fd_sc_hd__decap_3
XFILLER_0_60_177 VGND VGND VPWR VPWR sky130_fd_sc_hd__fill_2
X_13890_ instr_blt _07325_ _07339_ _02149_ VGND VGND VPWR VPWR _07340_ sky130_fd_sc_hd__a22o_1
X_12910_ _06407_ VGND VGND VPWR VPWR _00807_ sky130_fd_sc_hd__clkbuf_1
XTAP_2100 VGND VPWR sky130_fd_sc_hd__tapvpwrvgnd_1
X_12841_ mem_do_wdata _02092_ _06340_ _02104_ VGND VGND VPWR VPWR _00805_ sky130_fd_sc_hd__a22o_1
XTAP_2144 VGND VPWR sky130_fd_sc_hd__tapvpwrvgnd_1
XTAP_2122 VGND VPWR sky130_fd_sc_hd__tapvpwrvgnd_1
XTAP_2133 VGND VPWR sky130_fd_sc_hd__tapvpwrvgnd_1
XTAP_2111 VGND VPWR sky130_fd_sc_hd__tapvpwrvgnd_1
XTAP_2177 VGND VPWR sky130_fd_sc_hd__tapvpwrvgnd_1
XTAP_2166 VGND VPWR sky130_fd_sc_hd__tapvpwrvgnd_1
X_12772_ net62 net93 _06294_ VGND VGND VPWR VPWR _06300_ sky130_fd_sc_hd__mux2_1
XTAP_2155 VGND VPWR sky130_fd_sc_hd__tapvpwrvgnd_1
XFILLER_0_96_542 VGND VGND VPWR VPWR sky130_fd_sc_hd__fill_2
XTAP_1432 VGND VPWR sky130_fd_sc_hd__tapvpwrvgnd_1
XTAP_1421 VGND VPWR sky130_fd_sc_hd__tapvpwrvgnd_1
XTAP_1410 VGND VPWR sky130_fd_sc_hd__tapvpwrvgnd_1
X_15560_ clknet_leaf_87_clk _00210_ VGND VGND VPWR VPWR cpuregs\[2\]\[14\] sky130_fd_sc_hd__dfxtp_1
XFILLER_0_138_121 VGND VGND VPWR VPWR sky130_fd_sc_hd__decap_3
XTAP_2199 VGND VPWR sky130_fd_sc_hd__tapvpwrvgnd_1
XTAP_2188 VGND VPWR sky130_fd_sc_hd__tapvpwrvgnd_1
XTAP_1454 VGND VPWR sky130_fd_sc_hd__tapvpwrvgnd_1
XTAP_1465 VGND VPWR sky130_fd_sc_hd__tapvpwrvgnd_1
XTAP_1443 VGND VPWR sky130_fd_sc_hd__tapvpwrvgnd_1
X_11723_ net1014 _05225_ _05446_ VGND VGND VPWR VPWR _05481_ sky130_fd_sc_hd__mux2_1
XFILLER_0_68_299 VGND VGND VPWR VPWR sky130_fd_sc_hd__decap_8
X_14511_ _01619_ VGND VGND VPWR VPWR _01131_ sky130_fd_sc_hd__clkbuf_1
X_15491_ clknet_leaf_134_clk _00141_ VGND VGND VPWR VPWR cpuregs\[30\]\[9\] sky130_fd_sc_hd__dfxtp_1
X_11654_ _05444_ VGND VGND VPWR VPWR _00514_ sky130_fd_sc_hd__clkbuf_1
XTAP_1498 VGND VPWR sky130_fd_sc_hd__tapvpwrvgnd_1
XTAP_1487 VGND VPWR sky130_fd_sc_hd__tapvpwrvgnd_1
XTAP_1476 VGND VPWR sky130_fd_sc_hd__tapvpwrvgnd_1
X_14442_ net1131 _05173_ _01576_ VGND VGND VPWR VPWR _01583_ sky130_fd_sc_hd__mux2_1
X_10605_ cpuregs\[16\]\[28\] cpuregs\[17\]\[28\] cpuregs\[18\]\[28\] cpuregs\[19\]\[28\]
+ _03875_ _03726_ VGND VGND VPWR VPWR _04813_ sky130_fd_sc_hd__mux4_1
XFILLER_0_52_612 VGND VGND VPWR VPWR sky130_fd_sc_hd__fill_1
XFILLER_0_25_815 VGND VGND VPWR VPWR sky130_fd_sc_hd__fill_1
X_11585_ _05047_ net1214 _05374_ VGND VGND VPWR VPWR _05408_ sky130_fd_sc_hd__mux2_1
X_16112_ clknet_leaf_154_clk _00762_ VGND VGND VPWR VPWR count_cycle\[55\] sky130_fd_sc_hd__dfxtp_1
X_14373_ _01546_ VGND VGND VPWR VPWR _01034_ sky130_fd_sc_hd__clkbuf_1
XFILLER_0_37_697 VGND VGND VPWR VPWR sky130_fd_sc_hd__fill_2
XFILLER_0_122_511 VGND VGND VPWR VPWR sky130_fd_sc_hd__fill_1
X_10536_ _04742_ _04743_ _04744_ _04745_ _03676_ _04103_ VGND VGND VPWR VPWR _04746_
+ sky130_fd_sc_hd__mux4_1
XFILLER_0_107_585 VGND VGND VPWR VPWR sky130_fd_sc_hd__decap_4
X_13324_ cpuregs\[10\]\[16\] cpuregs\[11\]\[16\] _06766_ VGND VGND VPWR VPWR _06807_
+ sky130_fd_sc_hd__mux2_1
XFILLER_0_51_155 VGND VGND VPWR VPWR sky130_fd_sc_hd__decap_3
X_10467_ _02509_ _02621_ _03650_ VGND VGND VPWR VPWR _04679_ sky130_fd_sc_hd__mux2_1
X_16043_ clknet_leaf_29_clk _00693_ VGND VGND VPWR VPWR reg_next_pc\[18\] sky130_fd_sc_hd__dfxtp_1
X_13255_ _03322_ VGND VGND VPWR VPWR _06740_ sky130_fd_sc_hd__clkbuf_8
X_12206_ _05827_ _05828_ VGND VGND VPWR VPWR _05829_ sky130_fd_sc_hd__nor2_1
X_10398_ decoded_imm\[23\] net186 VGND VGND VPWR VPWR _04611_ sky130_fd_sc_hd__nor2_1
X_13186_ cpuregs\[6\]\[12\] cpuregs\[7\]\[12\] _06511_ VGND VGND VPWR VPWR _06673_
+ sky130_fd_sc_hd__mux2_1
XFILLER_0_20_564 VGND VGND VPWR VPWR sky130_fd_sc_hd__decap_3
X_12137_ _05689_ _05765_ VGND VGND VPWR VPWR _05766_ sky130_fd_sc_hd__nor2_1
X_12068_ _05686_ _05716_ VGND VGND VPWR VPWR _05717_ sky130_fd_sc_hd__or2_1
X_16945_ clknet_leaf_120_clk _01509_ VGND VGND VPWR VPWR cpuregs\[10\]\[0\] sky130_fd_sc_hd__dfxtp_1
X_11019_ _05092_ VGND VGND VPWR VPWR _00231_ sky130_fd_sc_hd__clkbuf_1
X_16876_ clknet_leaf_63_clk _01440_ VGND VGND VPWR VPWR cpuregs\[22\]\[27\] sky130_fd_sc_hd__dfxtp_1
XFILLER_0_35_43 VGND VGND VPWR VPWR sky130_fd_sc_hd__decap_3
X_15827_ clknet_leaf_64_clk _00477_ VGND VGND VPWR VPWR cpuregs\[16\]\[25\] sky130_fd_sc_hd__dfxtp_1
XFILLER_0_99_391 VGND VGND VPWR VPWR sky130_fd_sc_hd__fill_1
XFILLER_0_59_222 VGND VGND VPWR VPWR sky130_fd_sc_hd__fill_2
XFILLER_0_35_54 VGND VGND VPWR VPWR sky130_fd_sc_hd__fill_2
X_15758_ clknet_leaf_82_clk _00408_ VGND VGND VPWR VPWR cpuregs\[15\]\[20\] sky130_fd_sc_hd__dfxtp_1
X_15689_ clknet_leaf_55_clk _00339_ VGND VGND VPWR VPWR cpuregs\[27\]\[15\] sky130_fd_sc_hd__dfxtp_1
X_14709_ _01724_ VGND VGND VPWR VPWR _01224_ sky130_fd_sc_hd__clkbuf_1
X_08230_ reg_pc\[28\] decoded_imm\[28\] VGND VGND VPWR VPWR _02615_ sky130_fd_sc_hd__or2_1
XFILLER_0_74_258 VPWR VGND VPWR VGND sky130_ef_sc_hd__decap_12
XFILLER_0_7_503 VGND VGND VPWR VPWR sky130_fd_sc_hd__fill_1
XFILLER_0_7_558 VGND VGND VPWR VPWR sky130_fd_sc_hd__fill_2
X_08161_ _02456_ count_cycle\[55\] _02235_ _02550_ VGND VGND VPWR VPWR _02551_ sky130_fd_sc_hd__a211o_1
X_08092_ _02476_ _02477_ VGND VGND VPWR VPWR _02486_ sky130_fd_sc_hd__or2b_1
XFILLER_0_15_347 VGND VGND VPWR VPWR sky130_fd_sc_hd__decap_4
XFILLER_0_43_667 VGND VGND VPWR VPWR sky130_fd_sc_hd__fill_1
XFILLER_0_125_393 VGND VGND VPWR VPWR sky130_fd_sc_hd__fill_2
XFILLER_0_70_475 VGND VGND VPWR VPWR sky130_fd_sc_hd__fill_1
XFILLER_0_42_188 VGND VGND VPWR VPWR sky130_fd_sc_hd__fill_2
XFILLER_0_140_374 VGND VGND VPWR VPWR sky130_fd_sc_hd__fill_1
XFILLER_0_3_797 VPWR VGND VPWR VGND sky130_ef_sc_hd__decap_12
X_08994_ _02646_ _03287_ _03268_ VGND VGND VPWR VPWR _03288_ sky130_fd_sc_hd__mux2_1
XFILLER_0_76_83 VGND VGND VPWR VPWR sky130_fd_sc_hd__fill_1
X_07945_ _02347_ _02348_ VGND VGND VPWR VPWR _02349_ sky130_fd_sc_hd__nand2_1
X_09615_ _02310_ _02156_ _03652_ _03848_ VGND VGND VPWR VPWR _03849_ sky130_fd_sc_hd__a31o_1
X_07876_ _02207_ _02280_ _02283_ _02194_ _02284_ VGND VGND VPWR VPWR _02285_ sky130_fd_sc_hd__a221o_1
XFILLER_0_92_60 VPWR VGND VPWR VGND sky130_ef_sc_hd__decap_12
X_09546_ _03653_ _03778_ _03779_ _03780_ VGND VGND VPWR VPWR _03781_ sky130_fd_sc_hd__o211a_1
X_09477_ mem_do_wdata cpu_state\[5\] _02116_ _03709_ _03712_ VGND VGND VPWR VPWR _03713_
+ sky130_fd_sc_hd__a221o_1
X_08428_ _02808_ _02722_ VGND VGND VPWR VPWR _02809_ sky130_fd_sc_hd__and2b_1
XFILLER_0_108_305 VGND VGND VPWR VPWR sky130_fd_sc_hd__decap_3
XFILLER_0_135_113 VGND VGND VPWR VPWR sky130_fd_sc_hd__fill_2
XFILLER_0_108_327 VGND VGND VPWR VPWR sky130_fd_sc_hd__fill_1
XFILLER_0_81_729 VGND VGND VPWR VPWR sky130_fd_sc_hd__fill_1
XFILLER_0_65_269 VGND VGND VPWR VPWR sky130_fd_sc_hd__decap_8
XFILLER_0_18_141 VGND VGND VPWR VPWR sky130_fd_sc_hd__fill_1
X_08359_ net194 net226 VGND VGND VPWR VPWR _02740_ sky130_fd_sc_hd__or2_1
X_11370_ _05037_ net1495 _05288_ VGND VGND VPWR VPWR _05294_ sky130_fd_sc_hd__mux2_1
XFILLER_0_104_533 VGND VGND VPWR VPWR sky130_fd_sc_hd__fill_2
X_10321_ _03690_ _04536_ _03959_ VGND VGND VPWR VPWR _04537_ sky130_fd_sc_hd__o21a_1
XFILLER_0_61_475 VGND VGND VPWR VPWR sky130_fd_sc_hd__decap_4
X_13040_ _06441_ _06520_ _06524_ _06531_ _06468_ VGND VGND VPWR VPWR _06532_ sky130_fd_sc_hd__a311o_1
X_10252_ reg_pc\[18\] _03992_ _04463_ _04469_ _03702_ VGND VGND VPWR VPWR _04470_
+ sky130_fd_sc_hd__a221o_1
X_10183_ decoded_imm\[17\] net179 VGND VGND VPWR VPWR _04402_ sky130_fd_sc_hd__nand2_1
X_14991_ _03498_ net1049 _01865_ VGND VGND VPWR VPWR _01874_ sky130_fd_sc_hd__mux2_1
X_13942_ _07332_ _07373_ VGND VGND VPWR VPWR _07374_ sky130_fd_sc_hd__and2_1
X_16730_ clknet_leaf_109_clk _01294_ VGND VGND VPWR VPWR cpuregs\[4\]\[9\] sky130_fd_sc_hd__dfxtp_1
X_13873_ _07324_ VGND VGND VPWR VPWR _07325_ sky130_fd_sc_hd__clkbuf_4
X_16661_ clknet_leaf_130_clk _01228_ VGND VGND VPWR VPWR cpuregs\[29\]\[7\] sky130_fd_sc_hd__dfxtp_1
XFILLER_0_69_564 VGND VGND VPWR VPWR sky130_fd_sc_hd__fill_1
XFILLER_0_57_704 VGND VGND VPWR VPWR sky130_fd_sc_hd__fill_1
X_16592_ clknet_leaf_101_clk _01159_ VGND VGND VPWR VPWR cpuregs\[9\]\[2\] sky130_fd_sc_hd__dfxtp_1
X_12824_ instr_jalr VGND VGND VPWR VPWR _06327_ sky130_fd_sc_hd__inv_2
X_15612_ clknet_leaf_132_clk _00262_ VGND VGND VPWR VPWR cpuregs\[31\]\[2\] sky130_fd_sc_hd__dfxtp_1
X_12755_ _06288_ VGND VGND VPWR VPWR _00771_ sky130_fd_sc_hd__clkbuf_1
X_15543_ clknet_leaf_70_clk _00193_ VGND VGND VPWR VPWR cpuregs\[13\]\[29\] sky130_fd_sc_hd__dfxtp_1
XTAP_1240 VGND VPWR sky130_fd_sc_hd__tapvpwrvgnd_1
XFILLER_0_57_737 VGND VGND VPWR VPWR sky130_fd_sc_hd__fill_2
X_11706_ _05472_ VGND VGND VPWR VPWR _00538_ sky130_fd_sc_hd__clkbuf_1
XTAP_1284 VGND VPWR sky130_fd_sc_hd__tapvpwrvgnd_1
XTAP_1262 VGND VPWR sky130_fd_sc_hd__tapvpwrvgnd_1
XTAP_1273 VGND VPWR sky130_fd_sc_hd__tapvpwrvgnd_1
XTAP_1251 VGND VPWR sky130_fd_sc_hd__tapvpwrvgnd_1
XFILLER_0_56_236 VGND VGND VPWR VPWR sky130_fd_sc_hd__fill_1
X_15474_ clknet_leaf_81_clk _00124_ VGND VGND VPWR VPWR cpuregs\[12\]\[24\] sky130_fd_sc_hd__dfxtp_1
XTAP_1295 VGND VPWR sky130_fd_sc_hd__tapvpwrvgnd_1
X_12686_ _06229_ VGND VGND VPWR VPWR _06230_ sky130_fd_sc_hd__buf_4
X_11637_ _05031_ net1366 _05433_ VGND VGND VPWR VPWR _05436_ sky130_fd_sc_hd__mux2_1
X_14425_ _01573_ VGND VGND VPWR VPWR _01059_ sky130_fd_sc_hd__clkbuf_1
XFILLER_0_135_691 VGND VGND VPWR VPWR sky130_fd_sc_hd__fill_1
X_11568_ _05399_ VGND VGND VPWR VPWR _00473_ sky130_fd_sc_hd__clkbuf_1
X_14356_ net1511 _07575_ _07611_ _07612_ VGND VGND VPWR VPWR _01027_ sky130_fd_sc_hd__o22a_1
XFILLER_0_4_539 VGND VGND VPWR VPWR sky130_fd_sc_hd__fill_2
XFILLER_0_25_656 VGND VGND VPWR VPWR sky130_fd_sc_hd__fill_2
X_10519_ cpuregs\[8\]\[26\] cpuregs\[9\]\[26\] cpuregs\[10\]\[26\] cpuregs\[11\]\[26\]
+ _03876_ _03727_ VGND VGND VPWR VPWR _04729_ sky130_fd_sc_hd__mux4_1
XFILLER_0_97_27 VGND VGND VPWR VPWR sky130_fd_sc_hd__fill_1
X_13307_ cpuregs\[24\]\[15\] cpuregs\[25\]\[15\] cpuregs\[26\]\[15\] cpuregs\[27\]\[15\]
+ _06525_ _06558_ VGND VGND VPWR VPWR _06791_ sky130_fd_sc_hd__mux4_1
Xhold719 cpuregs\[8\]\[12\] VGND VGND VPWR VPWR net1077 sky130_fd_sc_hd__dlygate4sd3_1
Xhold708 cpuregs\[28\]\[11\] VGND VGND VPWR VPWR net1066 sky130_fd_sc_hd__dlygate4sd3_1
X_11499_ _05362_ VGND VGND VPWR VPWR _00441_ sky130_fd_sc_hd__clkbuf_1
X_14287_ mem_rdata_q\[31\] _07460_ VGND VGND VPWR VPWR _07572_ sky130_fd_sc_hd__and2_1
X_16026_ clknet_leaf_7_clk _00676_ VGND VGND VPWR VPWR reg_next_pc\[1\] sky130_fd_sc_hd__dfxtp_1
XFILLER_0_122_396 VGND VGND VPWR VPWR sky130_fd_sc_hd__decap_4
X_13238_ _06455_ _06719_ _06723_ _06466_ VGND VGND VPWR VPWR _06724_ sky130_fd_sc_hd__o211a_1
X_13169_ cpuregs\[30\]\[11\] cpuregs\[31\]\[11\] _06462_ VGND VGND VPWR VPWR _06657_
+ sky130_fd_sc_hd__mux2_1
XFILLER_0_137_22 VGND VGND VPWR VPWR sky130_fd_sc_hd__fill_1
XFILLER_0_137_44 VPWR VGND VPWR VGND sky130_ef_sc_hd__decap_12
X_07730_ cpu_state\[6\] cpu_state\[5\] VGND VGND VPWR VPWR _02152_ sky130_fd_sc_hd__nor2_4
X_16928_ clknet_leaf_82_clk _01492_ VGND VGND VPWR VPWR cpuregs\[0\]\[15\] sky130_fd_sc_hd__dfxtp_1
XFILLER_0_46_75 VGND VGND VPWR VPWR sky130_fd_sc_hd__decap_8
X_16859_ clknet_leaf_137_clk _01423_ VGND VGND VPWR VPWR cpuregs\[22\]\[10\] sky130_fd_sc_hd__dfxtp_1
X_07661_ mem_do_rinst _02086_ _02090_ VGND VGND VPWR VPWR _02091_ sky130_fd_sc_hd__a21o_1
X_09400_ reg_pc\[30\] _03631_ VGND VGND VPWR VPWR _03638_ sky130_fd_sc_hd__nand2_1
XFILLER_0_1_55 VGND VGND VPWR VPWR sky130_fd_sc_hd__fill_1
X_09331_ net626 _03577_ _03578_ VGND VGND VPWR VPWR _03579_ sky130_fd_sc_hd__mux2_1
XFILLER_0_47_225 VGND VGND VPWR VPWR sky130_fd_sc_hd__fill_2
XFILLER_0_63_729 VGND VGND VPWR VPWR sky130_fd_sc_hd__fill_1
X_09262_ _03518_ VGND VGND VPWR VPWR _03519_ sky130_fd_sc_hd__buf_2
X_08213_ reg_pc\[27\] decoded_imm\[27\] VGND VGND VPWR VPWR _02599_ sky130_fd_sc_hd__nor2_1
X_09193_ reg_out\[3\] alu_out_q\[3\] latched_stalu VGND VGND VPWR VPWR _03458_ sky130_fd_sc_hd__mux2_1
XFILLER_0_16_634 VGND VGND VPWR VPWR sky130_fd_sc_hd__fill_2
XFILLER_0_132_116 VGND VGND VPWR VPWR sky130_fd_sc_hd__decap_4
XFILLER_0_105_319 VGND VGND VPWR VPWR sky130_fd_sc_hd__decap_3
X_08144_ net15 _02448_ _02429_ VGND VGND VPWR VPWR _02535_ sky130_fd_sc_hd__a21o_1
XFILLER_0_7_388 VGND VGND VPWR VPWR sky130_fd_sc_hd__decap_4
XFILLER_0_101_503 VGND VGND VPWR VPWR sky130_fd_sc_hd__fill_1
X_08075_ _02286_ _02458_ _02470_ VGND VGND VPWR VPWR _07626_ sky130_fd_sc_hd__o21a_1
XFILLER_0_140_182 VPWR VGND VPWR VGND sky130_ef_sc_hd__decap_12
X_08977_ _03276_ VGND VGND VPWR VPWR net80 sky130_fd_sc_hd__buf_1
Xhold46 mem_wordsize\[0\] VGND VGND VPWR VPWR net404 sky130_fd_sc_hd__dlygate4sd3_1
Xhold35 instr_sltu VGND VGND VPWR VPWR net393 sky130_fd_sc_hd__dlygate4sd3_1
Xhold79 reg_next_pc\[29\] VGND VGND VPWR VPWR net437 sky130_fd_sc_hd__dlygate4sd3_1
X_07928_ reg_pc\[8\] decoded_imm\[8\] VGND VGND VPWR VPWR _02333_ sky130_fd_sc_hd__nand2_1
Xhold68 reg_next_pc\[5\] VGND VGND VPWR VPWR net426 sky130_fd_sc_hd__dlygate4sd3_1
Xhold57 count_cycle\[1\] VGND VGND VPWR VPWR net415 sky130_fd_sc_hd__dlygate4sd3_1
X_07859_ _02234_ VGND VGND VPWR VPWR _02268_ sky130_fd_sc_hd__buf_4
X_10870_ _05002_ VGND VGND VPWR VPWR _00172_ sky130_fd_sc_hd__clkbuf_1
XFILLER_0_97_169 VGND VGND VPWR VPWR sky130_fd_sc_hd__decap_4
XFILLER_0_94_810 VGND VGND VPWR VPWR sky130_fd_sc_hd__fill_2
XFILLER_0_66_501 VGND VGND VPWR VPWR sky130_fd_sc_hd__decap_4
X_09529_ cpuregs\[0\]\[1\] cpuregs\[1\]\[1\] cpuregs\[2\]\[1\] cpuregs\[3\]\[1\] _03680_
+ _03670_ VGND VGND VPWR VPWR _03764_ sky130_fd_sc_hd__mux4_1
XFILLER_0_78_394 VGND VGND VPWR VPWR sky130_fd_sc_hd__fill_1
X_12540_ _06124_ _05661_ _06125_ VGND VGND VPWR VPWR _06126_ sky130_fd_sc_hd__and3b_1
XFILLER_0_38_269 VGND VGND VPWR VPWR sky130_fd_sc_hd__fill_1
X_12471_ _05852_ net477 _05526_ _06072_ VGND VGND VPWR VPWR _00703_ sky130_fd_sc_hd__o211a_1
XFILLER_0_136_477 VGND VGND VPWR VPWR sky130_fd_sc_hd__fill_1
XFILLER_0_108_168 VGND VGND VPWR VPWR sky130_fd_sc_hd__decap_6
XFILLER_0_105_820 VGND VGND VPWR VPWR sky130_fd_sc_hd__fill_2
X_11422_ _05321_ VGND VGND VPWR VPWR _00405_ sky130_fd_sc_hd__clkbuf_1
XFILLER_0_46_291 VGND VGND VPWR VPWR sky130_fd_sc_hd__fill_1
X_14210_ _07529_ VGND VGND VPWR VPWR _00964_ sky130_fd_sc_hd__clkbuf_1
X_15190_ _01979_ VGND VGND VPWR VPWR _01450_ sky130_fd_sc_hd__clkbuf_1
X_14141_ _07490_ VGND VGND VPWR VPWR _00934_ sky130_fd_sc_hd__clkbuf_1
XFILLER_0_34_475 VGND VGND VPWR VPWR sky130_fd_sc_hd__fill_1
XFILLER_0_104_363 VGND VGND VPWR VPWR sky130_fd_sc_hd__fill_1
X_11353_ _05020_ net1295 _05277_ VGND VGND VPWR VPWR _05285_ sky130_fd_sc_hd__mux2_1
X_10304_ cpuregs\[14\]\[20\] cpuregs\[15\]\[20\] _03756_ VGND VGND VPWR VPWR _04520_
+ sky130_fd_sc_hd__mux2_1
X_14072_ _07452_ VGND VGND VPWR VPWR _00903_ sky130_fd_sc_hd__clkbuf_1
X_11284_ net1108 _05196_ _05240_ VGND VGND VPWR VPWR _05248_ sky130_fd_sc_hd__mux2_1
XFILLER_0_21_169 VGND VGND VPWR VPWR sky130_fd_sc_hd__decap_8
X_10235_ cpuregs\[12\]\[18\] cpuregs\[13\]\[18\] _03881_ VGND VGND VPWR VPWR _04453_
+ sky130_fd_sc_hd__mux2_1
XTAP_309 VGND VPWR sky130_fd_sc_hd__tapvpwrvgnd_1
X_13023_ _03321_ _06514_ VGND VGND VPWR VPWR _06515_ sky130_fd_sc_hd__or2_1
X_10166_ cpuregs\[4\]\[16\] cpuregs\[5\]\[16\] cpuregs\[6\]\[16\] cpuregs\[7\]\[16\]
+ _03894_ _04090_ VGND VGND VPWR VPWR _04386_ sky130_fd_sc_hd__mux4_1
X_10097_ cpuregs\[16\]\[14\] cpuregs\[17\]\[14\] cpuregs\[18\]\[14\] cpuregs\[19\]\[14\]
+ _03938_ _04028_ VGND VGND VPWR VPWR _04319_ sky130_fd_sc_hd__mux4_1
X_14974_ _01864_ VGND VGND VPWR VPWR _01865_ sky130_fd_sc_hd__clkbuf_8
X_16713_ clknet_leaf_73_clk _01280_ VGND VGND VPWR VPWR cpuregs\[3\]\[27\] sky130_fd_sc_hd__dfxtp_1
X_13925_ net390 _07358_ _07343_ _02172_ VGND VGND VPWR VPWR _00858_ sky130_fd_sc_hd__a22o_1
X_16644_ clknet_leaf_49_clk _01211_ VGND VGND VPWR VPWR cpuregs\[23\]\[22\] sky130_fd_sc_hd__dfxtp_1
XFILLER_0_16_56 VGND VGND VPWR VPWR sky130_fd_sc_hd__decap_4
X_13856_ _07313_ VGND VGND VPWR VPWR _01098_ sky130_fd_sc_hd__dlymetal6s2s_1
X_12807_ _06318_ VGND VGND VPWR VPWR _00793_ sky130_fd_sc_hd__clkbuf_1
XFILLER_0_29_203 VPWR VGND VPWR VGND sky130_ef_sc_hd__decap_12
X_16575_ clknet_leaf_45_clk _01152_ VGND VGND VPWR VPWR cpuregs\[24\]\[27\] sky130_fd_sc_hd__dfxtp_1
X_10999_ _05081_ VGND VGND VPWR VPWR _00222_ sky130_fd_sc_hd__clkbuf_1
X_13787_ _06442_ _07251_ _07255_ _06428_ VGND VGND VPWR VPWR _07256_ sky130_fd_sc_hd__o211a_1
XFILLER_0_29_225 VGND VGND VPWR VPWR sky130_fd_sc_hd__decap_3
XFILLER_0_84_353 VGND VGND VPWR VPWR sky130_fd_sc_hd__fill_1
X_12738_ cpuregs\[20\]\[31\] cpuregs\[21\]\[31\] _04194_ VGND VGND VPWR VPWR _06272_
+ sky130_fd_sc_hd__mux2_1
X_15526_ clknet_leaf_105_clk _00176_ VGND VGND VPWR VPWR cpuregs\[13\]\[12\] sky130_fd_sc_hd__dfxtp_1
XTAP_1092 VGND VPWR sky130_fd_sc_hd__tapvpwrvgnd_1
XTAP_1081 VGND VPWR sky130_fd_sc_hd__tapvpwrvgnd_1
XTAP_1070 VGND VPWR sky130_fd_sc_hd__tapvpwrvgnd_1
XFILLER_0_29_269 VGND VGND VPWR VPWR sky130_fd_sc_hd__fill_2
X_12669_ net1665 _06207_ _06217_ VGND VGND VPWR VPWR _06218_ sky130_fd_sc_hd__and3_1
X_15457_ clknet_leaf_112_clk _00107_ VGND VGND VPWR VPWR cpuregs\[12\]\[7\] sky130_fd_sc_hd__dfxtp_1
X_14408_ _05031_ net1528 _01562_ VGND VGND VPWR VPWR _01565_ sky130_fd_sc_hd__mux2_1
XFILLER_0_115_617 VGND VGND VPWR VPWR sky130_fd_sc_hd__fill_2
XFILLER_0_4_325 VGND VGND VPWR VPWR sky130_fd_sc_hd__fill_2
XFILLER_0_114_149 VGND VGND VPWR VPWR sky130_fd_sc_hd__decap_8
XFILLER_0_107_190 VPWR VGND VPWR VGND sky130_ef_sc_hd__decap_12
XFILLER_0_89_9 VGND VGND VPWR VPWR sky130_fd_sc_hd__fill_2
XFILLER_0_13_615 VGND VGND VPWR VPWR sky130_fd_sc_hd__fill_1
XFILLER_0_13_626 VGND VGND VPWR VPWR sky130_fd_sc_hd__fill_1
X_15388_ clknet_leaf_115_clk _00043_ VGND VGND VPWR VPWR cpuregs\[11\]\[6\] sky130_fd_sc_hd__dfxtp_1
XFILLER_0_123_661 VGND VGND VPWR VPWR sky130_fd_sc_hd__fill_2
XFILLER_0_111_801 VGND VGND VPWR VPWR sky130_fd_sc_hd__fill_1
X_14339_ decoded_imm\[9\] _07459_ _07602_ VGND VGND VPWR VPWR _01020_ sky130_fd_sc_hd__o21a_1
Xhold527 cpuregs\[11\]\[14\] VGND VGND VPWR VPWR net885 sky130_fd_sc_hd__dlygate4sd3_1
Xhold516 cpuregs\[4\]\[10\] VGND VGND VPWR VPWR net874 sky130_fd_sc_hd__dlygate4sd3_1
Xhold505 cpuregs\[3\]\[10\] VGND VGND VPWR VPWR net863 sky130_fd_sc_hd__dlygate4sd3_1
XFILLER_0_12_114 VGND VGND VPWR VPWR sky130_fd_sc_hd__decap_3
XFILLER_0_12_125 VPWR VGND VPWR VGND sky130_ef_sc_hd__decap_12
Xhold549 cpuregs\[15\]\[14\] VGND VGND VPWR VPWR net907 sky130_fd_sc_hd__dlygate4sd3_1
Xhold538 cpuregs\[3\]\[0\] VGND VGND VPWR VPWR net896 sky130_fd_sc_hd__dlygate4sd3_1
X_16009_ clknet_leaf_30_clk _00659_ VGND VGND VPWR VPWR reg_pc\[15\] sky130_fd_sc_hd__dfxtp_4
X_08900_ _03221_ VGND VGND VPWR VPWR _03222_ sky130_fd_sc_hd__buf_4
X_09880_ _04107_ _02340_ _03715_ VGND VGND VPWR VPWR _04108_ sky130_fd_sc_hd__mux2_1
XTAP_810 VGND VPWR sky130_fd_sc_hd__tapvpwrvgnd_1
X_08831_ _03174_ VGND VGND VPWR VPWR _03183_ sky130_fd_sc_hd__inv_2
XFILLER_0_0_597 VGND VGND VPWR VPWR sky130_fd_sc_hd__fill_2
XTAP_821 VGND VPWR sky130_fd_sc_hd__tapvpwrvgnd_1
XTAP_832 VGND VPWR sky130_fd_sc_hd__tapvpwrvgnd_1
XTAP_843 VGND VPWR sky130_fd_sc_hd__tapvpwrvgnd_1
Xhold1216 cpuregs\[5\]\[24\] VGND VGND VPWR VPWR net1574 sky130_fd_sc_hd__dlygate4sd3_1
Xhold1205 cpuregs\[2\]\[24\] VGND VGND VPWR VPWR net1563 sky130_fd_sc_hd__dlygate4sd3_1
XTAP_854 VGND VPWR sky130_fd_sc_hd__tapvpwrvgnd_1
XTAP_876 VGND VPWR sky130_fd_sc_hd__tapvpwrvgnd_1
XTAP_865 VGND VPWR sky130_fd_sc_hd__tapvpwrvgnd_1
Xhold1249 cpuregs\[18\]\[21\] VGND VGND VPWR VPWR net1607 sky130_fd_sc_hd__dlygate4sd3_1
X_08762_ _03090_ _03104_ VGND VGND VPWR VPWR _03119_ sky130_fd_sc_hd__nand2_1
Xhold1227 cpuregs\[21\]\[13\] VGND VGND VPWR VPWR net1585 sky130_fd_sc_hd__dlygate4sd3_1
Xhold1238 cpuregs\[29\]\[11\] VGND VGND VPWR VPWR net1596 sky130_fd_sc_hd__dlygate4sd3_1
XTAP_887 VGND VPWR sky130_fd_sc_hd__tapvpwrvgnd_1
XTAP_898 VGND VPWR sky130_fd_sc_hd__tapvpwrvgnd_1
X_08693_ _02922_ net246 _03042_ VGND VGND VPWR VPWR _03055_ sky130_fd_sc_hd__a21o_1
X_07713_ _02116_ _02131_ _02138_ VGND VGND VPWR VPWR _02139_ sky130_fd_sc_hd__o21ai_1
XFILLER_0_95_607 VGND VGND VPWR VPWR sky130_fd_sc_hd__fill_1
XFILLER_0_18_3 VGND VGND VPWR VPWR sky130_fd_sc_hd__fill_2
XFILLER_0_79_169 VGND VGND VPWR VPWR sky130_fd_sc_hd__fill_1
X_09314_ _03563_ VGND VGND VPWR VPWR _03564_ sky130_fd_sc_hd__clkbuf_4
XFILLER_0_48_578 VGND VGND VPWR VPWR sky130_fd_sc_hd__fill_2
XFILLER_0_118_433 VGND VGND VPWR VPWR sky130_fd_sc_hd__fill_1
XFILLER_0_63_526 VGND VGND VPWR VPWR sky130_fd_sc_hd__decap_4
XFILLER_0_48_589 VGND VGND VPWR VPWR sky130_fd_sc_hd__decap_4
X_09245_ _03503_ VGND VGND VPWR VPWR _03504_ sky130_fd_sc_hd__clkbuf_4
XFILLER_0_44_762 VGND VGND VPWR VPWR sky130_fd_sc_hd__fill_1
XFILLER_0_16_453 VGND VGND VPWR VPWR sky130_fd_sc_hd__fill_1
X_09176_ latched_rd\[0\] latched_rd\[1\] _03443_ VGND VGND VPWR VPWR _03444_ sky130_fd_sc_hd__nand3_4
X_08127_ _02517_ _02518_ VGND VGND VPWR VPWR _02519_ sky130_fd_sc_hd__or2_1
XFILLER_0_101_300 VGND VGND VPWR VPWR sky130_fd_sc_hd__decap_8
X_08058_ _02202_ VGND VGND VPWR VPWR _02454_ sky130_fd_sc_hd__clkbuf_4
Xoutput36 net36 VGND VGND VPWR VPWR mem_addr[11] sky130_fd_sc_hd__clkbuf_4
Xpicorv32_280 VGND VGND VPWR VPWR picorv32_280/HI eoi[27] sky130_fd_sc_hd__conb_1
Xoutput58 net58 VGND VGND VPWR VPWR mem_addr[3] sky130_fd_sc_hd__clkbuf_4
Xoutput47 net47 VGND VGND VPWR VPWR mem_addr[22] sky130_fd_sc_hd__clkbuf_4
Xpicorv32_291 VGND VGND VPWR VPWR picorv32_291/HI pcpi_insn[2] sky130_fd_sc_hd__conb_1
X_10020_ _03979_ _04243_ _04020_ VGND VGND VPWR VPWR _04244_ sky130_fd_sc_hd__a21o_1
XFILLER_0_9_6 VGND VGND VPWR VPWR sky130_fd_sc_hd__decap_6
Xoutput69 net69 VGND VGND VPWR VPWR mem_la_addr[13] sky130_fd_sc_hd__clkbuf_4
X_11971_ count_instr\[47\] _05645_ VGND VGND VPWR VPWR _05648_ sky130_fd_sc_hd__and2_1
X_13710_ cpuregs\[6\]\[28\] cpuregs\[7\]\[28\] _06383_ VGND VGND VPWR VPWR _07181_
+ sky130_fd_sc_hd__mux2_1
X_10922_ _05037_ net1562 _05027_ VGND VGND VPWR VPWR _05038_ sky130_fd_sc_hd__mux2_1
X_14690_ net1119 _05217_ _01706_ VGND VGND VPWR VPWR _01714_ sky130_fd_sc_hd__mux2_1
XFILLER_0_85_117 VGND VGND VPWR VPWR sky130_fd_sc_hd__fill_1
XFILLER_0_58_309 VGND VGND VPWR VPWR sky130_fd_sc_hd__decap_3
X_13641_ _07114_ VGND VGND VPWR VPWR _00831_ sky130_fd_sc_hd__clkbuf_1
XFILLER_0_79_692 VGND VGND VPWR VPWR sky130_fd_sc_hd__decap_4
X_10853_ _03463_ VGND VGND VPWR VPWR _04991_ sky130_fd_sc_hd__buf_2
X_16360_ clknet_leaf_73_clk _00942_ VGND VGND VPWR VPWR cpuregs\[1\]\[25\] sky130_fd_sc_hd__dfxtp_1
X_13572_ cpuregs\[24\]\[23\] cpuregs\[25\]\[23\] cpuregs\[26\]\[23\] cpuregs\[27\]\[23\]
+ _06856_ _06889_ VGND VGND VPWR VPWR _07048_ sky130_fd_sc_hd__mux4_1
XFILLER_0_82_813 VGND VGND VPWR VPWR sky130_fd_sc_hd__fill_1
XPHY_142 VGND VGND VPWR VPWR sky130_fd_sc_hd__decap_3
XPHY_131 VGND VGND VPWR VPWR sky130_fd_sc_hd__decap_3
XPHY_120 VGND VGND VPWR VPWR sky130_fd_sc_hd__decap_3
X_10784_ net947 _03478_ _04946_ VGND VGND VPWR VPWR _04952_ sky130_fd_sc_hd__mux2_1
XPHY_175 VGND VGND VPWR VPWR sky130_fd_sc_hd__decap_3
XPHY_164 VGND VGND VPWR VPWR sky130_fd_sc_hd__decap_3
XPHY_153 VGND VGND VPWR VPWR sky130_fd_sc_hd__decap_3
X_15311_ _03440_ net1120 _02041_ VGND VGND VPWR VPWR _02042_ sky130_fd_sc_hd__mux2_1
X_12523_ net1662 _06110_ _06113_ VGND VGND VPWR VPWR _00714_ sky130_fd_sc_hd__o21a_1
X_16291_ clknet_leaf_14_clk _00876_ VGND VGND VPWR VPWR instr_srl sky130_fd_sc_hd__dfxtp_2
XPHY_197 VGND VGND VPWR VPWR sky130_fd_sc_hd__decap_3
X_15242_ _02006_ VGND VGND VPWR VPWR _01475_ sky130_fd_sc_hd__clkbuf_1
XFILLER_0_93_194 VGND VGND VPWR VPWR sky130_fd_sc_hd__fill_2
XPHY_186 VGND VGND VPWR VPWR sky130_fd_sc_hd__decap_3
XFILLER_0_81_345 VPWR VGND VPWR VGND sky130_ef_sc_hd__decap_12
X_12454_ _06055_ _06056_ VGND VGND VPWR VPWR _06057_ sky130_fd_sc_hd__nor2_1
XFILLER_0_41_209 VGND VGND VPWR VPWR sky130_fd_sc_hd__fill_1
X_12385_ _05981_ _05736_ _05990_ _05992_ _05993_ VGND VGND VPWR VPWR _05994_ sky130_fd_sc_hd__a221o_1
X_15173_ net717 _03640_ _01936_ VGND VGND VPWR VPWR _01970_ sky130_fd_sc_hd__mux2_1
XFILLER_0_62_581 VGND VGND VPWR VPWR sky130_fd_sc_hd__fill_1
XFILLER_0_2_818 VGND VGND VPWR VPWR sky130_fd_sc_hd__decap_4
X_11405_ _05312_ VGND VGND VPWR VPWR _00397_ sky130_fd_sc_hd__clkbuf_1
X_14124_ _07481_ VGND VGND VPWR VPWR _00926_ sky130_fd_sc_hd__clkbuf_1
X_11336_ _05003_ net1569 _05266_ VGND VGND VPWR VPWR _05276_ sky130_fd_sc_hd__mux2_1
X_14055_ net397 _01101_ _07420_ VGND VGND VPWR VPWR _07444_ sky130_fd_sc_hd__mux2_1
X_13006_ _06441_ _06488_ _06492_ _06498_ _06468_ VGND VGND VPWR VPWR _06499_ sky130_fd_sc_hd__a311o_1
X_11267_ net870 _05179_ _05229_ VGND VGND VPWR VPWR _05239_ sky130_fd_sc_hd__mux2_1
X_10218_ _04407_ _04436_ VGND VGND VPWR VPWR _04437_ sky130_fd_sc_hd__or2_1
X_11198_ net580 _05194_ _05182_ VGND VGND VPWR VPWR _05195_ sky130_fd_sc_hd__mux2_1
XFILLER_0_118_35 VGND VGND VPWR VPWR sky130_fd_sc_hd__fill_1
X_10149_ _04295_ _04325_ _04326_ _04365_ _04368_ VGND VGND VPWR VPWR _04369_ sky130_fd_sc_hd__o2111a_1
XFILLER_0_27_44 VGND VGND VPWR VPWR sky130_fd_sc_hd__fill_1
X_14957_ _03603_ net1574 _01851_ VGND VGND VPWR VPWR _01856_ sky130_fd_sc_hd__mux2_1
X_14888_ _01819_ VGND VGND VPWR VPWR _01308_ sky130_fd_sc_hd__clkbuf_1
X_13908_ _07353_ VGND VGND VPWR VPWR _01106_ sky130_fd_sc_hd__buf_1
XFILLER_0_76_128 VGND VGND VPWR VPWR sky130_fd_sc_hd__decap_4
XPHY_0 VGND VGND VPWR VPWR sky130_fd_sc_hd__decap_3
X_16627_ clknet_leaf_142_clk _01194_ VGND VGND VPWR VPWR cpuregs\[23\]\[5\] sky130_fd_sc_hd__dfxtp_1
X_13839_ _07302_ VGND VGND VPWR VPWR _00842_ sky130_fd_sc_hd__clkbuf_1
XFILLER_0_43_54 VGND VGND VPWR VPWR sky130_fd_sc_hd__fill_2
XFILLER_0_69_191 VGND VGND VPWR VPWR sky130_fd_sc_hd__fill_2
XFILLER_0_57_342 VGND VGND VPWR VPWR sky130_fd_sc_hd__decap_3
X_16558_ clknet_leaf_138_clk _01135_ VGND VGND VPWR VPWR cpuregs\[24\]\[10\] sky130_fd_sc_hd__dfxtp_1
X_15509_ clknet_leaf_68_clk _00159_ VGND VGND VPWR VPWR cpuregs\[30\]\[27\] sky130_fd_sc_hd__dfxtp_1
X_16489_ clknet_leaf_137_clk _01071_ VGND VGND VPWR VPWR cpuregs\[19\]\[10\] sky130_fd_sc_hd__dfxtp_1
X_09030_ _03310_ VGND VGND VPWR VPWR _03311_ sky130_fd_sc_hd__buf_4
XFILLER_0_127_285 VGND VGND VPWR VPWR sky130_fd_sc_hd__fill_1
XFILLER_0_26_773 VGND VGND VPWR VPWR sky130_fd_sc_hd__fill_2
Xhold302 cpuregs\[6\]\[22\] VGND VGND VPWR VPWR net660 sky130_fd_sc_hd__dlygate4sd3_1
XFILLER_0_26_795 VGND VGND VPWR VPWR sky130_fd_sc_hd__fill_1
Xhold313 cpuregs\[17\]\[16\] VGND VGND VPWR VPWR net671 sky130_fd_sc_hd__dlygate4sd3_1
Xhold324 cpuregs\[19\]\[10\] VGND VGND VPWR VPWR net682 sky130_fd_sc_hd__dlygate4sd3_1
XFILLER_0_13_445 VGND VGND VPWR VPWR sky130_fd_sc_hd__decap_3
Xhold335 cpuregs\[19\]\[3\] VGND VGND VPWR VPWR net693 sky130_fd_sc_hd__dlygate4sd3_1
XFILLER_0_40_253 VGND VGND VPWR VPWR sky130_fd_sc_hd__decap_4
Xhold346 cpuregs\[22\]\[21\] VGND VGND VPWR VPWR net704 sky130_fd_sc_hd__dlygate4sd3_1
XFILLER_0_110_141 VGND VGND VPWR VPWR sky130_fd_sc_hd__decap_4
X_09932_ _04154_ _04156_ VGND VGND VPWR VPWR _04158_ sky130_fd_sc_hd__or2_1
Xhold368 cpuregs\[16\]\[13\] VGND VGND VPWR VPWR net726 sky130_fd_sc_hd__dlygate4sd3_1
Xhold357 cpuregs\[24\]\[13\] VGND VGND VPWR VPWR net715 sky130_fd_sc_hd__dlygate4sd3_1
Xhold379 cpuregs\[24\]\[14\] VGND VGND VPWR VPWR net737 sky130_fd_sc_hd__dlygate4sd3_1
XTAP_640 VGND VPWR sky130_fd_sc_hd__tapvpwrvgnd_1
XTAP_651 VGND VPWR sky130_fd_sc_hd__tapvpwrvgnd_1
X_09863_ cpuregs\[4\]\[8\] cpuregs\[5\]\[8\] cpuregs\[6\]\[8\] cpuregs\[7\]\[8\] _03667_
+ _04090_ VGND VGND VPWR VPWR _04091_ sky130_fd_sc_hd__mux4_1
X_08814_ _02857_ _03166_ VGND VGND VPWR VPWR _03167_ sky130_fd_sc_hd__or2_1
XFILLER_0_99_209 VGND VGND VPWR VPWR sky130_fd_sc_hd__fill_2
Xhold1024 cpuregs\[31\]\[31\] VGND VGND VPWR VPWR net1382 sky130_fd_sc_hd__dlygate4sd3_1
X_09794_ _03747_ _04016_ _04023_ VGND VGND VPWR VPWR _04024_ sky130_fd_sc_hd__or3_4
Xhold1013 count_cycle\[4\] VGND VGND VPWR VPWR net1371 sky130_fd_sc_hd__dlygate4sd3_1
XTAP_662 VGND VPWR sky130_fd_sc_hd__tapvpwrvgnd_1
XTAP_673 VGND VPWR sky130_fd_sc_hd__tapvpwrvgnd_1
Xhold1002 cpuregs\[21\]\[5\] VGND VGND VPWR VPWR net1360 sky130_fd_sc_hd__dlygate4sd3_1
XTAP_695 VGND VPWR sky130_fd_sc_hd__tapvpwrvgnd_1
XTAP_684 VGND VPWR sky130_fd_sc_hd__tapvpwrvgnd_1
X_08745_ _02762_ _03102_ VGND VGND VPWR VPWR _03103_ sky130_fd_sc_hd__xnor2_2
Xhold1035 cpuregs\[6\]\[29\] VGND VGND VPWR VPWR net1393 sky130_fd_sc_hd__dlygate4sd3_1
Xhold1057 cpuregs\[29\]\[17\] VGND VGND VPWR VPWR net1415 sky130_fd_sc_hd__dlygate4sd3_1
Xhold1046 cpuregs\[23\]\[8\] VGND VGND VPWR VPWR net1404 sky130_fd_sc_hd__dlygate4sd3_1
Xhold1068 cpuregs\[13\]\[11\] VGND VGND VPWR VPWR net1426 sky130_fd_sc_hd__dlygate4sd3_1
Xhold1079 mem_do_prefetch VGND VGND VPWR VPWR net1437 sky130_fd_sc_hd__dlygate4sd3_1
X_08676_ _03039_ _03027_ VGND VGND VPWR VPWR _03040_ sky130_fd_sc_hd__nor2_1
XTAP_1806 VGND VPWR sky130_fd_sc_hd__tapvpwrvgnd_1
XTAP_1828 VGND VPWR sky130_fd_sc_hd__tapvpwrvgnd_1
XTAP_1839 VGND VPWR sky130_fd_sc_hd__tapvpwrvgnd_1
XTAP_1817 VGND VPWR sky130_fd_sc_hd__tapvpwrvgnd_1
XFILLER_0_119_742 VGND VGND VPWR VPWR sky130_fd_sc_hd__fill_1
XFILLER_0_64_824 VGND VGND VPWR VPWR sky130_fd_sc_hd__fill_2
XFILLER_0_106_403 VGND VGND VPWR VPWR sky130_fd_sc_hd__fill_1
XFILLER_0_63_334 VGND VGND VPWR VPWR sky130_fd_sc_hd__fill_2
XFILLER_0_118_296 VGND VGND VPWR VPWR sky130_fd_sc_hd__decap_8
XFILLER_0_90_175 VGND VGND VPWR VPWR sky130_fd_sc_hd__decap_4
XFILLER_0_90_153 VGND VGND VPWR VPWR sky130_fd_sc_hd__fill_1
X_09228_ reg_out\[7\] alu_out_q\[7\] _03435_ VGND VGND VPWR VPWR _03489_ sky130_fd_sc_hd__mux2_1
XFILLER_0_16_250 VGND VGND VPWR VPWR sky130_fd_sc_hd__fill_2
XFILLER_0_23_209 VGND VGND VPWR VPWR sky130_fd_sc_hd__fill_1
XFILLER_0_90_197 VGND VGND VPWR VPWR sky130_fd_sc_hd__fill_1
XFILLER_0_90_186 VGND VGND VPWR VPWR sky130_fd_sc_hd__decap_8
X_09159_ mem_rdata_q\[24\] net17 _03291_ VGND VGND VPWR VPWR _03429_ sky130_fd_sc_hd__mux2_1
X_12170_ _05778_ _05781_ VGND VGND VPWR VPWR _05796_ sky130_fd_sc_hd__nand2_1
X_11121_ _05123_ VGND VGND VPWR VPWR _05146_ sky130_fd_sc_hd__buf_4
XFILLER_0_31_275 VGND VGND VPWR VPWR sky130_fd_sc_hd__fill_2
Xhold891 cpuregs\[6\]\[28\] VGND VGND VPWR VPWR net1249 sky130_fd_sc_hd__dlygate4sd3_1
Xhold880 cpuregs\[30\]\[4\] VGND VGND VPWR VPWR net1238 sky130_fd_sc_hd__dlygate4sd3_1
X_11052_ _05109_ VGND VGND VPWR VPWR _00247_ sky130_fd_sc_hd__clkbuf_1
X_15860_ clknet_leaf_46_clk _00510_ VGND VGND VPWR VPWR cpuregs\[25\]\[26\] sky130_fd_sc_hd__dfxtp_1
X_10003_ _04225_ _04226_ VGND VGND VPWR VPWR _04227_ sky130_fd_sc_hd__nand2_1
X_14811_ net237 VGND VGND VPWR VPWR _01778_ sky130_fd_sc_hd__buf_4
X_15791_ clknet_leaf_45_clk _00441_ VGND VGND VPWR VPWR cpuregs\[26\]\[21\] sky130_fd_sc_hd__dfxtp_1
XFILLER_0_98_253 VGND VGND VPWR VPWR sky130_fd_sc_hd__fill_1
X_14742_ _01741_ VGND VGND VPWR VPWR _01240_ sky130_fd_sc_hd__clkbuf_1
X_11954_ _05634_ _05620_ _05635_ VGND VGND VPWR VPWR _05636_ sky130_fd_sc_hd__and3b_1
X_10905_ _03576_ VGND VGND VPWR VPWR _05026_ sky130_fd_sc_hd__clkbuf_4
X_14673_ net1039 _05200_ _01695_ VGND VGND VPWR VPWR _01705_ sky130_fd_sc_hd__mux2_1
XFILLER_0_80_19 VGND VGND VPWR VPWR sky130_fd_sc_hd__decap_8
X_11885_ count_instr\[23\] _05581_ VGND VGND VPWR VPWR _05586_ sky130_fd_sc_hd__or2_1
X_13624_ _06969_ _07093_ _07095_ _03309_ _07097_ VGND VGND VPWR VPWR _07098_ sky130_fd_sc_hd__o311a_1
X_10836_ net1300 _03641_ _04945_ VGND VGND VPWR VPWR _04979_ sky130_fd_sc_hd__mux2_1
X_16412_ clknet_leaf_139_clk _00994_ VGND VGND VPWR VPWR latched_rd\[3\] sky130_fd_sc_hd__dfxtp_1
XFILLER_0_39_386 VGND VGND VPWR VPWR sky130_fd_sc_hd__decap_6
X_13555_ _03340_ _07030_ _06998_ VGND VGND VPWR VPWR _07031_ sky130_fd_sc_hd__a21o_1
X_10767_ net709 _03646_ _04906_ VGND VGND VPWR VPWR _04941_ sky130_fd_sc_hd__mux2_1
X_16343_ clknet_leaf_114_clk _00925_ VGND VGND VPWR VPWR cpuregs\[1\]\[8\] sky130_fd_sc_hd__dfxtp_1
X_13486_ cpuregs\[8\]\[21\] cpuregs\[9\]\[21\] _06764_ VGND VGND VPWR VPWR _06964_
+ sky130_fd_sc_hd__mux2_1
XFILLER_0_109_296 VGND VGND VPWR VPWR sky130_fd_sc_hd__fill_1
X_10698_ _04900_ _04901_ _04902_ VGND VGND VPWR VPWR _04903_ sky130_fd_sc_hd__nand3b_4
X_12506_ count_cycle\[0\] count_cycle\[1\] count_cycle\[2\] VGND VGND VPWR VPWR _06102_
+ sky130_fd_sc_hd__a21o_1
X_16274_ clknet_leaf_4_clk _00859_ VGND VGND VPWR VPWR instr_sb sky130_fd_sc_hd__dfxtp_1
XFILLER_0_42_529 VGND VGND VPWR VPWR sky130_fd_sc_hd__decap_3
XFILLER_0_140_704 VGND VGND VPWR VPWR sky130_fd_sc_hd__fill_1
X_12437_ _06038_ _06041_ _02153_ VGND VGND VPWR VPWR _06042_ sky130_fd_sc_hd__a21o_1
X_15225_ _03591_ net1564 _01995_ VGND VGND VPWR VPWR _01998_ sky130_fd_sc_hd__mux2_1
X_15156_ _01961_ VGND VGND VPWR VPWR _01434_ sky130_fd_sc_hd__clkbuf_1
XFILLER_0_2_626 VGND VGND VPWR VPWR sky130_fd_sc_hd__fill_2
XFILLER_0_22_253 VGND VGND VPWR VPWR sky130_fd_sc_hd__fill_2
X_12368_ _05731_ _05733_ _05956_ _05736_ VGND VGND VPWR VPWR _05978_ sky130_fd_sc_hd__a31o_1
X_14107_ _04987_ net891 _07471_ VGND VGND VPWR VPWR _07473_ sky130_fd_sc_hd__mux2_1
XFILLER_0_22_275 VGND VGND VPWR VPWR sky130_fd_sc_hd__decap_6
XFILLER_0_129_12 VPWR VGND VPWR VGND sky130_ef_sc_hd__decap_12
X_15087_ net948 _05205_ _01923_ VGND VGND VPWR VPWR _01925_ sky130_fd_sc_hd__mux2_1
X_12299_ decoded_imm_j\[14\] _05720_ VGND VGND VPWR VPWR _05915_ sky130_fd_sc_hd__nand2_1
X_11319_ _05267_ VGND VGND VPWR VPWR _00356_ sky130_fd_sc_hd__clkbuf_1
XFILLER_0_1_169 VGND VGND VPWR VPWR sky130_fd_sc_hd__fill_1
X_14038_ _07435_ VGND VGND VPWR VPWR _00892_ sky130_fd_sc_hd__clkbuf_1
XFILLER_0_38_65 VPWR VGND VPWR VGND sky130_ef_sc_hd__decap_12
X_15989_ clknet_leaf_1_clk _00639_ VGND VGND VPWR VPWR count_instr\[58\] sky130_fd_sc_hd__dfxtp_1
X_08530_ _02661_ _02897_ _02905_ _02849_ VGND VGND VPWR VPWR alu_out\[5\] sky130_fd_sc_hd__a22o_1
XFILLER_0_89_275 VGND VGND VPWR VPWR sky130_fd_sc_hd__decap_4
XFILLER_0_77_426 VGND VGND VPWR VPWR sky130_fd_sc_hd__decap_4
X_08461_ _02132_ _02751_ _02841_ VGND VGND VPWR VPWR _02842_ sky130_fd_sc_hd__o21a_1
X_08392_ net216 VGND VGND VPWR VPWR _02773_ sky130_fd_sc_hd__inv_2
XFILLER_0_85_470 VGND VGND VPWR VPWR sky130_fd_sc_hd__fill_1
XFILLER_0_58_695 VGND VGND VPWR VPWR sky130_fd_sc_hd__decap_4
XFILLER_0_46_813 VGND VGND VPWR VPWR sky130_fd_sc_hd__fill_1
XFILLER_0_72_131 VGND VGND VPWR VPWR sky130_fd_sc_hd__fill_1
XFILLER_0_70_85 VGND VGND VPWR VPWR sky130_fd_sc_hd__decap_4
XFILLER_0_9_269 VGND VGND VPWR VPWR sky130_fd_sc_hd__fill_1
XFILLER_0_115_222 VGND VGND VPWR VPWR sky130_fd_sc_hd__fill_2
XFILLER_0_85_3 VGND VGND VPWR VPWR sky130_fd_sc_hd__fill_2
X_09013_ _03300_ VGND VGND VPWR VPWR _01110_ sky130_fd_sc_hd__buf_1
XFILLER_0_60_326 VGND VGND VPWR VPWR sky130_fd_sc_hd__decap_4
Xhold110 cpuregs\[0\]\[22\] VGND VGND VPWR VPWR net468 sky130_fd_sc_hd__dlygate4sd3_1
XFILLER_0_5_497 VGND VGND VPWR VPWR sky130_fd_sc_hd__fill_1
XFILLER_0_14_754 VGND VGND VPWR VPWR sky130_fd_sc_hd__fill_2
Xhold132 cpuregs\[0\]\[24\] VGND VGND VPWR VPWR net490 sky130_fd_sc_hd__dlygate4sd3_1
Xhold143 cpuregs\[0\]\[4\] VGND VGND VPWR VPWR net501 sky130_fd_sc_hd__dlygate4sd3_1
XFILLER_0_41_573 VGND VGND VPWR VPWR sky130_fd_sc_hd__fill_1
Xhold121 cpuregs\[0\]\[7\] VGND VGND VPWR VPWR net479 sky130_fd_sc_hd__dlygate4sd3_1
Xhold154 net52 VGND VGND VPWR VPWR net512 sky130_fd_sc_hd__dlygate4sd3_1
Xhold176 cpuregs\[0\]\[18\] VGND VGND VPWR VPWR net534 sky130_fd_sc_hd__dlygate4sd3_1
Xhold165 count_instr\[21\] VGND VGND VPWR VPWR net523 sky130_fd_sc_hd__dlygate4sd3_1
XFILLER_0_1_670 VGND VGND VPWR VPWR sky130_fd_sc_hd__fill_2
Xhold198 net60 VGND VGND VPWR VPWR net556 sky130_fd_sc_hd__dlygate4sd3_1
Xhold187 reg_next_pc\[12\] VGND VGND VPWR VPWR net545 sky130_fd_sc_hd__dlygate4sd3_1
X_09915_ cpuregs\[28\]\[9\] cpuregs\[29\]\[9\] _03754_ VGND VGND VPWR VPWR _04142_
+ sky130_fd_sc_hd__mux2_1
XFILLER_0_95_93 VGND VGND VPWR VPWR sky130_fd_sc_hd__fill_2
X_09846_ _02160_ _04036_ _04067_ _04074_ VGND VGND VPWR VPWR _04075_ sky130_fd_sc_hd__a211o_1
XTAP_470 VGND VPWR sky130_fd_sc_hd__tapvpwrvgnd_1
XTAP_481 VGND VPWR sky130_fd_sc_hd__tapvpwrvgnd_1
XTAP_492 VGND VPWR sky130_fd_sc_hd__tapvpwrvgnd_1
X_09777_ _04003_ _04006_ VGND VGND VPWR VPWR _04007_ sky130_fd_sc_hd__nor2_1
XTAP_2326 VGND VPWR sky130_fd_sc_hd__tapvpwrvgnd_1
XTAP_2304 VGND VPWR sky130_fd_sc_hd__tapvpwrvgnd_1
XTAP_2315 VGND VPWR sky130_fd_sc_hd__tapvpwrvgnd_1
X_08728_ net217 _03086_ VGND VGND VPWR VPWR _03087_ sky130_fd_sc_hd__xnor2_1
XTAP_2348 VGND VPWR sky130_fd_sc_hd__tapvpwrvgnd_1
XTAP_2337 VGND VPWR sky130_fd_sc_hd__tapvpwrvgnd_1
XFILLER_0_139_815 VGND VGND VPWR VPWR sky130_fd_sc_hd__fill_1
X_08659_ _02922_ _03022_ _02716_ VGND VGND VPWR VPWR _03024_ sky130_fd_sc_hd__a21o_1
XFILLER_0_96_746 VGND VGND VPWR VPWR sky130_fd_sc_hd__fill_2
XTAP_1614 VGND VPWR sky130_fd_sc_hd__tapvpwrvgnd_1
XTAP_1603 VGND VPWR sky130_fd_sc_hd__tapvpwrvgnd_1
XTAP_1658 VGND VPWR sky130_fd_sc_hd__tapvpwrvgnd_1
XTAP_1636 VGND VPWR sky130_fd_sc_hd__tapvpwrvgnd_1
XTAP_1647 VGND VPWR sky130_fd_sc_hd__tapvpwrvgnd_1
XTAP_1625 VGND VPWR sky130_fd_sc_hd__tapvpwrvgnd_1
XTAP_1669 VGND VPWR sky130_fd_sc_hd__tapvpwrvgnd_1
X_11670_ _05453_ VGND VGND VPWR VPWR _00521_ sky130_fd_sc_hd__clkbuf_1
XFILLER_0_119_561 VGND VGND VPWR VPWR sky130_fd_sc_hd__fill_1
X_10621_ _04828_ _02621_ _04509_ VGND VGND VPWR VPWR _04829_ sky130_fd_sc_hd__mux2_1
XFILLER_0_48_183 VGND VGND VPWR VPWR sky130_fd_sc_hd__fill_1
X_10552_ _03766_ _04758_ _04760_ VGND VGND VPWR VPWR _04761_ sky130_fd_sc_hd__a21o_1
XFILLER_0_91_473 VGND VGND VPWR VPWR sky130_fd_sc_hd__fill_1
X_13340_ _06682_ _06822_ VGND VGND VPWR VPWR _06823_ sky130_fd_sc_hd__and2_1
XFILLER_0_63_197 VGND VGND VPWR VPWR sky130_fd_sc_hd__fill_2
X_13271_ _06461_ _06755_ VGND VGND VPWR VPWR _06756_ sky130_fd_sc_hd__and2_1
XFILLER_0_51_326 VGND VGND VPWR VPWR sky130_fd_sc_hd__decap_6
XFILLER_0_134_597 VGND VGND VPWR VPWR sky130_fd_sc_hd__fill_2
X_10483_ _03837_ _04693_ _03839_ VGND VGND VPWR VPWR _04694_ sky130_fd_sc_hd__a21o_1
X_15010_ _03558_ net1420 _01876_ VGND VGND VPWR VPWR _01884_ sky130_fd_sc_hd__mux2_1
X_12222_ _05828_ _05833_ _05842_ VGND VGND VPWR VPWR _05844_ sky130_fd_sc_hd__or3_1
X_12153_ _05778_ _05779_ VGND VGND VPWR VPWR _05780_ sky130_fd_sc_hd__and2_1
XFILLER_0_20_757 VGND VGND VPWR VPWR sky130_fd_sc_hd__fill_2
X_12084_ _03556_ reg_next_pc\[17\] _03223_ VGND VGND VPWR VPWR _05728_ sky130_fd_sc_hd__mux2_2
X_16961_ clknet_leaf_86_clk _01525_ VGND VGND VPWR VPWR cpuregs\[10\]\[16\] sky130_fd_sc_hd__dfxtp_1
X_11104_ _05137_ VGND VGND VPWR VPWR _00271_ sky130_fd_sc_hd__clkbuf_1
X_15912_ clknet_leaf_18_clk _00562_ VGND VGND VPWR VPWR cpuregs\[17\]\[14\] sky130_fd_sc_hd__dfxtp_1
X_11035_ net1066 _03519_ _05099_ VGND VGND VPWR VPWR _05101_ sky130_fd_sc_hd__mux2_1
X_16892_ clknet_leaf_104_clk _01456_ VGND VGND VPWR VPWR cpuregs\[8\]\[11\] sky130_fd_sc_hd__dfxtp_1
X_15843_ clknet_leaf_138_clk _00493_ VGND VGND VPWR VPWR cpuregs\[25\]\[9\] sky130_fd_sc_hd__dfxtp_1
X_15774_ clknet_leaf_127_clk _00424_ VGND VGND VPWR VPWR cpuregs\[26\]\[4\] sky130_fd_sc_hd__dfxtp_1
X_12986_ cpuregs\[4\]\[6\] cpuregs\[5\]\[6\] _06383_ VGND VGND VPWR VPWR _06479_ sky130_fd_sc_hd__mux2_1
X_14725_ _05008_ net1596 _01731_ VGND VGND VPWR VPWR _01733_ sky130_fd_sc_hd__mux2_1
X_11937_ count_instr\[38\] _05619_ VGND VGND VPWR VPWR _05623_ sky130_fd_sc_hd__and2_1
X_14656_ _01696_ VGND VGND VPWR VPWR _01199_ sky130_fd_sc_hd__clkbuf_1
X_11868_ count_instr\[19\] _05570_ VGND VGND VPWR VPWR _05573_ sky130_fd_sc_hd__or2_1
X_10819_ _04970_ VGND VGND VPWR VPWR _00153_ sky130_fd_sc_hd__clkbuf_1
X_13607_ _06442_ _07077_ _07081_ _06798_ VGND VGND VPWR VPWR _07082_ sky130_fd_sc_hd__o211a_1
X_14587_ _05005_ net1123 _01659_ VGND VGND VPWR VPWR _01660_ sky130_fd_sc_hd__mux2_1
XFILLER_0_6_206 VGND VGND VPWR VPWR sky130_fd_sc_hd__decap_8
X_11799_ net34 VGND VGND VPWR VPWR _05523_ sky130_fd_sc_hd__buf_4
XFILLER_0_137_391 VGND VGND VPWR VPWR sky130_fd_sc_hd__fill_1
XFILLER_0_131_57 VGND VGND VPWR VPWR sky130_fd_sc_hd__decap_4
X_13538_ _07013_ _07014_ VGND VGND VPWR VPWR _07015_ sky130_fd_sc_hd__and2_1
X_16326_ clknet_leaf_6_clk _00001_ VGND VGND VPWR VPWR is_lui_auipc_jal sky130_fd_sc_hd__dfxtp_2
XFILLER_0_43_816 VGND VGND VPWR VPWR sky130_fd_sc_hd__decap_4
X_16257_ clknet_leaf_39_clk alu_out\[30\] VGND VGND VPWR VPWR alu_out_q\[30\] sky130_fd_sc_hd__dfxtp_1
XFILLER_0_113_726 VGND VGND VPWR VPWR sky130_fd_sc_hd__fill_2
X_13469_ cpuregs\[20\]\[20\] cpuregs\[21\]\[20\] _06784_ VGND VGND VPWR VPWR _06948_
+ sky130_fd_sc_hd__mux2_1
XFILLER_0_42_348 VGND VGND VPWR VPWR sky130_fd_sc_hd__decap_3
Xoutput226 net226 VGND VGND VPWR VPWR pcpi_rs2[30] sky130_fd_sc_hd__clkbuf_4
X_15208_ _03538_ net1285 _01984_ VGND VGND VPWR VPWR _01989_ sky130_fd_sc_hd__mux2_1
X_16188_ clknet_leaf_5_clk _00000_ VGND VGND VPWR VPWR decoder_trigger sky130_fd_sc_hd__dfxtp_2
Xoutput204 net204 VGND VGND VPWR VPWR pcpi_rs2[10] sky130_fd_sc_hd__clkbuf_4
Xoutput215 net215 VGND VGND VPWR VPWR pcpi_rs2[20] sky130_fd_sc_hd__clkbuf_4
X_15139_ _01952_ VGND VGND VPWR VPWR _01426_ sky130_fd_sc_hd__clkbuf_1
XFILLER_0_23_595 VGND VGND VPWR VPWR sky130_fd_sc_hd__fill_1
X_07961_ _02224_ _02187_ net19 net2 _02210_ VGND VGND VPWR VPWR _02364_ sky130_fd_sc_hd__a32o_1
X_09700_ _03663_ _03926_ _03928_ _03931_ VGND VGND VPWR VPWR _03932_ sky130_fd_sc_hd__a31o_1
XFILLER_0_65_30 VGND VGND VPWR VPWR sky130_fd_sc_hd__fill_1
X_07892_ _02286_ _02288_ _02299_ VGND VGND VPWR VPWR _07645_ sky130_fd_sc_hd__o21a_1
X_09631_ _03797_ VGND VGND VPWR VPWR _03864_ sky130_fd_sc_hd__buf_6
X_09562_ _03675_ VGND VGND VPWR VPWR _03796_ sky130_fd_sc_hd__buf_4
X_08513_ _02883_ _02877_ _02889_ VGND VGND VPWR VPWR _02890_ sky130_fd_sc_hd__a21oi_2
XFILLER_0_81_40 VGND VGND VPWR VPWR sky130_fd_sc_hd__fill_1
XFILLER_0_78_757 VGND VGND VPWR VPWR sky130_fd_sc_hd__decap_4
X_09493_ cpuregs\[28\]\[1\] cpuregs\[29\]\[1\] _03666_ VGND VGND VPWR VPWR _03728_
+ sky130_fd_sc_hd__mux2_1
X_08444_ _02810_ _02824_ VGND VGND VPWR VPWR _02825_ sky130_fd_sc_hd__nand2_2
XFILLER_0_19_802 VGND VGND VPWR VPWR sky130_fd_sc_hd__fill_2
XFILLER_0_58_492 VGND VGND VPWR VPWR sky130_fd_sc_hd__fill_1
X_08375_ net193 net252 VGND VGND VPWR VPWR _02756_ sky130_fd_sc_hd__or2_1
XFILLER_0_18_356 VGND VGND VPWR VPWR sky130_fd_sc_hd__decap_8
XFILLER_0_60_101 VGND VGND VPWR VPWR sky130_fd_sc_hd__decap_3
XFILLER_0_46_698 VGND VGND VPWR VPWR sky130_fd_sc_hd__fill_2
XFILLER_0_33_326 VGND VGND VPWR VPWR sky130_fd_sc_hd__decap_8
XFILLER_0_104_715 VGND VGND VPWR VPWR sky130_fd_sc_hd__fill_1
XFILLER_0_33_348 VGND VGND VPWR VPWR sky130_fd_sc_hd__decap_4
XFILLER_0_131_545 VGND VGND VPWR VPWR sky130_fd_sc_hd__decap_3
XFILLER_0_103_225 VPWR VGND VPWR VGND sky130_ef_sc_hd__decap_12
X_09829_ _03664_ VGND VGND VPWR VPWR _04058_ sky130_fd_sc_hd__clkbuf_8
XTAP_2101 VGND VPWR sky130_fd_sc_hd__tapvpwrvgnd_1
XFILLER_0_69_702 VGND VGND VPWR VPWR sky130_fd_sc_hd__fill_1
X_12840_ mem_do_wdata _02140_ _02284_ _06338_ VGND VGND VPWR VPWR _06340_ sky130_fd_sc_hd__and4b_1
XTAP_2134 VGND VPWR sky130_fd_sc_hd__tapvpwrvgnd_1
XTAP_2112 VGND VPWR sky130_fd_sc_hd__tapvpwrvgnd_1
XTAP_2123 VGND VPWR sky130_fd_sc_hd__tapvpwrvgnd_1
XFILLER_0_139_623 VGND VGND VPWR VPWR sky130_fd_sc_hd__fill_1
X_12771_ _06299_ VGND VGND VPWR VPWR _00776_ sky130_fd_sc_hd__clkbuf_1
XTAP_2167 VGND VPWR sky130_fd_sc_hd__tapvpwrvgnd_1
XTAP_2156 VGND VPWR sky130_fd_sc_hd__tapvpwrvgnd_1
XTAP_2145 VGND VPWR sky130_fd_sc_hd__tapvpwrvgnd_1
XTAP_1433 VGND VPWR sky130_fd_sc_hd__tapvpwrvgnd_1
XTAP_1422 VGND VPWR sky130_fd_sc_hd__tapvpwrvgnd_1
XTAP_1411 VGND VPWR sky130_fd_sc_hd__tapvpwrvgnd_1
XTAP_1400 VGND VPWR sky130_fd_sc_hd__tapvpwrvgnd_1
XFILLER_0_69_779 VGND VGND VPWR VPWR sky130_fd_sc_hd__decap_4
XFILLER_0_68_234 VGND VGND VPWR VPWR sky130_fd_sc_hd__decap_6
Xclkbuf_leaf_147_clk clknet_4_2_0_clk VGND VGND VPWR VPWR clknet_leaf_147_clk sky130_fd_sc_hd__clkbuf_16
XTAP_2189 VGND VPWR sky130_fd_sc_hd__tapvpwrvgnd_1
XTAP_2178 VGND VPWR sky130_fd_sc_hd__tapvpwrvgnd_1
X_11722_ _05480_ VGND VGND VPWR VPWR _00546_ sky130_fd_sc_hd__clkbuf_1
XTAP_1455 VGND VPWR sky130_fd_sc_hd__tapvpwrvgnd_1
XTAP_1466 VGND VPWR sky130_fd_sc_hd__tapvpwrvgnd_1
XTAP_1444 VGND VPWR sky130_fd_sc_hd__tapvpwrvgnd_1
XFILLER_0_56_418 VGND VGND VPWR VPWR sky130_fd_sc_hd__fill_2
X_14510_ net978 _05173_ _01612_ VGND VGND VPWR VPWR _01619_ sky130_fd_sc_hd__mux2_1
X_15490_ clknet_leaf_142_clk _00140_ VGND VGND VPWR VPWR cpuregs\[30\]\[8\] sky130_fd_sc_hd__dfxtp_1
XFILLER_0_127_818 VGND VGND VPWR VPWR sky130_fd_sc_hd__fill_2
X_11653_ _05047_ net989 _05410_ VGND VGND VPWR VPWR _05444_ sky130_fd_sc_hd__mux2_1
XFILLER_0_83_237 VGND VGND VPWR VPWR sky130_fd_sc_hd__decap_8
XTAP_1499 VGND VPWR sky130_fd_sc_hd__tapvpwrvgnd_1
XTAP_1488 VGND VPWR sky130_fd_sc_hd__tapvpwrvgnd_1
XTAP_1477 VGND VPWR sky130_fd_sc_hd__tapvpwrvgnd_1
XFILLER_0_49_492 VGND VGND VPWR VPWR sky130_fd_sc_hd__fill_1
X_14441_ _01582_ VGND VGND VPWR VPWR _01066_ sky130_fd_sc_hd__clkbuf_1
X_10604_ _03795_ _04805_ _04811_ VGND VGND VPWR VPWR _04812_ sky130_fd_sc_hd__or3_2
X_14372_ _04995_ net1434 _07616_ VGND VGND VPWR VPWR _01546_ sky130_fd_sc_hd__mux2_1
X_11584_ _05407_ VGND VGND VPWR VPWR _00481_ sky130_fd_sc_hd__clkbuf_1
XFILLER_0_107_553 VGND VGND VPWR VPWR sky130_fd_sc_hd__fill_1
X_13323_ cpuregs\[8\]\[16\] cpuregs\[9\]\[16\] _06764_ VGND VGND VPWR VPWR _06806_
+ sky130_fd_sc_hd__mux2_1
X_16111_ clknet_leaf_153_clk _00761_ VGND VGND VPWR VPWR count_cycle\[54\] sky130_fd_sc_hd__dfxtp_1
XFILLER_0_24_326 VGND VGND VPWR VPWR sky130_fd_sc_hd__decap_3
XFILLER_0_134_383 VGND VGND VPWR VPWR sky130_fd_sc_hd__fill_2
X_10535_ cpuregs\[16\]\[26\] cpuregs\[17\]\[26\] cpuregs\[18\]\[26\] cpuregs\[19\]\[26\]
+ _03938_ _04028_ VGND VGND VPWR VPWR _04745_ sky130_fd_sc_hd__mux4_1
XFILLER_0_101_49 VGND VGND VPWR VPWR sky130_fd_sc_hd__decap_6
X_17091_ net249 VGND VGND VPWR VPWR net232 sky130_fd_sc_hd__clkbuf_2
X_10466_ _02548_ _02578_ _03650_ VGND VGND VPWR VPWR _04678_ sky130_fd_sc_hd__mux2_1
X_16042_ clknet_leaf_29_clk _00692_ VGND VGND VPWR VPWR reg_next_pc\[17\] sky130_fd_sc_hd__dfxtp_1
X_13254_ _03308_ VGND VGND VPWR VPWR _06739_ sky130_fd_sc_hd__buf_4
XFILLER_0_122_589 VGND VGND VPWR VPWR sky130_fd_sc_hd__fill_2
X_12205_ decoded_imm_j\[7\] _05706_ VGND VGND VPWR VPWR _05828_ sky130_fd_sc_hd__and2_1
X_13185_ _06639_ _06671_ VGND VGND VPWR VPWR _06672_ sky130_fd_sc_hd__and2_1
X_10397_ _04610_ VGND VGND VPWR VPWR _00091_ sky130_fd_sc_hd__clkbuf_1
X_12136_ _05520_ _05764_ VGND VGND VPWR VPWR _05765_ sky130_fd_sc_hd__nand2_1
XFILLER_0_20_576 VGND VGND VPWR VPWR sky130_fd_sc_hd__fill_1
X_12067_ _03521_ reg_next_pc\[12\] _03222_ VGND VGND VPWR VPWR _05716_ sky130_fd_sc_hd__mux2_1
X_16944_ clknet_leaf_99_clk _01508_ VGND VGND VPWR VPWR cpuregs\[0\]\[31\] sky130_fd_sc_hd__dfxtp_1
X_16875_ clknet_leaf_47_clk _01439_ VGND VGND VPWR VPWR cpuregs\[22\]\[26\] sky130_fd_sc_hd__dfxtp_1
X_11018_ net930 _03464_ _05088_ VGND VGND VPWR VPWR _05092_ sky130_fd_sc_hd__mux2_1
X_15826_ clknet_leaf_53_clk _00476_ VGND VGND VPWR VPWR cpuregs\[16\]\[24\] sky130_fd_sc_hd__dfxtp_1
XFILLER_0_126_57 VGND VGND VPWR VPWR sky130_fd_sc_hd__decap_4
X_15757_ clknet_leaf_94_clk _00407_ VGND VGND VPWR VPWR cpuregs\[15\]\[19\] sky130_fd_sc_hd__dfxtp_1
X_12969_ cpuregs\[30\]\[5\] cpuregs\[31\]\[5\] _06462_ VGND VGND VPWR VPWR _06463_
+ sky130_fd_sc_hd__mux2_1
Xclkbuf_leaf_138_clk clknet_4_3_0_clk VGND VGND VPWR VPWR clknet_leaf_138_clk sky130_fd_sc_hd__clkbuf_16
X_15688_ clknet_leaf_18_clk _00338_ VGND VGND VPWR VPWR cpuregs\[27\]\[14\] sky130_fd_sc_hd__dfxtp_1
X_14708_ _04991_ net1603 _01720_ VGND VGND VPWR VPWR _01724_ sky130_fd_sc_hd__mux2_1
XFILLER_0_19_109 VGND VGND VPWR VPWR sky130_fd_sc_hd__decap_3
X_14639_ _01687_ VGND VGND VPWR VPWR _01191_ sky130_fd_sc_hd__clkbuf_1
X_08160_ count_instr\[23\] instr_rdinstr _02203_ count_instr\[55\] VGND VGND VPWR
+ VPWR _02550_ sky130_fd_sc_hd__a22o_1
XFILLER_0_16_805 VGND VGND VPWR VPWR sky130_fd_sc_hd__decap_6
XFILLER_0_132_309 VGND VGND VPWR VPWR sky130_fd_sc_hd__decap_3
XFILLER_0_51_98 VGND VGND VPWR VPWR sky130_fd_sc_hd__decap_8
X_16309_ clknet_leaf_27_clk _00894_ VGND VGND VPWR VPWR decoded_imm_j\[14\] sky130_fd_sc_hd__dfxtp_1
X_08091_ count_cycle\[19\] _02454_ _02483_ _02484_ VGND VGND VPWR VPWR _02485_ sky130_fd_sc_hd__a211o_2
XFILLER_0_15_337 VGND VGND VPWR VPWR sky130_fd_sc_hd__fill_1
XFILLER_0_30_318 VGND VGND VPWR VPWR sky130_fd_sc_hd__fill_1
XFILLER_0_23_381 VGND VGND VPWR VPWR sky130_fd_sc_hd__decap_8
XFILLER_0_100_239 VGND VGND VPWR VPWR sky130_fd_sc_hd__decap_4
X_08993_ reg_out\[30\] reg_next_pc\[30\] _03270_ VGND VGND VPWR VPWR _03287_ sky130_fd_sc_hd__mux2_1
X_07944_ reg_pc\[9\] decoded_imm\[9\] VGND VGND VPWR VPWR _02348_ sky130_fd_sc_hd__nand2_1
X_07875_ _02198_ VGND VGND VPWR VPWR _02284_ sky130_fd_sc_hd__buf_4
X_09614_ _02263_ _03845_ _03846_ _03847_ VGND VGND VPWR VPWR _03848_ sky130_fd_sc_hd__o211a_1
X_09545_ _02159_ VGND VGND VPWR VPWR _03780_ sky130_fd_sc_hd__clkbuf_4
Xclkbuf_leaf_129_clk clknet_4_8_0_clk VGND VGND VPWR VPWR clknet_leaf_129_clk sky130_fd_sc_hd__clkbuf_16
X_09476_ _02158_ _03711_ cpu_state\[4\] VGND VGND VPWR VPWR _03712_ sky130_fd_sc_hd__o21a_1
X_08427_ _02426_ _02779_ _02697_ _02801_ _02807_ VGND VGND VPWR VPWR _02808_ sky130_fd_sc_hd__o221a_1
XFILLER_0_136_648 VGND VGND VPWR VPWR sky130_fd_sc_hd__fill_1
XFILLER_0_135_169 VGND VGND VPWR VPWR sky130_fd_sc_hd__decap_6
XFILLER_0_135_136 VGND VGND VPWR VPWR sky130_fd_sc_hd__fill_1
X_08358_ _02735_ _02736_ _02737_ _02738_ VGND VGND VPWR VPWR _02739_ sky130_fd_sc_hd__a22o_1
XFILLER_0_46_495 VGND VGND VPWR VPWR sky130_fd_sc_hd__decap_4
X_08289_ _02660_ _02661_ _02662_ _02663_ _02669_ VGND VGND VPWR VPWR _02670_ sky130_fd_sc_hd__a221o_1
X_10320_ _04532_ _04533_ _04534_ _04535_ _04030_ _04103_ VGND VGND VPWR VPWR _04536_
+ sky130_fd_sc_hd__mux4_1
XFILLER_0_61_465 VGND VGND VPWR VPWR sky130_fd_sc_hd__fill_1
XFILLER_0_33_167 VGND VGND VPWR VPWR sky130_fd_sc_hd__fill_1
XFILLER_0_104_589 VGND VGND VPWR VPWR sky130_fd_sc_hd__decap_8
X_10251_ _03688_ _04468_ _03959_ VGND VGND VPWR VPWR _04469_ sky130_fd_sc_hd__o21a_1
X_10182_ _04401_ VGND VGND VPWR VPWR _00085_ sky130_fd_sc_hd__clkbuf_1
X_14990_ _01873_ VGND VGND VPWR VPWR _01356_ sky130_fd_sc_hd__clkbuf_1
Xfanout250 net124 VGND VGND VPWR VPWR net250 sky130_fd_sc_hd__clkbuf_8
X_13941_ instr_xori _07367_ _07338_ _07364_ VGND VGND VPWR VPWR _07373_ sky130_fd_sc_hd__a22o_1
XFILLER_0_88_307 VGND VGND VPWR VPWR sky130_fd_sc_hd__fill_1
XFILLER_0_88_318 VGND VGND VPWR VPWR sky130_fd_sc_hd__fill_2
X_16660_ clknet_leaf_143_clk _01227_ VGND VGND VPWR VPWR cpuregs\[29\]\[6\] sky130_fd_sc_hd__dfxtp_1
X_13872_ _07323_ VGND VGND VPWR VPWR _07324_ sky130_fd_sc_hd__clkbuf_4
X_12823_ _06326_ VGND VGND VPWR VPWR _00801_ sky130_fd_sc_hd__clkbuf_1
X_15611_ clknet_leaf_126_clk _00261_ VGND VGND VPWR VPWR cpuregs\[31\]\[1\] sky130_fd_sc_hd__dfxtp_1
X_16591_ clknet_leaf_120_clk _01158_ VGND VGND VPWR VPWR cpuregs\[9\]\[1\] sky130_fd_sc_hd__dfxtp_1
X_15542_ clknet_leaf_68_clk _00192_ VGND VGND VPWR VPWR cpuregs\[13\]\[28\] sky130_fd_sc_hd__dfxtp_1
X_12754_ _02653_ _06285_ _06287_ VGND VGND VPWR VPWR _06288_ sky130_fd_sc_hd__mux2_1
XTAP_1241 VGND VPWR sky130_fd_sc_hd__tapvpwrvgnd_1
XTAP_1230 VGND VPWR sky130_fd_sc_hd__tapvpwrvgnd_1
XFILLER_0_57_727 VGND VGND VPWR VPWR sky130_fd_sc_hd__fill_1
XFILLER_0_127_615 VGND VGND VPWR VPWR sky130_fd_sc_hd__fill_1
X_11705_ net612 _05207_ _05469_ VGND VGND VPWR VPWR _05472_ sky130_fd_sc_hd__mux2_1
XTAP_1263 VGND VPWR sky130_fd_sc_hd__tapvpwrvgnd_1
XTAP_1274 VGND VPWR sky130_fd_sc_hd__tapvpwrvgnd_1
XTAP_1252 VGND VPWR sky130_fd_sc_hd__tapvpwrvgnd_1
X_15473_ clknet_leaf_77_clk _00123_ VGND VGND VPWR VPWR cpuregs\[12\]\[23\] sky130_fd_sc_hd__dfxtp_1
XTAP_1296 VGND VPWR sky130_fd_sc_hd__tapvpwrvgnd_1
XTAP_1285 VGND VPWR sky130_fd_sc_hd__tapvpwrvgnd_1
X_12685_ count_cycle\[51\] count_cycle\[52\] _06219_ _06228_ VGND VGND VPWR VPWR _06229_
+ sky130_fd_sc_hd__and4_1
XFILLER_0_21_13 VPWR VGND VPWR VGND sky130_ef_sc_hd__decap_12
X_11636_ _05435_ VGND VGND VPWR VPWR _00505_ sky130_fd_sc_hd__clkbuf_1
XFILLER_0_112_59 VGND VGND VPWR VPWR sky130_fd_sc_hd__fill_1
X_14424_ _05047_ net1279 _07615_ VGND VGND VPWR VPWR _01573_ sky130_fd_sc_hd__mux2_1
XFILLER_0_52_421 VGND VGND VPWR VPWR sky130_fd_sc_hd__fill_1
XFILLER_0_4_507 VGND VGND VPWR VPWR sky130_fd_sc_hd__fill_2
XFILLER_0_24_101 VGND VGND VPWR VPWR sky130_fd_sc_hd__fill_2
XFILLER_0_135_670 VGND VGND VPWR VPWR sky130_fd_sc_hd__fill_2
X_11567_ _05029_ net1543 _05397_ VGND VGND VPWR VPWR _05399_ sky130_fd_sc_hd__mux2_1
XFILLER_0_115_7 VGND VGND VPWR VPWR sky130_fd_sc_hd__fill_1
X_14355_ _06025_ decoded_imm_j\[2\] _07567_ net617 _07388_ VGND VGND VPWR VPWR _07612_
+ sky130_fd_sc_hd__a221o_1
Xhold709 cpuregs\[2\]\[25\] VGND VGND VPWR VPWR net1067 sky130_fd_sc_hd__dlygate4sd3_1
X_10518_ _02082_ _04726_ _04727_ _03780_ VGND VGND VPWR VPWR _04728_ sky130_fd_sc_hd__a22o_1
X_13306_ _06783_ _06785_ _06788_ _06789_ VGND VGND VPWR VPWR _06790_ sky130_fd_sc_hd__a211o_1
X_14286_ decoded_imm\[31\] _07459_ _07569_ _07571_ VGND VGND VPWR VPWR _00998_ sky130_fd_sc_hd__o22a_1
XFILLER_0_40_616 VGND VGND VPWR VPWR sky130_fd_sc_hd__fill_2
X_11498_ net1020 _05205_ _05360_ VGND VGND VPWR VPWR _05362_ sky130_fd_sc_hd__mux2_1
X_16025_ clknet_leaf_37_clk _00675_ VGND VGND VPWR VPWR reg_pc\[31\] sky130_fd_sc_hd__dfxtp_2
X_13237_ _06459_ _06720_ _06722_ _06563_ VGND VGND VPWR VPWR _06723_ sky130_fd_sc_hd__a211o_1
X_10449_ _03863_ _04652_ _04660_ VGND VGND VPWR VPWR _04661_ sky130_fd_sc_hd__or3_2
X_13168_ cpuregs\[28\]\[11\] cpuregs\[29\]\[11\] _06349_ VGND VGND VPWR VPWR _06656_
+ sky130_fd_sc_hd__mux2_1
XFILLER_0_0_779 VGND VGND VPWR VPWR sky130_fd_sc_hd__decap_4
X_12119_ _03618_ reg_next_pc\[27\] _03223_ VGND VGND VPWR VPWR _05753_ sky130_fd_sc_hd__mux2_2
X_13099_ _03341_ _06588_ VGND VGND VPWR VPWR _06589_ sky130_fd_sc_hd__and2_1
X_16927_ clknet_leaf_106_clk _01491_ VGND VGND VPWR VPWR cpuregs\[0\]\[14\] sky130_fd_sc_hd__dfxtp_1
XFILLER_0_34_9 VGND VGND VPWR VPWR sky130_fd_sc_hd__decap_4
X_16858_ clknet_leaf_134_clk _01422_ VGND VGND VPWR VPWR cpuregs\[22\]\[9\] sky130_fd_sc_hd__dfxtp_1
X_07660_ mem_do_wdata mem_do_rdata mem_do_rinst _02087_ _02089_ VGND VGND VPWR VPWR
+ _02090_ sky130_fd_sc_hd__o311a_1
X_16789_ clknet_leaf_123_clk _01353_ VGND VGND VPWR VPWR cpuregs\[6\]\[4\] sky130_fd_sc_hd__dfxtp_1
X_15809_ clknet_leaf_129_clk _00459_ VGND VGND VPWR VPWR cpuregs\[16\]\[7\] sky130_fd_sc_hd__dfxtp_1
X_09330_ _03445_ VGND VGND VPWR VPWR _03578_ sky130_fd_sc_hd__buf_4
XFILLER_0_75_513 VGND VGND VPWR VPWR sky130_fd_sc_hd__fill_1
X_09261_ _03434_ _03514_ _03516_ _03517_ VGND VGND VPWR VPWR _03518_ sky130_fd_sc_hd__a22o_2
XFILLER_0_8_813 VPWR VGND VPWR VGND sky130_ef_sc_hd__decap_12
XFILLER_0_118_648 VGND VGND VPWR VPWR sky130_fd_sc_hd__decap_6
XFILLER_0_117_125 VPWR VGND VPWR VGND sky130_ef_sc_hd__decap_12
XFILLER_0_56_760 VGND VGND VPWR VPWR sky130_fd_sc_hd__fill_1
X_08212_ count_cycle\[27\] _02454_ _02596_ _02597_ VGND VGND VPWR VPWR _02598_ sky130_fd_sc_hd__a211o_2
X_09192_ _03457_ VGND VGND VPWR VPWR _00039_ sky130_fd_sc_hd__clkbuf_1
XFILLER_0_117_169 VGND VGND VPWR VPWR sky130_fd_sc_hd__decap_6
X_08143_ _02147_ _02532_ _02533_ VGND VGND VPWR VPWR _02534_ sky130_fd_sc_hd__and3_1
XFILLER_0_16_668 VGND VGND VPWR VPWR sky130_fd_sc_hd__fill_2
X_08074_ _02148_ _02464_ _02469_ _02200_ VGND VGND VPWR VPWR _02470_ sky130_fd_sc_hd__a211o_1
XFILLER_0_70_273 VGND VGND VPWR VPWR sky130_fd_sc_hd__decap_8
XFILLER_0_15_167 VGND VGND VPWR VPWR sky130_fd_sc_hd__fill_1
XFILLER_0_3_551 VGND VGND VPWR VPWR sky130_fd_sc_hd__decap_3
XFILLER_0_140_194 VGND VGND VPWR VPWR sky130_fd_sc_hd__fill_2
X_08976_ _02567_ _03275_ _03268_ VGND VGND VPWR VPWR _03276_ sky130_fd_sc_hd__mux2_1
Xhold36 _02146_ VGND VGND VPWR VPWR net394 sky130_fd_sc_hd__dlygate4sd3_1
Xhold47 instr_slli VGND VGND VPWR VPWR net405 sky130_fd_sc_hd__dlygate4sd3_1
X_07927_ reg_pc\[8\] decoded_imm\[8\] VGND VGND VPWR VPWR _02332_ sky130_fd_sc_hd__or2_1
Xhold69 count_instr\[24\] VGND VGND VPWR VPWR net427 sky130_fd_sc_hd__clkdlybuf4s25_1
Xhold58 count_cycle\[62\] VGND VGND VPWR VPWR net416 sky130_fd_sc_hd__dlygate4sd3_1
XFILLER_0_98_627 VGND VGND VPWR VPWR sky130_fd_sc_hd__fill_2
X_07858_ _02258_ _02259_ _02267_ VGND VGND VPWR VPWR _07643_ sky130_fd_sc_hd__a21bo_1
XFILLER_0_97_137 VGND VGND VPWR VPWR sky130_fd_sc_hd__decap_8
X_07789_ instr_rdinstrh VGND VGND VPWR VPWR _02203_ sky130_fd_sc_hd__clkbuf_4
X_09528_ _03753_ _03758_ _03760_ _03762_ _03660_ VGND VGND VPWR VPWR _03763_ sky130_fd_sc_hd__a221o_1
XFILLER_0_39_727 VGND VGND VPWR VPWR sky130_fd_sc_hd__fill_1
XFILLER_0_93_310 VGND VGND VPWR VPWR sky130_fd_sc_hd__decap_4
XFILLER_0_93_365 VGND VGND VPWR VPWR sky130_fd_sc_hd__decap_6
X_09459_ _03668_ VGND VGND VPWR VPWR _03695_ sky130_fd_sc_hd__buf_4
X_12470_ _05790_ _05756_ _06071_ _05802_ VGND VGND VPWR VPWR _06072_ sky130_fd_sc_hd__a22o_1
X_11421_ net961 _05196_ _05313_ VGND VGND VPWR VPWR _05321_ sky130_fd_sc_hd__mux2_1
XFILLER_0_34_421 VGND VGND VPWR VPWR sky130_fd_sc_hd__fill_2
X_11352_ _05284_ VGND VGND VPWR VPWR _00372_ sky130_fd_sc_hd__clkbuf_1
X_14140_ _05020_ net1456 _07482_ VGND VGND VPWR VPWR _07490_ sky130_fd_sc_hd__mux2_1
XFILLER_0_120_813 VGND VGND VPWR VPWR sky130_fd_sc_hd__fill_2
X_10303_ cpuregs\[8\]\[20\] cpuregs\[9\]\[20\] cpuregs\[10\]\[20\] cpuregs\[11\]\[20\]
+ _03876_ _03895_ VGND VGND VPWR VPWR _04519_ sky130_fd_sc_hd__mux4_1
XFILLER_0_15_690 VGND VGND VPWR VPWR sky130_fd_sc_hd__decap_3
X_14071_ decoded_imm_j\[16\] _01109_ _07420_ VGND VGND VPWR VPWR _07452_ sky130_fd_sc_hd__mux2_1
X_11283_ _05247_ VGND VGND VPWR VPWR _00340_ sky130_fd_sc_hd__clkbuf_1
XFILLER_0_131_194 VGND VGND VPWR VPWR sky130_fd_sc_hd__decap_3
X_10234_ cpuregs\[14\]\[18\] cpuregs\[15\]\[18\] _03756_ VGND VGND VPWR VPWR _04452_
+ sky130_fd_sc_hd__mux2_1
X_13022_ cpuregs\[0\]\[7\] cpuregs\[1\]\[7\] cpuregs\[2\]\[7\] cpuregs\[3\]\[7\] _06364_
+ _03400_ VGND VGND VPWR VPWR _06514_ sky130_fd_sc_hd__mux4_1
X_10165_ _03739_ _04380_ _04384_ _03873_ VGND VGND VPWR VPWR _04385_ sky130_fd_sc_hd__o211a_1
X_10096_ cpuregs\[20\]\[14\] cpuregs\[21\]\[14\] cpuregs\[22\]\[14\] cpuregs\[23\]\[14\]
+ _04100_ _03939_ VGND VGND VPWR VPWR _04318_ sky130_fd_sc_hd__mux4_1
X_14973_ _04944_ _01791_ VGND VGND VPWR VPWR _01864_ sky130_fd_sc_hd__or2_4
X_16712_ clknet_leaf_81_clk _01279_ VGND VGND VPWR VPWR cpuregs\[3\]\[26\] sky130_fd_sc_hd__dfxtp_1
X_13924_ net386 _07358_ _07339_ _02172_ VGND VGND VPWR VPWR _00857_ sky130_fd_sc_hd__a22o_1
X_16643_ clknet_leaf_62_clk _01210_ VGND VGND VPWR VPWR cpuregs\[23\]\[21\] sky130_fd_sc_hd__dfxtp_1
X_13855_ mem_rdata_q\[5\] net28 _02089_ VGND VGND VPWR VPWR _07313_ sky130_fd_sc_hd__mux2_1
XFILLER_0_97_671 VGND VGND VPWR VPWR sky130_fd_sc_hd__fill_1
X_12806_ net570 net79 _06313_ VGND VGND VPWR VPWR _06318_ sky130_fd_sc_hd__mux2_1
X_16574_ clknet_leaf_46_clk _01151_ VGND VGND VPWR VPWR cpuregs\[24\]\[26\] sky130_fd_sc_hd__dfxtp_1
X_10998_ _05039_ net1159 _05074_ VGND VGND VPWR VPWR _05081_ sky130_fd_sc_hd__mux2_1
X_13786_ _06421_ _07252_ _07254_ _06343_ VGND VGND VPWR VPWR _07255_ sky130_fd_sc_hd__a211o_1
XFILLER_0_29_215 VGND VGND VPWR VPWR sky130_fd_sc_hd__decap_8
XFILLER_0_84_365 VGND VGND VPWR VPWR sky130_fd_sc_hd__decap_4
XFILLER_0_84_343 VGND VGND VPWR VPWR sky130_fd_sc_hd__fill_1
X_12737_ _03818_ _06270_ VGND VGND VPWR VPWR _06271_ sky130_fd_sc_hd__or2_1
X_15525_ clknet_leaf_103_clk _00175_ VGND VGND VPWR VPWR cpuregs\[13\]\[11\] sky130_fd_sc_hd__dfxtp_1
XTAP_1082 VGND VPWR sky130_fd_sc_hd__tapvpwrvgnd_1
XTAP_1060 VGND VPWR sky130_fd_sc_hd__tapvpwrvgnd_1
XTAP_1071 VGND VPWR sky130_fd_sc_hd__tapvpwrvgnd_1
XTAP_1093 VGND VPWR sky130_fd_sc_hd__tapvpwrvgnd_1
X_12668_ count_cycle\[48\] count_cycle\[49\] VGND VGND VPWR VPWR _06217_ sky130_fd_sc_hd__and2_1
X_15456_ clknet_leaf_116_clk _00106_ VGND VGND VPWR VPWR cpuregs\[12\]\[6\] sky130_fd_sc_hd__dfxtp_1
X_14407_ _01564_ VGND VGND VPWR VPWR _01050_ sky130_fd_sc_hd__clkbuf_1
X_11619_ _05426_ VGND VGND VPWR VPWR _00497_ sky130_fd_sc_hd__clkbuf_1
XFILLER_0_37_281 VGND VGND VPWR VPWR sky130_fd_sc_hd__fill_2
XFILLER_0_37_292 VGND VGND VPWR VPWR sky130_fd_sc_hd__decap_3
XFILLER_0_114_128 VGND VGND VPWR VPWR sky130_fd_sc_hd__decap_3
XFILLER_0_106_3 VGND VGND VPWR VPWR sky130_fd_sc_hd__fill_2
XFILLER_0_53_785 VGND VGND VPWR VPWR sky130_fd_sc_hd__fill_1
X_12599_ count_cycle\[29\] _06165_ _02185_ VGND VGND VPWR VPWR _06168_ sky130_fd_sc_hd__o21ai_1
X_15387_ clknet_leaf_122_clk _00042_ VGND VGND VPWR VPWR cpuregs\[11\]\[5\] sky130_fd_sc_hd__dfxtp_1
Xhold517 cpuregs\[18\]\[19\] VGND VGND VPWR VPWR net875 sky130_fd_sc_hd__dlygate4sd3_1
X_14338_ _07320_ decoded_imm_j\[9\] _07588_ mem_rdata_q\[29\] _07382_ VGND VGND VPWR
+ VPWR _07602_ sky130_fd_sc_hd__a221o_1
Xhold506 cpuregs\[15\]\[12\] VGND VGND VPWR VPWR net864 sky130_fd_sc_hd__dlygate4sd3_1
Xhold539 reg_next_pc\[24\] VGND VGND VPWR VPWR net897 sky130_fd_sc_hd__dlygate4sd3_1
X_14269_ latched_rd\[0\] _07560_ _07561_ net396 VGND VGND VPWR VPWR _00991_ sky130_fd_sc_hd__a22o_1
XFILLER_0_12_137 VGND VGND VPWR VPWR sky130_fd_sc_hd__decap_3
Xhold528 cpuregs\[14\]\[5\] VGND VGND VPWR VPWR net886 sky130_fd_sc_hd__dlygate4sd3_1
Xmax_cap236 _07462_ VGND VGND VPWR VPWR net236 sky130_fd_sc_hd__buf_1
X_16008_ clknet_leaf_30_clk _00658_ VGND VGND VPWR VPWR reg_pc\[14\] sky130_fd_sc_hd__dfxtp_2
XTAP_800 VGND VPWR sky130_fd_sc_hd__tapvpwrvgnd_1
X_08830_ _03180_ _03181_ VGND VGND VPWR VPWR _03182_ sky130_fd_sc_hd__or2_1
XFILLER_0_0_587 VGND VGND VPWR VPWR sky130_fd_sc_hd__fill_1
XFILLER_0_20_192 VGND VGND VPWR VPWR sky130_fd_sc_hd__decap_4
XTAP_811 VGND VPWR sky130_fd_sc_hd__tapvpwrvgnd_1
XTAP_822 VGND VPWR sky130_fd_sc_hd__tapvpwrvgnd_1
XTAP_833 VGND VPWR sky130_fd_sc_hd__tapvpwrvgnd_1
XTAP_844 VGND VPWR sky130_fd_sc_hd__tapvpwrvgnd_1
Xhold1206 cpuregs\[8\]\[22\] VGND VGND VPWR VPWR net1564 sky130_fd_sc_hd__dlygate4sd3_1
XTAP_855 VGND VPWR sky130_fd_sc_hd__tapvpwrvgnd_1
XTAP_877 VGND VPWR sky130_fd_sc_hd__tapvpwrvgnd_1
XTAP_866 VGND VPWR sky130_fd_sc_hd__tapvpwrvgnd_1
X_08761_ _03117_ _03115_ _03112_ VGND VGND VPWR VPWR _03118_ sky130_fd_sc_hd__or3_1
Xhold1239 cpuregs\[29\]\[1\] VGND VGND VPWR VPWR net1597 sky130_fd_sc_hd__dlygate4sd3_1
Xhold1217 net135 VGND VGND VPWR VPWR net1575 sky130_fd_sc_hd__dlygate4sd3_1
Xhold1228 cpuregs\[5\]\[9\] VGND VGND VPWR VPWR net1586 sky130_fd_sc_hd__dlygate4sd3_1
XTAP_888 VGND VPWR sky130_fd_sc_hd__tapvpwrvgnd_1
XTAP_899 VGND VPWR sky130_fd_sc_hd__tapvpwrvgnd_1
X_08692_ _02711_ _02986_ _03053_ VGND VGND VPWR VPWR _03054_ sky130_fd_sc_hd__a21o_1
X_07712_ mem_do_rinst reg_pc\[1\] _02137_ VGND VGND VPWR VPWR _02138_ sky130_fd_sc_hd__a21oi_2
X_09313_ _03546_ _03560_ _03561_ _03562_ VGND VGND VPWR VPWR _03563_ sky130_fd_sc_hd__a22o_2
Xclkbuf_leaf_60_clk clknet_4_13_0_clk VGND VGND VPWR VPWR clknet_leaf_60_clk sky130_fd_sc_hd__clkbuf_16
X_09244_ _03500_ _03501_ _03502_ _03449_ VGND VGND VPWR VPWR _03503_ sky130_fd_sc_hd__a2bb2o_2
X_09175_ _03442_ VGND VGND VPWR VPWR _03443_ sky130_fd_sc_hd__inv_2
X_08126_ reg_pc\[21\] decoded_imm\[21\] VGND VGND VPWR VPWR _02518_ sky130_fd_sc_hd__and2_1
XFILLER_0_114_695 VGND VGND VPWR VPWR sky130_fd_sc_hd__decap_4
X_08057_ _02268_ _02444_ _02450_ _02453_ VGND VGND VPWR VPWR _07625_ sky130_fd_sc_hd__a31oi_1
XFILLER_0_3_381 VGND VGND VPWR VPWR sky130_fd_sc_hd__fill_2
Xpicorv32_270 VGND VGND VPWR VPWR picorv32_270/HI eoi[17] sky130_fd_sc_hd__conb_1
Xoutput48 net48 VGND VGND VPWR VPWR mem_addr[23] sky130_fd_sc_hd__clkbuf_4
Xoutput37 net37 VGND VGND VPWR VPWR mem_addr[12] sky130_fd_sc_hd__clkbuf_4
Xpicorv32_281 VGND VGND VPWR VPWR picorv32_281/HI eoi[28] sky130_fd_sc_hd__conb_1
Xoutput59 net59 VGND VGND VPWR VPWR mem_addr[4] sky130_fd_sc_hd__clkbuf_4
Xpicorv32_292 VGND VGND VPWR VPWR picorv32_292/HI pcpi_insn[3] sky130_fd_sc_hd__conb_1
XFILLER_0_11_192 VGND VGND VPWR VPWR sky130_fd_sc_hd__fill_1
X_08959_ _02493_ _03263_ _03246_ VGND VGND VPWR VPWR _03264_ sky130_fd_sc_hd__mux2_2
X_11970_ _05647_ VGND VGND VPWR VPWR _00627_ sky130_fd_sc_hd__clkbuf_1
X_10921_ _03609_ VGND VGND VPWR VPWR _05037_ sky130_fd_sc_hd__clkbuf_4
XFILLER_0_128_209 VGND VGND VPWR VPWR sky130_fd_sc_hd__decap_3
X_13640_ _07113_ net220 _06960_ VGND VGND VPWR VPWR _07114_ sky130_fd_sc_hd__mux2_1
X_10852_ _04990_ VGND VGND VPWR VPWR _00166_ sky130_fd_sc_hd__clkbuf_1
XFILLER_0_137_721 VGND VGND VPWR VPWR sky130_fd_sc_hd__fill_1
X_13571_ _06783_ _07044_ _07046_ _06789_ VGND VGND VPWR VPWR _07047_ sky130_fd_sc_hd__a211o_1
XFILLER_0_78_192 VGND VGND VPWR VPWR sky130_fd_sc_hd__decap_4
XPHY_143 VGND VGND VPWR VPWR sky130_fd_sc_hd__decap_3
XPHY_132 VGND VGND VPWR VPWR sky130_fd_sc_hd__decap_3
XPHY_121 VGND VGND VPWR VPWR sky130_fd_sc_hd__decap_3
XPHY_110 VGND VGND VPWR VPWR sky130_fd_sc_hd__decap_3
X_10783_ _04951_ VGND VGND VPWR VPWR _00136_ sky130_fd_sc_hd__clkbuf_1
XFILLER_0_39_557 VGND VGND VPWR VPWR sky130_fd_sc_hd__decap_3
Xclkbuf_leaf_51_clk clknet_4_7_0_clk VGND VGND VPWR VPWR clknet_leaf_51_clk sky130_fd_sc_hd__clkbuf_16
XPHY_176 VGND VGND VPWR VPWR sky130_fd_sc_hd__decap_3
XPHY_165 VGND VGND VPWR VPWR sky130_fd_sc_hd__decap_3
XPHY_154 VGND VGND VPWR VPWR sky130_fd_sc_hd__decap_3
X_12522_ count_cycle\[7\] _06110_ _05640_ VGND VGND VPWR VPWR _06113_ sky130_fd_sc_hd__a21oi_1
X_16290_ clknet_leaf_4_clk _00875_ VGND VGND VPWR VPWR instr_xor sky130_fd_sc_hd__dfxtp_1
X_15310_ _02040_ VGND VGND VPWR VPWR _02041_ sky130_fd_sc_hd__buf_4
X_15241_ _03641_ net1430 _01972_ VGND VGND VPWR VPWR _02006_ sky130_fd_sc_hd__mux2_1
XPHY_198 VGND VGND VPWR VPWR sky130_fd_sc_hd__decap_3
XPHY_187 VGND VGND VPWR VPWR sky130_fd_sc_hd__decap_3
XFILLER_0_124_437 VGND VGND VPWR VPWR sky130_fd_sc_hd__decap_4
X_12453_ _06004_ _05753_ VGND VGND VPWR VPWR _06056_ sky130_fd_sc_hd__nor2_1
X_15172_ _01969_ VGND VGND VPWR VPWR _01442_ sky130_fd_sc_hd__clkbuf_1
X_12384_ _05981_ _05736_ _05969_ VGND VGND VPWR VPWR _05993_ sky130_fd_sc_hd__o21a_1
XFILLER_0_22_413 VGND VGND VPWR VPWR sky130_fd_sc_hd__fill_1
X_11404_ net862 _05179_ _05302_ VGND VGND VPWR VPWR _05312_ sky130_fd_sc_hd__mux2_1
XFILLER_0_50_755 VGND VGND VPWR VPWR sky130_fd_sc_hd__fill_1
X_11335_ _05275_ VGND VGND VPWR VPWR _00364_ sky130_fd_sc_hd__clkbuf_1
X_14123_ _05003_ net1533 _07471_ VGND VGND VPWR VPWR _07481_ sky130_fd_sc_hd__mux2_1
XFILLER_0_120_654 VGND VGND VPWR VPWR sky130_fd_sc_hd__fill_1
XFILLER_0_120_643 VGND VGND VPWR VPWR sky130_fd_sc_hd__fill_1
X_14054_ _07443_ VGND VGND VPWR VPWR _01101_ sky130_fd_sc_hd__clkbuf_1
X_11266_ _05238_ VGND VGND VPWR VPWR _00332_ sky130_fd_sc_hd__clkbuf_1
X_10217_ _02159_ _04408_ _04435_ _03709_ VGND VGND VPWR VPWR _04436_ sky130_fd_sc_hd__a22o_1
X_13005_ _06455_ _06493_ _06497_ _06466_ VGND VGND VPWR VPWR _06498_ sky130_fd_sc_hd__o211a_1
XFILLER_0_94_29 VGND VGND VPWR VPWR sky130_fd_sc_hd__fill_1
X_11197_ _03551_ VGND VGND VPWR VPWR _05194_ sky130_fd_sc_hd__clkbuf_4
X_10148_ _04187_ _04366_ _04367_ _04363_ VGND VGND VPWR VPWR _04368_ sky130_fd_sc_hd__a31o_1
X_14956_ _01855_ VGND VGND VPWR VPWR _01340_ sky130_fd_sc_hd__clkbuf_1
X_10079_ cpu_state\[4\] _04300_ VGND VGND VPWR VPWR _04301_ sky130_fd_sc_hd__and2_1
X_13907_ mem_rdata_q\[13\] net5 _03291_ VGND VGND VPWR VPWR _07353_ sky130_fd_sc_hd__mux2_1
X_14887_ _03597_ net1000 _01815_ VGND VGND VPWR VPWR _01819_ sky130_fd_sc_hd__mux2_1
XFILLER_0_57_310 VGND VGND VPWR VPWR sky130_fd_sc_hd__fill_2
X_16626_ clknet_leaf_126_clk _01193_ VGND VGND VPWR VPWR cpuregs\[23\]\[4\] sky130_fd_sc_hd__dfxtp_1
XPHY_1 VGND VGND VPWR VPWR sky130_fd_sc_hd__decap_3
X_13838_ _02185_ _07301_ VGND VGND VPWR VPWR _07302_ sky130_fd_sc_hd__and2_1
X_13769_ _06970_ _07237_ VGND VGND VPWR VPWR _07238_ sky130_fd_sc_hd__and2_1
X_16557_ clknet_leaf_138_clk _01134_ VGND VGND VPWR VPWR cpuregs\[24\]\[9\] sky130_fd_sc_hd__dfxtp_1
Xclkbuf_leaf_42_clk clknet_4_7_0_clk VGND VGND VPWR VPWR clknet_leaf_42_clk sky130_fd_sc_hd__clkbuf_16
X_15508_ clknet_leaf_61_clk _00158_ VGND VGND VPWR VPWR cpuregs\[30\]\[26\] sky130_fd_sc_hd__dfxtp_1
XFILLER_0_84_184 VPWR VGND VPWR VGND sky130_ef_sc_hd__decap_12
XFILLER_0_17_229 VGND VGND VPWR VPWR sky130_fd_sc_hd__decap_4
X_16488_ clknet_leaf_138_clk _01070_ VGND VGND VPWR VPWR cpuregs\[19\]\[9\] sky130_fd_sc_hd__dfxtp_1
X_15439_ clknet_leaf_49_clk _00089_ VGND VGND VPWR VPWR net183 sky130_fd_sc_hd__dfxtp_4
XFILLER_0_4_101 VGND VGND VPWR VPWR sky130_fd_sc_hd__decap_8
XFILLER_0_25_273 VGND VGND VPWR VPWR sky130_fd_sc_hd__fill_1
Xhold314 cpuregs\[19\]\[17\] VGND VGND VPWR VPWR net672 sky130_fd_sc_hd__dlygate4sd3_1
Xhold303 cpuregs\[12\]\[7\] VGND VGND VPWR VPWR net661 sky130_fd_sc_hd__dlygate4sd3_1
Xhold325 cpuregs\[12\]\[2\] VGND VGND VPWR VPWR net683 sky130_fd_sc_hd__dlygate4sd3_1
XFILLER_0_41_777 VGND VGND VPWR VPWR sky130_fd_sc_hd__fill_1
Xhold369 cpuregs\[14\]\[25\] VGND VGND VPWR VPWR net727 sky130_fd_sc_hd__dlygate4sd3_1
Xhold358 cpuregs\[2\]\[22\] VGND VGND VPWR VPWR net716 sky130_fd_sc_hd__dlygate4sd3_1
Xhold347 cpuregs\[22\]\[15\] VGND VGND VPWR VPWR net705 sky130_fd_sc_hd__dlygate4sd3_1
X_09931_ _04154_ _04156_ VGND VGND VPWR VPWR _04157_ sky130_fd_sc_hd__nand2_1
XFILLER_0_68_63 VGND VGND VPWR VPWR sky130_fd_sc_hd__decap_4
Xhold336 cpuregs\[22\]\[12\] VGND VGND VPWR VPWR net694 sky130_fd_sc_hd__dlygate4sd3_1
XFILLER_0_7_66 VGND VGND VPWR VPWR sky130_fd_sc_hd__decap_6
XFILLER_0_1_830 VGND VGND VPWR VPWR sky130_fd_sc_hd__fill_2
XFILLER_0_7_88 VGND VGND VPWR VPWR sky130_fd_sc_hd__fill_2
XFILLER_0_0_351 VGND VGND VPWR VPWR sky130_fd_sc_hd__decap_4
X_09862_ _03669_ VGND VGND VPWR VPWR _04090_ sky130_fd_sc_hd__buf_4
XFILLER_0_110_197 VGND VGND VPWR VPWR sky130_fd_sc_hd__fill_1
XTAP_630 VGND VPWR sky130_fd_sc_hd__tapvpwrvgnd_1
XTAP_641 VGND VPWR sky130_fd_sc_hd__tapvpwrvgnd_1
XTAP_652 VGND VPWR sky130_fd_sc_hd__tapvpwrvgnd_1
X_08813_ _02915_ _02846_ _02738_ VGND VGND VPWR VPWR _03166_ sky130_fd_sc_hd__mux2_1
Xhold1003 cpuregs\[10\]\[27\] VGND VGND VPWR VPWR net1361 sky130_fd_sc_hd__dlygate4sd3_1
X_09793_ _03677_ _04017_ _04022_ _03660_ VGND VGND VPWR VPWR _04023_ sky130_fd_sc_hd__o211a_1
XTAP_663 VGND VPWR sky130_fd_sc_hd__tapvpwrvgnd_1
XTAP_674 VGND VPWR sky130_fd_sc_hd__tapvpwrvgnd_1
XTAP_685 VGND VPWR sky130_fd_sc_hd__tapvpwrvgnd_1
Xhold1014 cpuregs\[9\]\[8\] VGND VGND VPWR VPWR net1372 sky130_fd_sc_hd__dlygate4sd3_1
X_08744_ _02771_ _03064_ _03085_ _02122_ VGND VGND VPWR VPWR _03102_ sky130_fd_sc_hd__a31o_1
Xhold1036 cpuregs\[30\]\[31\] VGND VGND VPWR VPWR net1394 sky130_fd_sc_hd__dlygate4sd3_1
Xhold1058 cpuregs\[8\]\[6\] VGND VGND VPWR VPWR net1416 sky130_fd_sc_hd__dlygate4sd3_1
XTAP_696 VGND VPWR sky130_fd_sc_hd__tapvpwrvgnd_1
Xhold1047 cpuregs\[3\]\[8\] VGND VGND VPWR VPWR net1405 sky130_fd_sc_hd__dlygate4sd3_1
Xhold1025 cpuregs\[11\]\[7\] VGND VGND VPWR VPWR net1383 sky130_fd_sc_hd__dlygate4sd3_1
Xhold1069 cpuregs\[10\]\[2\] VGND VGND VPWR VPWR net1427 sky130_fd_sc_hd__dlygate4sd3_1
X_08675_ _03025_ net178 VGND VGND VPWR VPWR _03039_ sky130_fd_sc_hd__and2b_1
XTAP_1807 VGND VPWR sky130_fd_sc_hd__tapvpwrvgnd_1
XFILLER_0_95_416 VGND VGND VPWR VPWR sky130_fd_sc_hd__fill_1
XTAP_1829 VGND VPWR sky130_fd_sc_hd__tapvpwrvgnd_1
XTAP_1818 VGND VPWR sky130_fd_sc_hd__tapvpwrvgnd_1
XFILLER_0_138_518 VGND VGND VPWR VPWR sky130_fd_sc_hd__fill_1
XFILLER_0_76_641 VGND VGND VPWR VPWR sky130_fd_sc_hd__decap_3
XFILLER_0_118_220 VPWR VGND VPWR VGND sky130_ef_sc_hd__decap_12
Xclkbuf_leaf_33_clk clknet_4_5_0_clk VGND VGND VPWR VPWR clknet_leaf_33_clk sky130_fd_sc_hd__clkbuf_16
XFILLER_0_91_611 VGND VGND VPWR VPWR sky130_fd_sc_hd__decap_4
XFILLER_0_75_162 VGND VGND VPWR VPWR sky130_fd_sc_hd__fill_1
XFILLER_0_75_140 VGND VGND VPWR VPWR sky130_fd_sc_hd__fill_1
XFILLER_0_63_302 VPWR VGND VPWR VGND sky130_ef_sc_hd__decap_12
XFILLER_0_118_253 VGND VGND VPWR VPWR sky130_fd_sc_hd__fill_2
XFILLER_0_63_324 VGND VGND VPWR VPWR sky130_fd_sc_hd__fill_2
XFILLER_0_133_223 VGND VGND VPWR VPWR sky130_fd_sc_hd__fill_1
X_09227_ _03486_ _03487_ VGND VGND VPWR VPWR _03488_ sky130_fd_sc_hd__nor2_1
XFILLER_0_51_508 VGND VGND VPWR VPWR sky130_fd_sc_hd__fill_1
XFILLER_0_17_785 VPWR VGND VPWR VGND sky130_ef_sc_hd__decap_12
X_09158_ _03428_ VGND VGND VPWR VPWR _00030_ sky130_fd_sc_hd__clkbuf_1
XFILLER_0_133_278 VGND VGND VPWR VPWR sky130_fd_sc_hd__fill_2
X_08109_ _02441_ _02462_ _02476_ _02489_ VGND VGND VPWR VPWR _02502_ sky130_fd_sc_hd__or4_1
X_09089_ _03311_ _03368_ VGND VGND VPWR VPWR _03369_ sky130_fd_sc_hd__or2_1
XFILLER_0_32_755 VGND VGND VPWR VPWR sky130_fd_sc_hd__fill_1
XFILLER_0_102_643 VGND VGND VPWR VPWR sky130_fd_sc_hd__fill_1
XFILLER_0_102_632 VGND VGND VPWR VPWR sky130_fd_sc_hd__fill_2
X_11120_ _05145_ VGND VGND VPWR VPWR _00279_ sky130_fd_sc_hd__clkbuf_1
XFILLER_0_101_164 VGND VGND VPWR VPWR sky130_fd_sc_hd__decap_4
Xhold881 cpuregs\[20\]\[0\] VGND VGND VPWR VPWR net1239 sky130_fd_sc_hd__dlygate4sd3_1
Xhold870 cpuregs\[7\]\[5\] VGND VGND VPWR VPWR net1228 sky130_fd_sc_hd__dlygate4sd3_1
X_11051_ net806 _03571_ _05099_ VGND VGND VPWR VPWR _05109_ sky130_fd_sc_hd__mux2_1
Xhold892 cpuregs\[20\]\[1\] VGND VGND VPWR VPWR net1250 sky130_fd_sc_hd__dlygate4sd3_1
X_10002_ decoded_imm\[12\] net174 VGND VGND VPWR VPWR _04226_ sky130_fd_sc_hd__nand2_1
X_14810_ _01777_ VGND VGND VPWR VPWR _01272_ sky130_fd_sc_hd__clkbuf_1
X_15790_ clknet_leaf_49_clk _00440_ VGND VGND VPWR VPWR cpuregs\[26\]\[20\] sky130_fd_sc_hd__dfxtp_1
X_14741_ _05024_ net1552 _01731_ VGND VGND VPWR VPWR _01741_ sky130_fd_sc_hd__mux2_1
X_11953_ count_instr\[42\] _05632_ VGND VGND VPWR VPWR _05635_ sky130_fd_sc_hd__or2_1
X_14672_ _01704_ VGND VGND VPWR VPWR _01207_ sky130_fd_sc_hd__clkbuf_1
X_10904_ _05025_ VGND VGND VPWR VPWR _00183_ sky130_fd_sc_hd__clkbuf_1
X_11884_ _05584_ VGND VGND VPWR VPWR _05585_ sky130_fd_sc_hd__buf_6
XFILLER_0_39_310 VPWR VGND VPWR VGND sky130_ef_sc_hd__decap_12
X_13623_ _06911_ _07096_ VGND VGND VPWR VPWR _07097_ sky130_fd_sc_hd__or2_1
XFILLER_0_129_529 VGND VGND VPWR VPWR sky130_fd_sc_hd__fill_1
X_10835_ _04978_ VGND VGND VPWR VPWR _00161_ sky130_fd_sc_hd__clkbuf_1
X_16411_ clknet_leaf_139_clk _00993_ VGND VGND VPWR VPWR latched_rd\[2\] sky130_fd_sc_hd__dfxtp_1
Xclkbuf_leaf_24_clk clknet_4_4_0_clk VGND VGND VPWR VPWR clknet_leaf_24_clk sky130_fd_sc_hd__clkbuf_16
XFILLER_0_66_162 VGND VGND VPWR VPWR sky130_fd_sc_hd__fill_1
XFILLER_0_27_516 VGND VGND VPWR VPWR sky130_fd_sc_hd__fill_2
X_16342_ clknet_leaf_111_clk _00924_ VGND VGND VPWR VPWR cpuregs\[1\]\[7\] sky130_fd_sc_hd__dfxtp_1
X_13554_ cpuregs\[10\]\[23\] cpuregs\[11\]\[23\] _06766_ VGND VGND VPWR VPWR _07030_
+ sky130_fd_sc_hd__mux2_1
X_10766_ _04940_ VGND VGND VPWR VPWR _00130_ sky130_fd_sc_hd__clkbuf_1
X_13485_ cpuregs\[12\]\[21\] cpuregs\[13\]\[21\] cpuregs\[14\]\[21\] cpuregs\[15\]\[21\]
+ _06696_ _06728_ VGND VGND VPWR VPWR _06963_ sky130_fd_sc_hd__mux4_1
X_10697_ latched_rd\[3\] VGND VGND VPWR VPWR _04902_ sky130_fd_sc_hd__buf_4
X_12505_ count_cycle\[0\] count_cycle\[1\] count_cycle\[2\] VGND VGND VPWR VPWR _06101_
+ sky130_fd_sc_hd__and3_1
X_16273_ clknet_leaf_4_clk net391 VGND VGND VPWR VPWR instr_lhu sky130_fd_sc_hd__dfxtp_1
XFILLER_0_42_519 VGND VGND VPWR VPWR sky130_fd_sc_hd__fill_2
X_15224_ _01997_ VGND VGND VPWR VPWR _01466_ sky130_fd_sc_hd__clkbuf_1
X_12436_ _06039_ _06040_ VGND VGND VPWR VPWR _06041_ sky130_fd_sc_hd__nor2_1
XFILLER_0_140_727 VGND VGND VPWR VPWR sky130_fd_sc_hd__fill_1
X_15155_ net704 _03583_ _01959_ VGND VGND VPWR VPWR _01961_ sky130_fd_sc_hd__mux2_1
XFILLER_0_112_418 VGND VGND VPWR VPWR sky130_fd_sc_hd__fill_2
X_12367_ _05763_ net541 _05975_ _05977_ _05697_ VGND VGND VPWR VPWR _00694_ sky130_fd_sc_hd__o221a_1
X_14106_ _07472_ VGND VGND VPWR VPWR _00917_ sky130_fd_sc_hd__clkbuf_1
XFILLER_0_129_24 VGND VGND VPWR VPWR sky130_fd_sc_hd__decap_4
X_15086_ _01924_ VGND VGND VPWR VPWR _01401_ sky130_fd_sc_hd__clkbuf_1
X_12298_ _05735_ _05913_ _05914_ _05730_ VGND VGND VPWR VPWR _00688_ sky130_fd_sc_hd__o211a_1
X_11318_ _04981_ net1429 _05266_ VGND VGND VPWR VPWR _05267_ sky130_fd_sc_hd__mux2_1
X_14037_ decoded_imm_j\[12\] _01105_ _03430_ VGND VGND VPWR VPWR _07435_ sky130_fd_sc_hd__mux2_1
X_11249_ net960 _05159_ _05229_ VGND VGND VPWR VPWR _05230_ sky130_fd_sc_hd__mux2_1
XFILLER_0_38_77 VGND VGND VPWR VPWR sky130_fd_sc_hd__decap_6
XFILLER_0_89_232 VGND VGND VPWR VPWR sky130_fd_sc_hd__fill_1
X_15988_ clknet_leaf_0_clk _00638_ VGND VGND VPWR VPWR count_instr\[57\] sky130_fd_sc_hd__dfxtp_1
X_14939_ _01846_ VGND VGND VPWR VPWR _01332_ sky130_fd_sc_hd__clkbuf_1
X_08460_ _02840_ VGND VGND VPWR VPWR _02841_ sky130_fd_sc_hd__clkbuf_4
X_08391_ _02536_ _02771_ VGND VGND VPWR VPWR _02772_ sky130_fd_sc_hd__or2_1
X_16609_ clknet_leaf_91_clk _01176_ VGND VGND VPWR VPWR cpuregs\[9\]\[19\] sky130_fd_sc_hd__dfxtp_1
XFILLER_0_92_419 VGND VGND VPWR VPWR sky130_fd_sc_hd__fill_1
XFILLER_0_70_53 VGND VGND VPWR VPWR sky130_fd_sc_hd__decap_3
Xclkbuf_leaf_15_clk clknet_4_3_0_clk VGND VGND VPWR VPWR clknet_leaf_15_clk sky130_fd_sc_hd__clkbuf_16
XFILLER_0_18_505 VGND VGND VPWR VPWR sky130_fd_sc_hd__decap_4
XFILLER_0_57_184 VGND VGND VPWR VPWR sky130_fd_sc_hd__fill_1
XFILLER_0_57_173 VGND VGND VPWR VPWR sky130_fd_sc_hd__fill_1
XFILLER_0_116_757 VGND VGND VPWR VPWR sky130_fd_sc_hd__fill_2
X_09012_ mem_rdata_q\[17\] net9 _03292_ VGND VGND VPWR VPWR _03300_ sky130_fd_sc_hd__mux2_1
XFILLER_0_72_187 VGND VGND VPWR VPWR sky130_fd_sc_hd__fill_1
XFILLER_0_5_465 VGND VGND VPWR VPWR sky130_fd_sc_hd__fill_2
XFILLER_0_5_432 VGND VGND VPWR VPWR sky130_fd_sc_hd__decap_4
XFILLER_0_131_738 VGND VGND VPWR VPWR sky130_fd_sc_hd__fill_1
XFILLER_0_78_3 VGND VGND VPWR VPWR sky130_fd_sc_hd__decap_4
Xhold100 count_instr\[25\] VGND VGND VPWR VPWR net458 sky130_fd_sc_hd__dlygate4sd3_1
XFILLER_0_41_541 VGND VGND VPWR VPWR sky130_fd_sc_hd__decap_3
XFILLER_0_79_84 VGND VGND VPWR VPWR sky130_fd_sc_hd__decap_6
Xhold133 cpuregs\[0\]\[16\] VGND VGND VPWR VPWR net491 sky130_fd_sc_hd__dlygate4sd3_1
Xhold144 count_cycle\[21\] VGND VGND VPWR VPWR net502 sky130_fd_sc_hd__dlygate4sd3_1
XFILLER_0_14_777 VGND VGND VPWR VPWR sky130_fd_sc_hd__decap_6
Xhold111 instr_sh VGND VGND VPWR VPWR net469 sky130_fd_sc_hd__dlygate4sd3_1
Xhold122 instr_lw VGND VGND VPWR VPWR net480 sky130_fd_sc_hd__dlygate4sd3_1
Xhold177 net156 VGND VGND VPWR VPWR net535 sky130_fd_sc_hd__dlygate4sd3_1
Xhold155 net145 VGND VGND VPWR VPWR net513 sky130_fd_sc_hd__dlygate4sd3_1
Xhold166 cpuregs\[0\]\[0\] VGND VGND VPWR VPWR net524 sky130_fd_sc_hd__dlygate4sd3_1
Xhold188 net43 VGND VGND VPWR VPWR net546 sky130_fd_sc_hd__dlygate4sd3_1
Xhold199 net142 VGND VGND VPWR VPWR net557 sky130_fd_sc_hd__dlygate4sd3_1
X_09914_ cpuregs\[30\]\[9\] cpuregs\[31\]\[9\] _03835_ VGND VGND VPWR VPWR _04141_
+ sky130_fd_sc_hd__mux2_1
X_09845_ _04070_ _04071_ _04073_ VGND VGND VPWR VPWR _04074_ sky130_fd_sc_hd__a21oi_1
XTAP_460 VGND VPWR sky130_fd_sc_hd__tapvpwrvgnd_1
XTAP_471 VGND VPWR sky130_fd_sc_hd__tapvpwrvgnd_1
XTAP_482 VGND VPWR sky130_fd_sc_hd__tapvpwrvgnd_1
XTAP_493 VGND VPWR sky130_fd_sc_hd__tapvpwrvgnd_1
X_09776_ _03911_ _03912_ _03913_ _03956_ _04005_ VGND VGND VPWR VPWR _04006_ sky130_fd_sc_hd__a41o_1
XTAP_2305 VGND VPWR sky130_fd_sc_hd__tapvpwrvgnd_1
XTAP_2316 VGND VPWR sky130_fd_sc_hd__tapvpwrvgnd_1
X_08727_ _03064_ _03085_ _02122_ VGND VGND VPWR VPWR _03086_ sky130_fd_sc_hd__a21oi_1
XTAP_2349 VGND VPWR sky130_fd_sc_hd__tapvpwrvgnd_1
XTAP_2338 VGND VPWR sky130_fd_sc_hd__tapvpwrvgnd_1
XTAP_2327 VGND VPWR sky130_fd_sc_hd__tapvpwrvgnd_1
X_08658_ _02716_ _03022_ VGND VGND VPWR VPWR _03023_ sky130_fd_sc_hd__nand2_1
XTAP_1615 VGND VPWR sky130_fd_sc_hd__tapvpwrvgnd_1
XTAP_1604 VGND VPWR sky130_fd_sc_hd__tapvpwrvgnd_1
XFILLER_0_138_326 VGND VGND VPWR VPWR sky130_fd_sc_hd__fill_1
XTAP_1637 VGND VPWR sky130_fd_sc_hd__tapvpwrvgnd_1
XTAP_1648 VGND VPWR sky130_fd_sc_hd__tapvpwrvgnd_1
XTAP_1626 VGND VPWR sky130_fd_sc_hd__tapvpwrvgnd_1
XTAP_1659 VGND VPWR sky130_fd_sc_hd__tapvpwrvgnd_1
X_08589_ _02958_ _02959_ VGND VGND VPWR VPWR _02960_ sky130_fd_sc_hd__xor2_1
XFILLER_0_36_302 VGND VGND VPWR VPWR sky130_fd_sc_hd__decap_6
X_10620_ _02242_ _04790_ _04827_ VGND VGND VPWR VPWR _04828_ sky130_fd_sc_hd__a21o_1
XFILLER_0_91_430 VGND VGND VPWR VPWR sky130_fd_sc_hd__fill_1
X_10551_ _04045_ _04759_ _04121_ VGND VGND VPWR VPWR _04760_ sky130_fd_sc_hd__a21o_1
XFILLER_0_63_143 VPWR VGND VPWR VGND sky130_ef_sc_hd__decap_12
XFILLER_0_24_519 VGND VGND VPWR VPWR sky130_fd_sc_hd__decap_8
X_10482_ cpuregs\[12\]\[25\] cpuregs\[13\]\[25\] _03880_ VGND VGND VPWR VPWR _04693_
+ sky130_fd_sc_hd__mux2_1
XFILLER_0_106_234 VGND VGND VPWR VPWR sky130_fd_sc_hd__decap_3
X_13270_ cpuregs\[30\]\[14\] cpuregs\[31\]\[14\] _06754_ VGND VGND VPWR VPWR _06755_
+ sky130_fd_sc_hd__mux2_1
XFILLER_0_134_587 VGND VGND VPWR VPWR sky130_fd_sc_hd__fill_1
XFILLER_0_106_267 VGND VGND VPWR VPWR sky130_fd_sc_hd__fill_2
X_12221_ _05828_ _05833_ _05842_ VGND VGND VPWR VPWR _05843_ sky130_fd_sc_hd__o21ai_1
XFILLER_0_102_462 VGND VGND VPWR VPWR sky130_fd_sc_hd__fill_1
XFILLER_0_102_440 VGND VGND VPWR VPWR sky130_fd_sc_hd__fill_2
X_12152_ decoded_imm_j\[3\] _05698_ VGND VGND VPWR VPWR _05779_ sky130_fd_sc_hd__or2_1
X_12083_ _05696_ net1592 _05725_ _05727_ VGND VGND VPWR VPWR _00660_ sky130_fd_sc_hd__o211a_1
X_16960_ clknet_leaf_84_clk _01524_ VGND VGND VPWR VPWR cpuregs\[10\]\[15\] sky130_fd_sc_hd__dfxtp_1
X_11103_ net1331 _03519_ _05135_ VGND VGND VPWR VPWR _05137_ sky130_fd_sc_hd__mux2_1
X_15911_ clknet_leaf_98_clk _00561_ VGND VGND VPWR VPWR cpuregs\[17\]\[13\] sky130_fd_sc_hd__dfxtp_1
X_11034_ _05100_ VGND VGND VPWR VPWR _00238_ sky130_fd_sc_hd__clkbuf_1
X_16891_ clknet_leaf_107_clk _01455_ VGND VGND VPWR VPWR cpuregs\[8\]\[10\] sky130_fd_sc_hd__dfxtp_1
X_15842_ clknet_leaf_143_clk _00492_ VGND VGND VPWR VPWR cpuregs\[25\]\[8\] sky130_fd_sc_hd__dfxtp_1
X_15773_ clknet_leaf_130_clk _00423_ VGND VGND VPWR VPWR cpuregs\[26\]\[3\] sky130_fd_sc_hd__dfxtp_1
X_12985_ _06417_ _06473_ _06477_ _06428_ VGND VGND VPWR VPWR _06478_ sky130_fd_sc_hd__o211a_1
XFILLER_0_86_224 VPWR VGND VPWR VGND sky130_ef_sc_hd__decap_12
X_14724_ _01732_ VGND VGND VPWR VPWR _01231_ sky130_fd_sc_hd__clkbuf_1
X_11936_ _05622_ VGND VGND VPWR VPWR _00618_ sky130_fd_sc_hd__clkbuf_1
XFILLER_0_67_471 VGND VGND VPWR VPWR sky130_fd_sc_hd__fill_1
X_14655_ net1274 _05181_ _01695_ VGND VGND VPWR VPWR _01696_ sky130_fd_sc_hd__mux2_1
X_11867_ count_instr\[19\] count_instr\[18\] _05567_ VGND VGND VPWR VPWR _05572_ sky130_fd_sc_hd__and3_1
XFILLER_0_24_79 VGND VGND VPWR VPWR sky130_fd_sc_hd__fill_1
X_10818_ net657 _03584_ _04968_ VGND VGND VPWR VPWR _04970_ sky130_fd_sc_hd__mux2_1
X_13606_ _06792_ _07078_ _07080_ _06894_ VGND VGND VPWR VPWR _07081_ sky130_fd_sc_hd__a211o_1
X_14586_ _01647_ VGND VGND VPWR VPWR _01659_ sky130_fd_sc_hd__buf_4
X_11798_ _05519_ _05520_ count_instr\[0\] VGND VGND VPWR VPWR _05522_ sky130_fd_sc_hd__a21o_1
X_10749_ net1357 _03591_ _04929_ VGND VGND VPWR VPWR _04932_ sky130_fd_sc_hd__mux2_1
X_13537_ cpuregs\[22\]\[22\] cpuregs\[23\]\[22\] _06786_ VGND VGND VPWR VPWR _07014_
+ sky130_fd_sc_hd__mux2_1
X_16325_ clknet_leaf_13_clk _00910_ VGND VGND VPWR VPWR decoded_imm\[0\] sky130_fd_sc_hd__dfxtp_1
X_16256_ clknet_leaf_39_clk alu_out\[29\] VGND VGND VPWR VPWR alu_out_q\[29\] sky130_fd_sc_hd__dfxtp_1
XFILLER_0_125_543 VPWR VGND VPWR VGND sky130_ef_sc_hd__decap_12
X_13468_ _06849_ _06946_ VGND VGND VPWR VPWR _06947_ sky130_fd_sc_hd__or2_1
X_15207_ _01988_ VGND VGND VPWR VPWR _01458_ sky130_fd_sc_hd__clkbuf_1
Xoutput216 net216 VGND VGND VPWR VPWR pcpi_rs2[21] sky130_fd_sc_hd__clkbuf_4
X_12419_ _05811_ VGND VGND VPWR VPWR _06025_ sky130_fd_sc_hd__buf_4
X_13399_ _06580_ _06879_ VGND VGND VPWR VPWR _06880_ sky130_fd_sc_hd__or2_1
Xoutput205 net205 VGND VGND VPWR VPWR pcpi_rs2[11] sky130_fd_sc_hd__buf_2
X_16187_ clknet_leaf_4_clk _00805_ VGND VGND VPWR VPWR mem_do_wdata sky130_fd_sc_hd__dfxtp_4
XFILLER_0_64_9 VGND VGND VPWR VPWR sky130_fd_sc_hd__fill_2
X_15138_ net741 _03531_ _01948_ VGND VGND VPWR VPWR _01952_ sky130_fd_sc_hd__mux2_1
XFILLER_0_49_54 VGND VGND VPWR VPWR sky130_fd_sc_hd__fill_2
Xoutput227 net227 VGND VGND VPWR VPWR pcpi_rs2[31] sky130_fd_sc_hd__clkbuf_4
X_07960_ _02359_ _02362_ VGND VGND VPWR VPWR _02363_ sky130_fd_sc_hd__xor2_1
X_15069_ _01915_ VGND VGND VPWR VPWR _01393_ sky130_fd_sc_hd__clkbuf_1
Xclkbuf_leaf_4_clk clknet_4_1_0_clk VGND VGND VPWR VPWR clknet_leaf_4_clk sky130_fd_sc_hd__clkbuf_16
X_07891_ _02292_ _02293_ _02298_ VGND VGND VPWR VPWR _02299_ sky130_fd_sc_hd__a21o_1
X_09630_ _00016_ VGND VGND VPWR VPWR _03863_ sky130_fd_sc_hd__buf_4
XFILLER_0_65_97 VGND VGND VPWR VPWR sky130_fd_sc_hd__decap_3
X_09561_ _00016_ VGND VGND VPWR VPWR _03795_ sky130_fd_sc_hd__buf_4
X_08512_ _02887_ _02888_ VGND VGND VPWR VPWR _02889_ sky130_fd_sc_hd__or2_1
X_09492_ _03726_ VGND VGND VPWR VPWR _03727_ sky130_fd_sc_hd__clkbuf_8
XFILLER_0_136_808 VGND VGND VPWR VPWR sky130_fd_sc_hd__fill_2
X_08443_ net194 _02811_ _02744_ _02745_ _02823_ VGND VGND VPWR VPWR _02824_ sky130_fd_sc_hd__o32a_1
XFILLER_0_77_268 VGND VGND VPWR VPWR sky130_fd_sc_hd__decap_3
XFILLER_0_46_611 VGND VGND VPWR VPWR sky130_fd_sc_hd__fill_1
XFILLER_0_105_70 VGND VGND VPWR VPWR sky130_fd_sc_hd__decap_4
X_08374_ _02215_ _02751_ VGND VGND VPWR VPWR _02755_ sky130_fd_sc_hd__nand2_1
XFILLER_0_116_510 VGND VGND VPWR VPWR sky130_fd_sc_hd__decap_8
XFILLER_0_73_452 VGND VGND VPWR VPWR sky130_fd_sc_hd__decap_3
XFILLER_0_45_154 VGND VGND VPWR VPWR sky130_fd_sc_hd__decap_3
XFILLER_0_61_625 VGND VGND VPWR VPWR sky130_fd_sc_hd__decap_4
XFILLER_0_45_176 VGND VGND VPWR VPWR sky130_fd_sc_hd__fill_1
XFILLER_0_18_379 VGND VGND VPWR VPWR sky130_fd_sc_hd__fill_1
XFILLER_0_61_669 VGND VGND VPWR VPWR sky130_fd_sc_hd__decap_3
XFILLER_0_45_198 VGND VGND VPWR VPWR sky130_fd_sc_hd__decap_3
XFILLER_0_5_262 VPWR VGND VPWR VGND sky130_ef_sc_hd__decap_12
XFILLER_0_14_530 VGND VGND VPWR VPWR sky130_fd_sc_hd__fill_2
XFILLER_0_131_535 VGND VGND VPWR VPWR sky130_fd_sc_hd__fill_1
XFILLER_0_103_237 VGND VGND VPWR VPWR sky130_fd_sc_hd__decap_4
XFILLER_0_60_168 VGND VGND VPWR VPWR sky130_fd_sc_hd__decap_4
XTAP_290 VGND VPWR sky130_fd_sc_hd__tapvpwrvgnd_1
X_09828_ cpuregs\[24\]\[7\] cpuregs\[25\]\[7\] cpuregs\[26\]\[7\] cpuregs\[27\]\[7\]
+ _03902_ _03718_ VGND VGND VPWR VPWR _04057_ sky130_fd_sc_hd__mux4_1
X_09759_ _03676_ _03985_ _03989_ _03659_ VGND VGND VPWR VPWR _03990_ sky130_fd_sc_hd__o211a_1
XTAP_2135 VGND VPWR sky130_fd_sc_hd__tapvpwrvgnd_1
XTAP_2113 VGND VPWR sky130_fd_sc_hd__tapvpwrvgnd_1
XTAP_2124 VGND VPWR sky130_fd_sc_hd__tapvpwrvgnd_1
XTAP_2102 VGND VPWR sky130_fd_sc_hd__tapvpwrvgnd_1
X_12770_ net517 net92 _06294_ VGND VGND VPWR VPWR _06299_ sky130_fd_sc_hd__mux2_1
XTAP_2168 VGND VPWR sky130_fd_sc_hd__tapvpwrvgnd_1
XTAP_2157 VGND VPWR sky130_fd_sc_hd__tapvpwrvgnd_1
XTAP_2146 VGND VPWR sky130_fd_sc_hd__tapvpwrvgnd_1
XTAP_1423 VGND VPWR sky130_fd_sc_hd__tapvpwrvgnd_1
XTAP_1412 VGND VPWR sky130_fd_sc_hd__tapvpwrvgnd_1
XTAP_1401 VGND VPWR sky130_fd_sc_hd__tapvpwrvgnd_1
XFILLER_0_69_769 VGND VGND VPWR VPWR sky130_fd_sc_hd__fill_1
XTAP_2179 VGND VPWR sky130_fd_sc_hd__tapvpwrvgnd_1
X_11721_ net697 _05223_ _05446_ VGND VGND VPWR VPWR _05480_ sky130_fd_sc_hd__mux2_1
XFILLER_0_84_739 VGND VGND VPWR VPWR sky130_fd_sc_hd__fill_1
XFILLER_0_83_216 VGND VGND VPWR VPWR sky130_fd_sc_hd__fill_1
XTAP_1445 VGND VPWR sky130_fd_sc_hd__tapvpwrvgnd_1
XTAP_1456 VGND VPWR sky130_fd_sc_hd__tapvpwrvgnd_1
XTAP_1434 VGND VPWR sky130_fd_sc_hd__tapvpwrvgnd_1
X_11652_ _05443_ VGND VGND VPWR VPWR _00513_ sky130_fd_sc_hd__clkbuf_1
XTAP_1489 VGND VPWR sky130_fd_sc_hd__tapvpwrvgnd_1
XTAP_1478 VGND VPWR sky130_fd_sc_hd__tapvpwrvgnd_1
XTAP_1467 VGND VPWR sky130_fd_sc_hd__tapvpwrvgnd_1
X_14440_ net1281 _05171_ _01576_ VGND VGND VPWR VPWR _01582_ sky130_fd_sc_hd__mux2_1
X_10603_ _04125_ _04806_ _04810_ _03971_ VGND VGND VPWR VPWR _04811_ sky130_fd_sc_hd__o211a_1
X_14371_ _01545_ VGND VGND VPWR VPWR _01033_ sky130_fd_sc_hd__clkbuf_1
X_11583_ _05045_ net1490 _05397_ VGND VGND VPWR VPWR _05407_ sky130_fd_sc_hd__mux2_1
X_13322_ cpuregs\[12\]\[16\] cpuregs\[13\]\[16\] cpuregs\[14\]\[16\] cpuregs\[15\]\[16\]
+ _06696_ _06728_ VGND VGND VPWR VPWR _06805_ sky130_fd_sc_hd__mux4_1
X_16110_ clknet_leaf_152_clk _00760_ VGND VGND VPWR VPWR count_cycle\[53\] sky130_fd_sc_hd__dfxtp_1
X_10534_ cpuregs\[20\]\[26\] cpuregs\[21\]\[26\] cpuregs\[22\]\[26\] cpuregs\[23\]\[26\]
+ _04100_ _03936_ VGND VGND VPWR VPWR _04744_ sky130_fd_sc_hd__mux4_1
X_17090_ net125 VGND VGND VPWR VPWR net231 sky130_fd_sc_hd__buf_1
XFILLER_0_10_37 VGND VGND VPWR VPWR sky130_fd_sc_hd__decap_8
X_10465_ _04671_ _04675_ VGND VGND VPWR VPWR _04677_ sky130_fd_sc_hd__or2_1
X_16041_ clknet_leaf_29_clk _00691_ VGND VGND VPWR VPWR reg_next_pc\[16\] sky130_fd_sc_hd__dfxtp_1
X_13253_ _06434_ _06737_ VGND VGND VPWR VPWR _06738_ sky130_fd_sc_hd__and2_1
X_10396_ _04609_ _02536_ _04509_ VGND VGND VPWR VPWR _04610_ sky130_fd_sc_hd__mux2_1
X_12204_ decoded_imm_j\[7\] _05706_ VGND VGND VPWR VPWR _05827_ sky130_fd_sc_hd__nor2_1
X_13184_ cpuregs\[4\]\[12\] cpuregs\[5\]\[12\] _06575_ VGND VGND VPWR VPWR _06671_
+ sky130_fd_sc_hd__mux2_1
X_12135_ instr_jal decoded_imm_j\[1\] VGND VGND VPWR VPWR _05764_ sky130_fd_sc_hd__and2_1
X_16943_ clknet_leaf_91_clk _01507_ VGND VGND VPWR VPWR cpuregs\[0\]\[30\] sky130_fd_sc_hd__dfxtp_1
X_12066_ _05696_ net980 _05697_ _05715_ VGND VGND VPWR VPWR _00655_ sky130_fd_sc_hd__o211a_1
XFILLER_0_19_57 VGND VGND VPWR VPWR sky130_fd_sc_hd__decap_3
X_16874_ clknet_leaf_63_clk _01438_ VGND VGND VPWR VPWR cpuregs\[22\]\[25\] sky130_fd_sc_hd__dfxtp_1
X_11017_ _05091_ VGND VGND VPWR VPWR _00230_ sky130_fd_sc_hd__clkbuf_1
X_15825_ clknet_leaf_43_clk _00475_ VGND VGND VPWR VPWR cpuregs\[16\]\[23\] sky130_fd_sc_hd__dfxtp_1
XFILLER_0_35_34 VGND VGND VPWR VPWR sky130_fd_sc_hd__fill_1
XFILLER_0_99_393 VGND VGND VPWR VPWR sky130_fd_sc_hd__decap_6
X_15756_ clknet_leaf_85_clk _00406_ VGND VGND VPWR VPWR cpuregs\[15\]\[18\] sky130_fd_sc_hd__dfxtp_1
X_12968_ _00007_ VGND VGND VPWR VPWR _06462_ sky130_fd_sc_hd__clkbuf_8
XFILLER_0_129_101 VGND VGND VPWR VPWR sky130_fd_sc_hd__fill_2
XFILLER_0_74_205 VPWR VGND VPWR VGND sky130_ef_sc_hd__decap_12
XFILLER_0_59_279 VGND VGND VPWR VPWR sky130_fd_sc_hd__fill_1
X_15687_ clknet_leaf_98_clk _00337_ VGND VGND VPWR VPWR cpuregs\[27\]\[13\] sky130_fd_sc_hd__dfxtp_1
X_14707_ _01723_ VGND VGND VPWR VPWR _01223_ sky130_fd_sc_hd__clkbuf_1
X_12899_ _06382_ _06391_ _06396_ _03332_ VGND VGND VPWR VPWR _06397_ sky130_fd_sc_hd__o211a_1
X_11919_ count_instr\[33\] _05606_ VGND VGND VPWR VPWR _05610_ sky130_fd_sc_hd__or2_1
XFILLER_0_74_227 VGND VGND VPWR VPWR sky130_fd_sc_hd__fill_1
X_14638_ net1269 _05165_ _01684_ VGND VGND VPWR VPWR _01687_ sky130_fd_sc_hd__mux2_1
XTAP_1990 VGND VPWR sky130_fd_sc_hd__tapvpwrvgnd_1
XFILLER_0_83_794 VGND VGND VPWR VPWR sky130_fd_sc_hd__decap_3
XFILLER_0_82_260 VGND VGND VPWR VPWR sky130_fd_sc_hd__fill_1
X_16308_ clknet_leaf_27_clk _00893_ VGND VGND VPWR VPWR decoded_imm_j\[13\] sky130_fd_sc_hd__dfxtp_1
X_14569_ _01650_ VGND VGND VPWR VPWR _01158_ sky130_fd_sc_hd__clkbuf_1
X_08090_ count_instr\[19\] _02201_ count_cycle\[51\] _02456_ VGND VGND VPWR VPWR _02484_
+ sky130_fd_sc_hd__a22o_1
X_16239_ clknet_leaf_22_clk alu_out\[12\] VGND VGND VPWR VPWR alu_out_q\[12\] sky130_fd_sc_hd__dfxtp_1
XFILLER_0_2_243 VGND VGND VPWR VPWR sky130_fd_sc_hd__fill_1
XFILLER_0_23_393 VGND VGND VPWR VPWR sky130_fd_sc_hd__fill_2
X_08992_ _03286_ VGND VGND VPWR VPWR net85 sky130_fd_sc_hd__buf_2
XFILLER_0_76_41 VGND VGND VPWR VPWR sky130_fd_sc_hd__decap_8
XFILLER_0_76_85 VGND VGND VPWR VPWR sky130_fd_sc_hd__decap_4
X_07943_ reg_pc\[9\] decoded_imm\[9\] VGND VGND VPWR VPWR _02347_ sky130_fd_sc_hd__or2_1
X_07874_ net27 net130 _02282_ _02219_ VGND VGND VPWR VPWR _02283_ sky130_fd_sc_hd__a22o_1
X_09613_ net245 VGND VGND VPWR VPWR _03847_ sky130_fd_sc_hd__buf_4
XFILLER_0_92_40 VGND VGND VPWR VPWR sky130_fd_sc_hd__fill_1
XFILLER_0_78_544 VGND VGND VPWR VPWR sky130_fd_sc_hd__fill_2
X_09544_ _02294_ _03652_ _03365_ VGND VGND VPWR VPWR _03779_ sky130_fd_sc_hd__a21o_1
XFILLER_0_93_503 VGND VGND VPWR VPWR sky130_fd_sc_hd__fill_1
X_09475_ _03648_ _03710_ VGND VGND VPWR VPWR _03711_ sky130_fd_sc_hd__and2b_1
X_08426_ _02695_ _02806_ VGND VGND VPWR VPWR _02807_ sky130_fd_sc_hd__nand2_1
XFILLER_0_135_126 VGND VGND VPWR VPWR sky130_fd_sc_hd__fill_2
X_08357_ net191 net223 VGND VGND VPWR VPWR _02738_ sky130_fd_sc_hd__nand2_1
XFILLER_0_46_485 VGND VGND VPWR VPWR sky130_fd_sc_hd__fill_1
X_08288_ _02665_ _02666_ _02667_ _02668_ VGND VGND VPWR VPWR _02669_ sky130_fd_sc_hd__a22o_1
XFILLER_0_61_444 VGND VGND VPWR VPWR sky130_fd_sc_hd__fill_1
XFILLER_0_61_422 VGND VGND VPWR VPWR sky130_fd_sc_hd__fill_1
XFILLER_0_33_113 VGND VGND VPWR VPWR sky130_fd_sc_hd__fill_1
X_10250_ _04464_ _04465_ _04466_ _04467_ _03676_ _03659_ VGND VGND VPWR VPWR _04468_
+ sky130_fd_sc_hd__mux4_2
XFILLER_0_131_387 VGND VGND VPWR VPWR sky130_fd_sc_hd__fill_2
X_10181_ _04400_ _02445_ _04150_ VGND VGND VPWR VPWR _04401_ sky130_fd_sc_hd__mux2_1
X_13940_ _07372_ VGND VGND VPWR VPWR _00863_ sky130_fd_sc_hd__clkbuf_1
Xfanout251 net123 VGND VGND VPWR VPWR net251 sky130_fd_sc_hd__buf_4
X_15610_ clknet_leaf_125_clk _00260_ VGND VGND VPWR VPWR cpuregs\[31\]\[0\] sky130_fd_sc_hd__dfxtp_1
X_13871_ _02165_ decoder_pseudo_trigger VGND VGND VPWR VPWR _07323_ sky130_fd_sc_hd__or2_1
X_12822_ net536 net88 _06293_ VGND VGND VPWR VPWR _06326_ sky130_fd_sc_hd__mux2_1
X_16590_ clknet_leaf_118_clk _01157_ VGND VGND VPWR VPWR cpuregs\[9\]\[0\] sky130_fd_sc_hd__dfxtp_1
X_15541_ clknet_leaf_71_clk _00191_ VGND VGND VPWR VPWR cpuregs\[13\]\[27\] sky130_fd_sc_hd__dfxtp_1
X_12753_ _02309_ _06286_ _03714_ VGND VGND VPWR VPWR _06287_ sky130_fd_sc_hd__a21oi_1
XFILLER_0_96_374 VGND VGND VPWR VPWR sky130_fd_sc_hd__fill_2
XTAP_1231 VGND VPWR sky130_fd_sc_hd__tapvpwrvgnd_1
XTAP_1220 VGND VPWR sky130_fd_sc_hd__tapvpwrvgnd_1
XFILLER_0_139_443 VGND VGND VPWR VPWR sky130_fd_sc_hd__fill_2
X_11704_ _05471_ VGND VGND VPWR VPWR _00537_ sky130_fd_sc_hd__clkbuf_1
X_15472_ clknet_leaf_78_clk _00122_ VGND VGND VPWR VPWR cpuregs\[12\]\[22\] sky130_fd_sc_hd__dfxtp_1
XFILLER_0_84_525 VGND VGND VPWR VPWR sky130_fd_sc_hd__fill_1
XTAP_1264 VGND VPWR sky130_fd_sc_hd__tapvpwrvgnd_1
XTAP_1275 VGND VPWR sky130_fd_sc_hd__tapvpwrvgnd_1
XTAP_1253 VGND VPWR sky130_fd_sc_hd__tapvpwrvgnd_1
XTAP_1242 VGND VPWR sky130_fd_sc_hd__tapvpwrvgnd_1
X_14423_ _01572_ VGND VGND VPWR VPWR _01058_ sky130_fd_sc_hd__clkbuf_1
XTAP_1297 VGND VPWR sky130_fd_sc_hd__tapvpwrvgnd_1
XTAP_1286 VGND VPWR sky130_fd_sc_hd__tapvpwrvgnd_1
X_12684_ count_cycle\[53\] count_cycle\[54\] VGND VGND VPWR VPWR _06228_ sky130_fd_sc_hd__and2_1
X_11635_ _05029_ net1025 _05433_ VGND VGND VPWR VPWR _05435_ sky130_fd_sc_hd__mux2_1
XFILLER_0_126_126 VGND VGND VPWR VPWR sky130_fd_sc_hd__decap_3
XFILLER_0_108_830 VGND VGND VPWR VPWR sky130_fd_sc_hd__fill_2
XFILLER_0_92_580 VGND VGND VPWR VPWR sky130_fd_sc_hd__fill_2
X_11566_ _05398_ VGND VGND VPWR VPWR _00472_ sky130_fd_sc_hd__clkbuf_1
X_14354_ mem_rdata_q\[22\] _07460_ VGND VGND VPWR VPWR _07611_ sky130_fd_sc_hd__and2_1
XFILLER_0_13_809 VGND VGND VPWR VPWR sky130_fd_sc_hd__fill_2
X_10517_ _02536_ _02578_ _02646_ _02605_ _03847_ _03916_ VGND VGND VPWR VPWR _04727_
+ sky130_fd_sc_hd__mux4_1
XFILLER_0_108_7 VGND VGND VPWR VPWR sky130_fd_sc_hd__fill_1
X_13305_ _03328_ VGND VGND VPWR VPWR _06789_ sky130_fd_sc_hd__clkbuf_4
X_14285_ _07570_ _07460_ mem_rdata_q\[31\] VGND VGND VPWR VPWR _07571_ sky130_fd_sc_hd__o21a_1
X_16024_ clknet_leaf_37_clk _00674_ VGND VGND VPWR VPWR reg_pc\[30\] sky130_fd_sc_hd__dfxtp_2
X_11497_ _05361_ VGND VGND VPWR VPWR _00440_ sky130_fd_sc_hd__clkbuf_1
X_13236_ _06461_ _06721_ VGND VGND VPWR VPWR _06722_ sky130_fd_sc_hd__and2_1
X_10448_ _03739_ _04653_ _04659_ VGND VGND VPWR VPWR _04660_ sky130_fd_sc_hd__o21ba_1
X_10379_ _03878_ _04590_ _04592_ VGND VGND VPWR VPWR _04593_ sky130_fd_sc_hd__a21o_1
X_13167_ cpuregs\[24\]\[11\] cpuregs\[25\]\[11\] cpuregs\[26\]\[11\] cpuregs\[27\]\[11\]
+ _06525_ _06558_ VGND VGND VPWR VPWR _06655_ sky130_fd_sc_hd__mux4_1
X_12118_ _05735_ _05751_ _05752_ _05730_ VGND VGND VPWR VPWR _00670_ sky130_fd_sc_hd__o211a_1
X_13098_ cpuregs\[22\]\[9\] cpuregs\[23\]\[9\] _06450_ VGND VGND VPWR VPWR _06588_
+ sky130_fd_sc_hd__mux2_1
X_12049_ _03480_ reg_next_pc\[6\] _03221_ VGND VGND VPWR VPWR _05704_ sky130_fd_sc_hd__mux2_2
X_16926_ clknet_leaf_111_clk _01490_ VGND VGND VPWR VPWR cpuregs\[0\]\[13\] sky130_fd_sc_hd__dfxtp_1
XFILLER_0_137_57 VPWR VGND VPWR VGND sky130_ef_sc_hd__decap_12
XFILLER_0_46_66 VGND VGND VPWR VPWR sky130_fd_sc_hd__decap_4
XFILLER_0_46_99 VGND VGND VPWR VPWR sky130_fd_sc_hd__decap_3
X_16857_ clknet_leaf_141_clk _01421_ VGND VGND VPWR VPWR cpuregs\[22\]\[8\] sky130_fd_sc_hd__dfxtp_1
X_15808_ clknet_leaf_145_clk _00458_ VGND VGND VPWR VPWR cpuregs\[16\]\[6\] sky130_fd_sc_hd__dfxtp_1
X_16788_ clknet_leaf_122_clk _01352_ VGND VGND VPWR VPWR cpuregs\[6\]\[3\] sky130_fd_sc_hd__dfxtp_1
XFILLER_0_1_57 VGND VGND VPWR VPWR sky130_fd_sc_hd__fill_1
X_15739_ clknet_leaf_124_clk _00389_ VGND VGND VPWR VPWR cpuregs\[15\]\[1\] sky130_fd_sc_hd__dfxtp_1
X_09260_ reg_pc\[11\] _03507_ VGND VGND VPWR VPWR _03517_ sky130_fd_sc_hd__or2_1
XFILLER_0_62_65 VGND VGND VPWR VPWR sky130_fd_sc_hd__decap_3
XFILLER_0_118_627 VPWR VGND VPWR VGND sky130_ef_sc_hd__decap_12
XFILLER_0_8_825 VGND VGND VPWR VPWR sky130_fd_sc_hd__decap_6
X_08211_ count_instr\[27\] _02201_ count_cycle\[59\] _02456_ VGND VGND VPWR VPWR _02597_
+ sky130_fd_sc_hd__a22o_1
XFILLER_0_7_313 VGND VGND VPWR VPWR sky130_fd_sc_hd__fill_1
XFILLER_0_117_137 VGND VGND VPWR VPWR sky130_fd_sc_hd__decap_3
XFILLER_0_90_539 VGND VGND VPWR VPWR sky130_fd_sc_hd__fill_2
XFILLER_0_16_625 VGND VGND VPWR VPWR sky130_fd_sc_hd__fill_1
XFILLER_0_28_474 VGND VGND VPWR VPWR sky130_fd_sc_hd__fill_2
X_09191_ net869 _03456_ _03446_ VGND VGND VPWR VPWR _03457_ sky130_fd_sc_hd__mux2_1
X_08142_ _02517_ _02531_ _02528_ VGND VGND VPWR VPWR _02533_ sky130_fd_sc_hd__or3_1
XFILLER_0_71_753 VGND VGND VPWR VPWR sky130_fd_sc_hd__decap_8
XFILLER_0_43_444 VGND VGND VPWR VPWR sky130_fd_sc_hd__fill_1
X_08073_ _02221_ _02465_ _02467_ _02242_ _02468_ VGND VGND VPWR VPWR _02469_ sky130_fd_sc_hd__a32o_1
XFILLER_0_70_241 VGND VGND VPWR VPWR sky130_fd_sc_hd__fill_2
XFILLER_0_101_505 VGND VGND VPWR VPWR sky130_fd_sc_hd__fill_2
XFILLER_0_140_151 VGND VGND VPWR VPWR sky130_fd_sc_hd__decap_6
XFILLER_0_60_3 VGND VGND VPWR VPWR sky130_fd_sc_hd__decap_3
X_08975_ reg_out\[24\] reg_next_pc\[24\] _03270_ VGND VGND VPWR VPWR _03275_ sky130_fd_sc_hd__mux2_1
X_07926_ _02319_ _02322_ _02320_ VGND VGND VPWR VPWR _02331_ sky130_fd_sc_hd__o21a_1
Xhold37 decoded_rd\[2\] VGND VGND VPWR VPWR net395 sky130_fd_sc_hd__dlygate4sd3_1
Xhold48 count_instr\[56\] VGND VGND VPWR VPWR net406 sky130_fd_sc_hd__dlygate4sd3_1
Xhold59 mem_rdata_q\[6\] VGND VGND VPWR VPWR net417 sky130_fd_sc_hd__dlygate4sd3_1
X_07857_ _02222_ _02262_ _02266_ VGND VGND VPWR VPWR _02267_ sky130_fd_sc_hd__a21oi_1
XFILLER_0_97_127 VGND VGND VPWR VPWR sky130_fd_sc_hd__fill_2
X_07788_ _02173_ VGND VGND VPWR VPWR _02202_ sky130_fd_sc_hd__clkbuf_4
X_09527_ _03696_ _03761_ _03676_ VGND VGND VPWR VPWR _03762_ sky130_fd_sc_hd__o21a_1
XFILLER_0_54_709 VGND VGND VPWR VPWR sky130_fd_sc_hd__fill_1
X_09458_ _03677_ _03693_ VGND VGND VPWR VPWR _03694_ sky130_fd_sc_hd__nor2_1
X_09389_ _03628_ VGND VGND VPWR VPWR _03629_ sky130_fd_sc_hd__buf_2
XFILLER_0_93_388 VGND VGND VPWR VPWR sky130_fd_sc_hd__fill_1
X_08409_ _02660_ _02661_ net251 VGND VGND VPWR VPWR _02790_ sky130_fd_sc_hd__a21bo_1
XFILLER_0_47_783 VGND VGND VPWR VPWR sky130_fd_sc_hd__fill_1
X_11420_ _05320_ VGND VGND VPWR VPWR _00404_ sky130_fd_sc_hd__clkbuf_1
XFILLER_0_62_742 VGND VGND VPWR VPWR sky130_fd_sc_hd__decap_4
XFILLER_0_34_411 VGND VGND VPWR VPWR sky130_fd_sc_hd__decap_4
X_11351_ _05018_ net1358 _05277_ VGND VGND VPWR VPWR _05284_ sky130_fd_sc_hd__mux2_1
XFILLER_0_34_477 VGND VGND VPWR VPWR sky130_fd_sc_hd__fill_1
XFILLER_0_132_663 VGND VGND VPWR VPWR sky130_fd_sc_hd__fill_1
X_10302_ _02081_ _04515_ _04516_ _04517_ _02241_ VGND VGND VPWR VPWR _04518_ sky130_fd_sc_hd__a32o_1
XFILLER_0_104_365 VGND VGND VPWR VPWR sky130_fd_sc_hd__decap_4
X_14070_ _07451_ VGND VGND VPWR VPWR _00902_ sky130_fd_sc_hd__clkbuf_1
X_11282_ net640 _05194_ _05240_ VGND VGND VPWR VPWR _05247_ sky130_fd_sc_hd__mux2_1
X_10233_ cpuregs\[8\]\[18\] cpuregs\[9\]\[18\] cpuregs\[10\]\[18\] cpuregs\[11\]\[18\]
+ _03865_ _03727_ VGND VGND VPWR VPWR _04451_ sky130_fd_sc_hd__mux4_1
X_13021_ _06434_ _06512_ VGND VGND VPWR VPWR _06513_ sky130_fd_sc_hd__and2_1
X_10164_ _03878_ _04381_ _04383_ VGND VGND VPWR VPWR _04384_ sky130_fd_sc_hd__a21o_1
X_10095_ cpuregs\[24\]\[14\] cpuregs\[25\]\[14\] cpuregs\[26\]\[14\] cpuregs\[27\]\[14\]
+ _03935_ _03936_ VGND VGND VPWR VPWR _04317_ sky130_fd_sc_hd__mux4_1
X_14972_ _01863_ VGND VGND VPWR VPWR _01348_ sky130_fd_sc_hd__clkbuf_1
X_16711_ clknet_leaf_72_clk _01278_ VGND VGND VPWR VPWR cpuregs\[3\]\[25\] sky130_fd_sc_hd__dfxtp_1
X_13923_ net480 _07358_ _07362_ _02172_ VGND VGND VPWR VPWR _00856_ sky130_fd_sc_hd__a22o_1
X_16642_ clknet_leaf_53_clk _01209_ VGND VGND VPWR VPWR cpuregs\[23\]\[20\] sky130_fd_sc_hd__dfxtp_1
XFILLER_0_88_149 VGND VGND VPWR VPWR sky130_fd_sc_hd__decap_4
X_13854_ _07309_ _01096_ _01095_ VGND VGND VPWR VPWR _07312_ sky130_fd_sc_hd__nor3b_1
X_16573_ clknet_leaf_66_clk _01150_ VGND VGND VPWR VPWR cpuregs\[24\]\[25\] sky130_fd_sc_hd__dfxtp_1
X_12805_ _06317_ VGND VGND VPWR VPWR _00792_ sky130_fd_sc_hd__clkbuf_1
X_10997_ _05080_ VGND VGND VPWR VPWR _00221_ sky130_fd_sc_hd__clkbuf_1
XFILLER_0_96_160 VGND VGND VPWR VPWR sky130_fd_sc_hd__decap_6
X_13785_ _06387_ _07253_ VGND VGND VPWR VPWR _07254_ sky130_fd_sc_hd__and2_1
X_15524_ clknet_leaf_107_clk _00174_ VGND VGND VPWR VPWR cpuregs\[13\]\[10\] sky130_fd_sc_hd__dfxtp_1
X_12736_ cpuregs\[16\]\[31\] cpuregs\[17\]\[31\] cpuregs\[18\]\[31\] cpuregs\[19\]\[31\]
+ _03831_ _03832_ VGND VGND VPWR VPWR _06270_ sky130_fd_sc_hd__mux4_1
XTAP_1083 VGND VPWR sky130_fd_sc_hd__tapvpwrvgnd_1
XTAP_1061 VGND VPWR sky130_fd_sc_hd__tapvpwrvgnd_1
XTAP_1072 VGND VPWR sky130_fd_sc_hd__tapvpwrvgnd_1
XTAP_1050 VGND VPWR sky130_fd_sc_hd__tapvpwrvgnd_1
XTAP_1094 VGND VPWR sky130_fd_sc_hd__tapvpwrvgnd_1
X_12667_ net1659 VGND VGND VPWR VPWR _06216_ sky130_fd_sc_hd__inv_2
X_15455_ clknet_leaf_122_clk _00105_ VGND VGND VPWR VPWR cpuregs\[12\]\[5\] sky130_fd_sc_hd__dfxtp_1
X_14406_ _05029_ net1607 _01562_ VGND VGND VPWR VPWR _01564_ sky130_fd_sc_hd__mux2_1
X_11618_ _05012_ net1206 _05422_ VGND VGND VPWR VPWR _05426_ sky130_fd_sc_hd__mux2_1
X_15386_ clknet_leaf_122_clk _00041_ VGND VGND VPWR VPWR cpuregs\[11\]\[4\] sky130_fd_sc_hd__dfxtp_1
XFILLER_0_25_433 VGND VGND VPWR VPWR sky130_fd_sc_hd__fill_1
X_14337_ decoded_imm\[10\] _07459_ _07601_ VGND VGND VPWR VPWR _01019_ sky130_fd_sc_hd__o21a_1
X_12598_ _06167_ VGND VGND VPWR VPWR _00735_ sky130_fd_sc_hd__clkbuf_1
X_11549_ _05389_ VGND VGND VPWR VPWR _00464_ sky130_fd_sc_hd__clkbuf_1
Xhold518 cpuregs\[15\]\[10\] VGND VGND VPWR VPWR net876 sky130_fd_sc_hd__dlygate4sd3_1
Xhold507 cpuregs\[27\]\[8\] VGND VGND VPWR VPWR net865 sky130_fd_sc_hd__dlygate4sd3_1
Xhold529 cpuregs\[15\]\[23\] VGND VGND VPWR VPWR net887 sky130_fd_sc_hd__dlygate4sd3_1
Xmax_cap237 net1666 VGND VGND VPWR VPWR net237 sky130_fd_sc_hd__clkbuf_2
X_14268_ _02148_ _07560_ VGND VGND VPWR VPWR _07561_ sky130_fd_sc_hd__nor2_1
X_16007_ clknet_leaf_30_clk _00657_ VGND VGND VPWR VPWR reg_pc\[13\] sky130_fd_sc_hd__dfxtp_2
X_13219_ _06639_ _06704_ VGND VGND VPWR VPWR _06705_ sky130_fd_sc_hd__and2_1
X_14199_ net487 net251 _07519_ VGND VGND VPWR VPWR _07524_ sky130_fd_sc_hd__mux2_1
XFILLER_0_20_160 VGND VGND VPWR VPWR sky130_fd_sc_hd__fill_2
XTAP_801 VGND VPWR sky130_fd_sc_hd__tapvpwrvgnd_1
XFILLER_0_57_21 VGND VGND VPWR VPWR sky130_fd_sc_hd__decap_8
XFILLER_0_20_182 VGND VGND VPWR VPWR sky130_fd_sc_hd__decap_3
XTAP_812 VGND VPWR sky130_fd_sc_hd__tapvpwrvgnd_1
XTAP_823 VGND VPWR sky130_fd_sc_hd__tapvpwrvgnd_1
XTAP_834 VGND VPWR sky130_fd_sc_hd__tapvpwrvgnd_1
Xhold1207 cpuregs\[29\]\[15\] VGND VGND VPWR VPWR net1565 sky130_fd_sc_hd__dlygate4sd3_1
XTAP_845 VGND VPWR sky130_fd_sc_hd__tapvpwrvgnd_1
XTAP_856 VGND VPWR sky130_fd_sc_hd__tapvpwrvgnd_1
XTAP_867 VGND VPWR sky130_fd_sc_hd__tapvpwrvgnd_1
Xhold1229 cpuregs\[31\]\[23\] VGND VGND VPWR VPWR net1587 sky130_fd_sc_hd__dlygate4sd3_1
X_08760_ _02933_ _02979_ VGND VGND VPWR VPWR _03117_ sky130_fd_sc_hd__nand2_1
Xhold1218 cpuregs\[22\]\[8\] VGND VGND VPWR VPWR net1576 sky130_fd_sc_hd__dlygate4sd3_1
XFILLER_0_32_7 VGND VGND VPWR VPWR sky130_fd_sc_hd__fill_1
XTAP_878 VGND VPWR sky130_fd_sc_hd__tapvpwrvgnd_1
XTAP_889 VGND VPWR sky130_fd_sc_hd__tapvpwrvgnd_1
X_16909_ clknet_leaf_71_clk _01473_ VGND VGND VPWR VPWR cpuregs\[8\]\[28\] sky130_fd_sc_hd__dfxtp_1
X_08691_ _02493_ net213 _02942_ _03031_ VGND VGND VPWR VPWR _03053_ sky130_fd_sc_hd__a31o_1
XFILLER_0_73_31 VGND VGND VPWR VPWR sky130_fd_sc_hd__decap_4
X_07711_ mem_do_wdata mem_do_rdata _02136_ VGND VGND VPWR VPWR _02137_ sky130_fd_sc_hd__o21a_1
XFILLER_0_25_6 VPWR VGND VPWR VGND sky130_ef_sc_hd__decap_12
XFILLER_0_94_108 VGND VGND VPWR VPWR sky130_fd_sc_hd__fill_2
XFILLER_0_73_86 VGND VGND VPWR VPWR sky130_fd_sc_hd__fill_1
X_09312_ reg_pc\[18\] _03554_ _03459_ VGND VGND VPWR VPWR _03562_ sky130_fd_sc_hd__o21a_1
XFILLER_0_87_193 VPWR VGND VPWR VGND sky130_ef_sc_hd__decap_12
XFILLER_0_91_815 VGND VGND VPWR VPWR sky130_fd_sc_hd__fill_1
X_09243_ reg_out\[9\] alu_out_q\[9\] _03435_ VGND VGND VPWR VPWR _03502_ sky130_fd_sc_hd__mux2_1
XFILLER_0_29_783 VGND VGND VPWR VPWR sky130_fd_sc_hd__fill_1
X_09174_ latched_branch latched_store _02109_ VGND VGND VPWR VPWR _03442_ sky130_fd_sc_hd__o21ai_4
X_08125_ reg_pc\[21\] decoded_imm\[21\] VGND VGND VPWR VPWR _02517_ sky130_fd_sc_hd__nor2_1
XFILLER_0_71_561 VGND VGND VPWR VPWR sky130_fd_sc_hd__decap_3
XFILLER_0_16_488 VGND VGND VPWR VPWR sky130_fd_sc_hd__decap_3
X_08056_ net407 _02232_ _02452_ VGND VGND VPWR VPWR _02453_ sky130_fd_sc_hd__a21oi_2
Xoutput38 net38 VGND VGND VPWR VPWR mem_addr[13] sky130_fd_sc_hd__clkbuf_4
Xoutput49 net49 VGND VGND VPWR VPWR mem_addr[24] sky130_fd_sc_hd__clkbuf_4
Xpicorv32_260 VGND VGND VPWR VPWR picorv32_260/HI eoi[7] sky130_fd_sc_hd__conb_1
Xpicorv32_271 VGND VGND VPWR VPWR picorv32_271/HI eoi[18] sky130_fd_sc_hd__conb_1
Xpicorv32_293 VGND VGND VPWR VPWR picorv32_293/HI pcpi_insn[4] sky130_fd_sc_hd__conb_1
Xpicorv32_282 VGND VGND VPWR VPWR picorv32_282/HI eoi[29] sky130_fd_sc_hd__conb_1
X_08958_ reg_out\[19\] reg_next_pc\[19\] _03248_ VGND VGND VPWR VPWR _03263_ sky130_fd_sc_hd__mux2_1
X_08889_ net126 net218 _02209_ VGND VGND VPWR VPWR _03220_ sky130_fd_sc_hd__mux2_1
X_07909_ _02302_ _02315_ VGND VGND VPWR VPWR _07646_ sky130_fd_sc_hd__nor2_1
X_10920_ _05036_ VGND VGND VPWR VPWR _00188_ sky130_fd_sc_hd__clkbuf_1
XPHY_100 VGND VGND VPWR VPWR sky130_fd_sc_hd__decap_3
X_10851_ _04989_ net1227 _04985_ VGND VGND VPWR VPWR _04990_ sky130_fd_sc_hd__mux2_1
X_13570_ _07013_ _07045_ VGND VGND VPWR VPWR _07046_ sky130_fd_sc_hd__and2_1
XFILLER_0_94_642 VGND VGND VPWR VPWR sky130_fd_sc_hd__fill_2
XPHY_133 VGND VGND VPWR VPWR sky130_fd_sc_hd__decap_3
XPHY_122 VGND VGND VPWR VPWR sky130_fd_sc_hd__decap_3
XPHY_111 VGND VGND VPWR VPWR sky130_fd_sc_hd__decap_3
X_10782_ net1238 _03472_ _04946_ VGND VGND VPWR VPWR _04951_ sky130_fd_sc_hd__mux2_1
XFILLER_0_93_163 VGND VGND VPWR VPWR sky130_fd_sc_hd__decap_4
XPHY_166 VGND VGND VPWR VPWR sky130_fd_sc_hd__decap_3
XPHY_155 VGND VGND VPWR VPWR sky130_fd_sc_hd__decap_3
XPHY_144 VGND VGND VPWR VPWR sky130_fd_sc_hd__decap_3
X_12521_ _06112_ VGND VGND VPWR VPWR _00713_ sky130_fd_sc_hd__clkbuf_1
X_12452_ _06004_ _05753_ VGND VGND VPWR VPWR _06055_ sky130_fd_sc_hd__and2_1
X_15240_ _02005_ VGND VGND VPWR VPWR _01474_ sky130_fd_sc_hd__clkbuf_1
XPHY_199 VGND VGND VPWR VPWR sky130_fd_sc_hd__decap_3
XPHY_188 VGND VGND VPWR VPWR sky130_fd_sc_hd__decap_3
XPHY_177 VGND VGND VPWR VPWR sky130_fd_sc_hd__decap_3
XFILLER_0_54_539 VGND VGND VPWR VPWR sky130_fd_sc_hd__decap_4
X_11403_ _05311_ VGND VGND VPWR VPWR _00396_ sky130_fd_sc_hd__clkbuf_1
X_15171_ net790 _03634_ _01959_ VGND VGND VPWR VPWR _01969_ sky130_fd_sc_hd__mux2_1
X_12383_ decoded_imm_j\[17\] _05728_ _05961_ _05991_ VGND VGND VPWR VPWR _05992_ sky130_fd_sc_hd__a31o_1
XFILLER_0_1_308 VGND VGND VPWR VPWR sky130_fd_sc_hd__fill_2
X_14122_ _07480_ VGND VGND VPWR VPWR _00925_ sky130_fd_sc_hd__clkbuf_1
X_11334_ _05001_ net1463 _05266_ VGND VGND VPWR VPWR _05275_ sky130_fd_sc_hd__mux2_1
X_11265_ net865 _05177_ _05229_ VGND VGND VPWR VPWR _05238_ sky130_fd_sc_hd__mux2_1
X_14053_ mem_rdata_q\[8\] net31 _07422_ VGND VGND VPWR VPWR _07443_ sky130_fd_sc_hd__mux2_1
X_10216_ _03656_ _04421_ _04434_ _03774_ reg_pc\[17\] VGND VGND VPWR VPWR _04435_
+ sky130_fd_sc_hd__a32o_1
X_13004_ _06459_ _06494_ _06496_ _03328_ VGND VGND VPWR VPWR _06497_ sky130_fd_sc_hd__a211o_1
XFILLER_0_118_15 VPWR VGND VPWR VGND sky130_ef_sc_hd__decap_12
XFILLER_0_94_19 VGND VGND VPWR VPWR sky130_fd_sc_hd__decap_8
X_11196_ _05193_ VGND VGND VPWR VPWR _00307_ sky130_fd_sc_hd__clkbuf_1
X_10147_ _04079_ _04109_ _04155_ _04361_ VGND VGND VPWR VPWR _04367_ sky130_fd_sc_hd__a211o_1
X_14955_ _03597_ net699 _01851_ VGND VGND VPWR VPWR _01855_ sky130_fd_sc_hd__mux2_1
XFILLER_0_89_403 VGND VGND VPWR VPWR sky130_fd_sc_hd__decap_3
X_10078_ _02366_ _02403_ _02480_ _02426_ _03364_ _03651_ VGND VGND VPWR VPWR _04300_
+ sky130_fd_sc_hd__mux4_1
XFILLER_0_27_57 VGND VGND VPWR VPWR sky130_fd_sc_hd__decap_4
XFILLER_0_89_436 VGND VGND VPWR VPWR sky130_fd_sc_hd__decap_8
XFILLER_0_27_79 VGND VGND VPWR VPWR sky130_fd_sc_hd__fill_2
X_13906_ _07352_ VGND VGND VPWR VPWR _00852_ sky130_fd_sc_hd__clkbuf_1
X_14886_ _01818_ VGND VGND VPWR VPWR _01307_ sky130_fd_sc_hd__clkbuf_1
XPHY_2 VGND VGND VPWR VPWR sky130_fd_sc_hd__decap_3
X_16625_ clknet_leaf_128_clk _01192_ VGND VGND VPWR VPWR cpuregs\[23\]\[3\] sky130_fd_sc_hd__dfxtp_1
X_13837_ instr_lh _07299_ _07300_ latched_is_lh VGND VGND VPWR VPWR _07301_ sky130_fd_sc_hd__a22o_1
X_13768_ cpuregs\[4\]\[30\] cpuregs\[5\]\[30\] _03329_ VGND VGND VPWR VPWR _07237_
+ sky130_fd_sc_hd__mux2_1
XFILLER_0_57_333 VGND VGND VPWR VPWR sky130_fd_sc_hd__decap_3
X_16556_ clknet_leaf_143_clk _01133_ VGND VGND VPWR VPWR cpuregs\[24\]\[8\] sky130_fd_sc_hd__dfxtp_1
X_15507_ clknet_leaf_67_clk _00157_ VGND VGND VPWR VPWR cpuregs\[30\]\[25\] sky130_fd_sc_hd__dfxtp_1
X_12719_ decoded_imm\[31\] _02653_ VGND VGND VPWR VPWR _06253_ sky130_fd_sc_hd__xnor2_1
Xclkbuf_0_clk clk VGND VGND VPWR VPWR clknet_0_clk sky130_fd_sc_hd__clkbuf_16
X_16487_ clknet_leaf_143_clk _01069_ VGND VGND VPWR VPWR cpuregs\[19\]\[8\] sky130_fd_sc_hd__dfxtp_1
XFILLER_0_127_265 VPWR VGND VPWR VGND sky130_ef_sc_hd__decap_12
X_13699_ _06415_ _07157_ _07170_ _02181_ decoded_imm\[27\] VGND VGND VPWR VPWR _07171_
+ sky130_fd_sc_hd__a32o_1
X_15438_ clknet_leaf_51_clk _00088_ VGND VGND VPWR VPWR net181 sky130_fd_sc_hd__dfxtp_4
XFILLER_0_115_449 VGND VGND VPWR VPWR sky130_fd_sc_hd__decap_4
XFILLER_0_53_561 VGND VGND VPWR VPWR sky130_fd_sc_hd__fill_2
XFILLER_0_5_647 VGND VGND VPWR VPWR sky130_fd_sc_hd__fill_1
X_15369_ _03629_ net1026 _02063_ VGND VGND VPWR VPWR _02072_ sky130_fd_sc_hd__mux2_1
XFILLER_0_130_419 VGND VGND VPWR VPWR sky130_fd_sc_hd__fill_1
Xhold326 cpuregs\[27\]\[21\] VGND VGND VPWR VPWR net684 sky130_fd_sc_hd__dlygate4sd3_1
XFILLER_0_123_471 VGND VGND VPWR VPWR sky130_fd_sc_hd__decap_6
Xhold315 cpuregs\[26\]\[13\] VGND VGND VPWR VPWR net673 sky130_fd_sc_hd__dlygate4sd3_1
Xhold304 cpuregs\[12\]\[10\] VGND VGND VPWR VPWR net662 sky130_fd_sc_hd__dlygate4sd3_1
XFILLER_0_7_12 VGND VGND VPWR VPWR sky130_fd_sc_hd__fill_1
XFILLER_0_40_244 VGND VGND VPWR VPWR sky130_fd_sc_hd__fill_2
Xhold359 cpuregs\[22\]\[30\] VGND VGND VPWR VPWR net717 sky130_fd_sc_hd__dlygate4sd3_1
Xhold348 cpuregs\[28\]\[30\] VGND VGND VPWR VPWR net706 sky130_fd_sc_hd__dlygate4sd3_1
X_09930_ _04155_ _04112_ _04109_ VGND VGND VPWR VPWR _04156_ sky130_fd_sc_hd__o21a_1
XFILLER_0_7_78 VGND VGND VPWR VPWR sky130_fd_sc_hd__fill_2
Xhold337 cpuregs\[23\]\[3\] VGND VGND VPWR VPWR net695 sky130_fd_sc_hd__dlygate4sd3_1
XFILLER_0_0_341 VGND VGND VPWR VPWR sky130_fd_sc_hd__fill_1
XTAP_620 VGND VPWR sky130_fd_sc_hd__tapvpwrvgnd_1
XTAP_631 VGND VPWR sky130_fd_sc_hd__tapvpwrvgnd_1
XTAP_642 VGND VPWR sky130_fd_sc_hd__tapvpwrvgnd_1
X_09861_ _03663_ _04084_ _04088_ _03685_ VGND VGND VPWR VPWR _04089_ sky130_fd_sc_hd__o211a_1
X_08812_ _02733_ _03156_ _03165_ _03020_ VGND VGND VPWR VPWR alu_out\[27\] sky130_fd_sc_hd__a22o_1
Xhold1004 cpuregs\[22\]\[17\] VGND VGND VPWR VPWR net1362 sky130_fd_sc_hd__dlygate4sd3_1
Xhold1015 cpuregs\[13\]\[0\] VGND VGND VPWR VPWR net1373 sky130_fd_sc_hd__dlygate4sd3_1
XTAP_653 VGND VPWR sky130_fd_sc_hd__tapvpwrvgnd_1
X_09792_ _03720_ _04018_ _04021_ VGND VGND VPWR VPWR _04022_ sky130_fd_sc_hd__a21o_1
XTAP_664 VGND VPWR sky130_fd_sc_hd__tapvpwrvgnd_1
XTAP_675 VGND VPWR sky130_fd_sc_hd__tapvpwrvgnd_1
XTAP_686 VGND VPWR sky130_fd_sc_hd__tapvpwrvgnd_1
X_08743_ _02699_ _02986_ _03100_ VGND VGND VPWR VPWR _03101_ sky130_fd_sc_hd__a21o_1
Xhold1037 cpuregs\[13\]\[22\] VGND VGND VPWR VPWR net1395 sky130_fd_sc_hd__dlygate4sd3_1
Xhold1048 cpuregs\[13\]\[8\] VGND VGND VPWR VPWR net1406 sky130_fd_sc_hd__dlygate4sd3_1
XTAP_697 VGND VPWR sky130_fd_sc_hd__tapvpwrvgnd_1
Xhold1026 cpuregs\[3\]\[7\] VGND VGND VPWR VPWR net1384 sky130_fd_sc_hd__dlygate4sd3_1
Xhold1059 cpuregs\[5\]\[20\] VGND VGND VPWR VPWR net1417 sky130_fd_sc_hd__dlygate4sd3_1
XFILLER_0_84_85 VGND VGND VPWR VPWR sky130_fd_sc_hd__fill_1
XFILLER_0_23_3 VPWR VGND VPWR VGND sky130_ef_sc_hd__decap_12
X_08674_ _03036_ _03037_ VGND VGND VPWR VPWR _03038_ sky130_fd_sc_hd__nor2_1
XTAP_1819 VGND VPWR sky130_fd_sc_hd__tapvpwrvgnd_1
XTAP_1808 VGND VPWR sky130_fd_sc_hd__tapvpwrvgnd_1
XFILLER_0_119_700 VGND VGND VPWR VPWR sky130_fd_sc_hd__decap_3
XFILLER_0_75_130 VGND VGND VPWR VPWR sky130_fd_sc_hd__decap_4
XFILLER_0_119_733 VGND VGND VPWR VPWR sky130_fd_sc_hd__fill_1
XFILLER_0_118_232 VGND VGND VPWR VPWR sky130_fd_sc_hd__decap_6
XFILLER_0_76_686 VGND VGND VPWR VPWR sky130_fd_sc_hd__fill_1
XFILLER_0_91_645 VGND VGND VPWR VPWR sky130_fd_sc_hd__fill_1
X_09226_ reg_pc\[7\] reg_pc\[6\] _03474_ VGND VGND VPWR VPWR _03487_ sky130_fd_sc_hd__and3_1
XFILLER_0_106_438 VGND VGND VPWR VPWR sky130_fd_sc_hd__fill_1
XFILLER_0_106_416 VGND VGND VPWR VPWR sky130_fd_sc_hd__fill_1
XFILLER_0_17_797 VGND VGND VPWR VPWR sky130_fd_sc_hd__decap_4
XFILLER_0_32_734 VGND VGND VPWR VPWR sky130_fd_sc_hd__fill_2
X_09157_ decoded_imm_j\[3\] _01116_ _03296_ VGND VGND VPWR VPWR _03428_ sky130_fd_sc_hd__mux2_1
XFILLER_0_114_471 VGND VGND VPWR VPWR sky130_fd_sc_hd__decap_4
X_08108_ _02475_ _02499_ _02488_ _02500_ VGND VGND VPWR VPWR _02501_ sky130_fd_sc_hd__o211a_1
XFILLER_0_71_391 VGND VGND VPWR VPWR sky130_fd_sc_hd__fill_1
X_09088_ cpuregs\[4\]\[3\] cpuregs\[5\]\[3\] cpuregs\[6\]\[3\] cpuregs\[7\]\[3\] _03336_
+ _03337_ VGND VGND VPWR VPWR _03368_ sky130_fd_sc_hd__mux4_1
XFILLER_0_31_222 VGND VGND VPWR VPWR sky130_fd_sc_hd__fill_2
X_08039_ reg_pc\[15\] decoded_imm\[15\] decoded_imm\[14\] reg_pc\[14\] VGND VGND VPWR
+ VPWR _02436_ sky130_fd_sc_hd__o211a_1
Xhold882 cpuregs\[7\]\[26\] VGND VGND VPWR VPWR net1240 sky130_fd_sc_hd__dlygate4sd3_1
Xhold871 cpuregs\[31\]\[24\] VGND VGND VPWR VPWR net1229 sky130_fd_sc_hd__dlygate4sd3_1
Xhold860 cpuregs\[22\]\[10\] VGND VGND VPWR VPWR net1218 sky130_fd_sc_hd__dlygate4sd3_1
X_11050_ _05108_ VGND VGND VPWR VPWR _00246_ sky130_fd_sc_hd__clkbuf_1
Xhold893 cpuregs\[3\]\[31\] VGND VGND VPWR VPWR net1251 sky130_fd_sc_hd__dlygate4sd3_1
X_10001_ decoded_imm\[12\] net174 VGND VGND VPWR VPWR _04225_ sky130_fd_sc_hd__or2_1
XFILLER_0_98_222 VGND VGND VPWR VPWR sky130_fd_sc_hd__decap_3
X_14740_ _01740_ VGND VGND VPWR VPWR _01239_ sky130_fd_sc_hd__clkbuf_1
X_11952_ count_instr\[42\] count_instr\[41\] _05628_ VGND VGND VPWR VPWR _05634_ sky130_fd_sc_hd__and3_1
X_14671_ net1019 _05198_ _01695_ VGND VGND VPWR VPWR _01704_ sky130_fd_sc_hd__mux2_1
XFILLER_0_86_417 VGND VGND VPWR VPWR sky130_fd_sc_hd__decap_3
X_10903_ _05024_ net908 _05006_ VGND VGND VPWR VPWR _05025_ sky130_fd_sc_hd__mux2_1
X_11883_ count_instr\[23\] count_instr\[22\] count_instr\[21\] _05575_ VGND VGND VPWR
+ VPWR _05584_ sky130_fd_sc_hd__and4_1
X_13622_ cpuregs\[0\]\[25\] cpuregs\[1\]\[25\] cpuregs\[2\]\[25\] cpuregs\[3\]\[25\]
+ _06344_ _06345_ VGND VGND VPWR VPWR _07096_ sky130_fd_sc_hd__mux4_1
X_10834_ net675 _03635_ _04968_ VGND VGND VPWR VPWR _04978_ sky130_fd_sc_hd__mux2_1
XFILLER_0_39_322 VGND VGND VPWR VPWR sky130_fd_sc_hd__decap_3
X_16410_ clknet_leaf_139_clk _00992_ VGND VGND VPWR VPWR latched_rd\[1\] sky130_fd_sc_hd__dfxtp_1
X_13553_ cpuregs\[8\]\[23\] cpuregs\[9\]\[23\] _06764_ VGND VGND VPWR VPWR _07029_
+ sky130_fd_sc_hd__mux2_1
X_16341_ clknet_leaf_115_clk _00923_ VGND VGND VPWR VPWR cpuregs\[1\]\[6\] sky130_fd_sc_hd__dfxtp_1
X_10765_ net678 _03641_ _04906_ VGND VGND VPWR VPWR _04940_ sky130_fd_sc_hd__mux2_1
XFILLER_0_66_185 VGND VGND VPWR VPWR sky130_fd_sc_hd__fill_2
X_12504_ net399 net415 _06100_ VGND VGND VPWR VPWR _00708_ sky130_fd_sc_hd__o21a_1
XFILLER_0_124_224 VPWR VGND VPWR VGND sky130_ef_sc_hd__decap_12
XFILLER_0_124_213 VGND VGND VPWR VPWR sky130_fd_sc_hd__fill_1
X_13484_ _00011_ VGND VGND VPWR VPWR _06962_ sky130_fd_sc_hd__buf_2
XFILLER_0_89_19 VGND VGND VPWR VPWR sky130_fd_sc_hd__fill_1
X_10696_ latched_rd\[2\] VGND VGND VPWR VPWR _04901_ sky130_fd_sc_hd__buf_4
X_16272_ clknet_leaf_4_clk net387 VGND VGND VPWR VPWR instr_lbu sky130_fd_sc_hd__dfxtp_1
X_12435_ _06004_ _05749_ VGND VGND VPWR VPWR _06040_ sky130_fd_sc_hd__nor2_1
X_15223_ _03584_ net1380 _01995_ VGND VGND VPWR VPWR _01997_ sky130_fd_sc_hd__mux2_1
X_15154_ _01960_ VGND VGND VPWR VPWR _01433_ sky130_fd_sc_hd__clkbuf_1
X_12366_ _05785_ _05734_ _05976_ _02166_ VGND VGND VPWR VPWR _05977_ sky130_fd_sc_hd__a22o_1
XFILLER_0_1_105 VGND VGND VPWR VPWR sky130_fd_sc_hd__fill_1
XFILLER_0_50_586 VGND VGND VPWR VPWR sky130_fd_sc_hd__fill_2
X_11317_ _05265_ VGND VGND VPWR VPWR _05266_ sky130_fd_sc_hd__buf_4
X_14105_ _04981_ net1525 _07471_ VGND VGND VPWR VPWR _07472_ sky130_fd_sc_hd__mux2_1
X_15085_ net1376 _05202_ _01923_ VGND VGND VPWR VPWR _01924_ sky130_fd_sc_hd__mux2_1
X_12297_ _05737_ reg_next_pc\[13\] VGND VGND VPWR VPWR _05914_ sky130_fd_sc_hd__or2_1
X_14036_ _07434_ VGND VGND VPWR VPWR _00891_ sky130_fd_sc_hd__clkbuf_1
X_11248_ _05228_ VGND VGND VPWR VPWR _05229_ sky130_fd_sc_hd__buf_4
X_11179_ _05160_ VGND VGND VPWR VPWR _05182_ sky130_fd_sc_hd__buf_4
XFILLER_0_38_56 VGND VGND VPWR VPWR sky130_fd_sc_hd__fill_1
X_15987_ clknet_leaf_153_clk _00637_ VGND VGND VPWR VPWR count_instr\[56\] sky130_fd_sc_hd__dfxtp_1
X_14938_ _03544_ net1531 _01840_ VGND VGND VPWR VPWR _01846_ sky130_fd_sc_hd__mux2_1
X_14869_ _01809_ VGND VGND VPWR VPWR _01299_ sky130_fd_sc_hd__clkbuf_1
X_08390_ net217 VGND VGND VPWR VPWR _02771_ sky130_fd_sc_hd__inv_2
X_16608_ clknet_leaf_84_clk _01175_ VGND VGND VPWR VPWR cpuregs\[9\]\[18\] sky130_fd_sc_hd__dfxtp_1
XFILLER_0_45_303 VGND VGND VPWR VPWR sky130_fd_sc_hd__fill_1
XFILLER_0_128_541 VGND VGND VPWR VPWR sky130_fd_sc_hd__fill_1
X_16539_ clknet_leaf_14_clk _01116_ VGND VGND VPWR VPWR mem_rdata_q\[23\] sky130_fd_sc_hd__dfxtp_1
XFILLER_0_116_747 VGND VGND VPWR VPWR sky130_fd_sc_hd__decap_8
XFILLER_0_116_736 VGND VGND VPWR VPWR sky130_fd_sc_hd__fill_2
XFILLER_0_115_246 VGND VGND VPWR VPWR sky130_fd_sc_hd__fill_1
X_09011_ _03299_ VGND VGND VPWR VPWR _00033_ sky130_fd_sc_hd__clkbuf_1
XFILLER_0_14_701 VGND VGND VPWR VPWR sky130_fd_sc_hd__fill_2
XFILLER_0_26_583 VGND VGND VPWR VPWR sky130_fd_sc_hd__decap_4
XFILLER_0_130_216 VGND VGND VPWR VPWR sky130_fd_sc_hd__decap_3
Xhold101 cpuregs\[0\]\[19\] VGND VGND VPWR VPWR net459 sky130_fd_sc_hd__dlygate4sd3_1
Xhold134 cpuregs\[0\]\[27\] VGND VGND VPWR VPWR net492 sky130_fd_sc_hd__dlygate4sd3_1
XFILLER_0_13_244 VGND VGND VPWR VPWR sky130_fd_sc_hd__decap_8
Xhold112 instr_sw VGND VGND VPWR VPWR net470 sky130_fd_sc_hd__dlygate4sd3_1
Xhold123 _00856_ VGND VGND VPWR VPWR net481 sky130_fd_sc_hd__dlygate4sd3_1
Xhold167 net138 VGND VGND VPWR VPWR net525 sky130_fd_sc_hd__dlygate4sd3_1
Xhold156 net160 VGND VGND VPWR VPWR net514 sky130_fd_sc_hd__dlygate4sd3_1
Xhold145 net162 VGND VGND VPWR VPWR net503 sky130_fd_sc_hd__dlygate4sd3_1
XFILLER_0_1_650 VGND VGND VPWR VPWR sky130_fd_sc_hd__fill_1
Xhold178 net57 VGND VGND VPWR VPWR net536 sky130_fd_sc_hd__dlygate4sd3_1
Xhold189 net46 VGND VGND VPWR VPWR net547 sky130_fd_sc_hd__dlygate4sd3_1
XFILLER_0_0_160 VGND VGND VPWR VPWR sky130_fd_sc_hd__decap_8
X_09913_ cpuregs\[24\]\[9\] cpuregs\[25\]\[9\] cpuregs\[26\]\[9\] cpuregs\[27\]\[9\]
+ _03831_ _03832_ VGND VGND VPWR VPWR _04140_ sky130_fd_sc_hd__mux4_1
X_09844_ _04068_ _04069_ _04072_ _02152_ VGND VGND VPWR VPWR _04073_ sky130_fd_sc_hd__a31o_1
XTAP_450 VGND VPWR sky130_fd_sc_hd__tapvpwrvgnd_1
XTAP_461 VGND VPWR sky130_fd_sc_hd__tapvpwrvgnd_1
XTAP_472 VGND VPWR sky130_fd_sc_hd__tapvpwrvgnd_1
XTAP_483 VGND VPWR sky130_fd_sc_hd__tapvpwrvgnd_1
XTAP_494 VGND VPWR sky130_fd_sc_hd__tapvpwrvgnd_1
X_09775_ _04004_ _03954_ _03955_ VGND VGND VPWR VPWR _04005_ sky130_fd_sc_hd__o21a_1
XTAP_2306 VGND VPWR sky130_fd_sc_hd__tapvpwrvgnd_1
XTAP_2317 VGND VPWR sky130_fd_sc_hd__tapvpwrvgnd_1
X_08726_ net216 net215 VGND VGND VPWR VPWR _03085_ sky130_fd_sc_hd__nor2_1
XFILLER_0_96_704 VGND VGND VPWR VPWR sky130_fd_sc_hd__decap_8
XTAP_2339 VGND VPWR sky130_fd_sc_hd__tapvpwrvgnd_1
XTAP_2328 VGND VPWR sky130_fd_sc_hd__tapvpwrvgnd_1
X_08657_ net209 net208 _02998_ VGND VGND VPWR VPWR _03022_ sky130_fd_sc_hd__or3_2
XTAP_1605 VGND VPWR sky130_fd_sc_hd__tapvpwrvgnd_1
XFILLER_0_95_225 VGND VGND VPWR VPWR sky130_fd_sc_hd__decap_3
XTAP_1638 VGND VPWR sky130_fd_sc_hd__tapvpwrvgnd_1
XTAP_1649 VGND VPWR sky130_fd_sc_hd__tapvpwrvgnd_1
XTAP_1627 VGND VPWR sky130_fd_sc_hd__tapvpwrvgnd_1
XTAP_1616 VGND VPWR sky130_fd_sc_hd__tapvpwrvgnd_1
XFILLER_0_49_631 VGND VGND VPWR VPWR sky130_fd_sc_hd__fill_2
X_08588_ _02948_ _02950_ _02947_ VGND VGND VPWR VPWR _02959_ sky130_fd_sc_hd__a21bo_1
XFILLER_0_37_826 VGND VGND VPWR VPWR sky130_fd_sc_hd__fill_2
X_10550_ cpuregs\[12\]\[27\] cpuregs\[13\]\[27\] _03749_ VGND VGND VPWR VPWR _04759_
+ sky130_fd_sc_hd__mux2_1
XFILLER_0_119_585 VGND VGND VPWR VPWR sky130_fd_sc_hd__fill_2
XFILLER_0_63_155 VGND VGND VPWR VPWR sky130_fd_sc_hd__fill_2
X_10481_ cpuregs\[14\]\[25\] cpuregs\[15\]\[25\] _03835_ VGND VGND VPWR VPWR _04692_
+ sky130_fd_sc_hd__mux2_1
XFILLER_0_91_486 VGND VGND VPWR VPWR sky130_fd_sc_hd__fill_2
XFILLER_0_64_689 VGND VGND VPWR VPWR sky130_fd_sc_hd__fill_2
XFILLER_0_63_166 VGND VGND VPWR VPWR sky130_fd_sc_hd__fill_2
XFILLER_0_51_306 VGND VGND VPWR VPWR sky130_fd_sc_hd__decap_4
X_09209_ net1328 _03472_ _03446_ VGND VGND VPWR VPWR _03473_ sky130_fd_sc_hd__mux2_1
XFILLER_0_122_728 VGND VGND VPWR VPWR sky130_fd_sc_hd__fill_1
X_12220_ _05840_ _05841_ VGND VGND VPWR VPWR _05842_ sky130_fd_sc_hd__nor2_1
XFILLER_0_32_531 VGND VGND VPWR VPWR sky130_fd_sc_hd__fill_1
XFILLER_0_32_542 VGND VGND VPWR VPWR sky130_fd_sc_hd__fill_2
X_12151_ decoded_imm_j\[3\] _05698_ VGND VGND VPWR VPWR _05778_ sky130_fd_sc_hd__nand2_1
X_12082_ _05686_ _05726_ VGND VGND VPWR VPWR _05727_ sky130_fd_sc_hd__or2_1
Xhold690 cpuregs\[11\]\[30\] VGND VGND VPWR VPWR net1048 sky130_fd_sc_hd__dlygate4sd3_1
X_11102_ _05136_ VGND VGND VPWR VPWR _00270_ sky130_fd_sc_hd__clkbuf_1
X_15910_ clknet_leaf_136_clk _00560_ VGND VGND VPWR VPWR cpuregs\[17\]\[12\] sky130_fd_sc_hd__dfxtp_1
X_11033_ net638 _03511_ _05099_ VGND VGND VPWR VPWR _05100_ sky130_fd_sc_hd__mux2_1
X_16890_ clknet_leaf_109_clk _01454_ VGND VGND VPWR VPWR cpuregs\[8\]\[9\] sky130_fd_sc_hd__dfxtp_1
X_15841_ clknet_leaf_129_clk _00491_ VGND VGND VPWR VPWR cpuregs\[25\]\[7\] sky130_fd_sc_hd__dfxtp_1
XFILLER_0_99_542 VGND VGND VPWR VPWR sky130_fd_sc_hd__fill_2
X_12984_ _06421_ _06474_ _06476_ VGND VGND VPWR VPWR _06477_ sky130_fd_sc_hd__a21o_1
X_15772_ clknet_leaf_133_clk _00422_ VGND VGND VPWR VPWR cpuregs\[26\]\[2\] sky130_fd_sc_hd__dfxtp_1
XFILLER_0_86_214 VGND VGND VPWR VPWR sky130_fd_sc_hd__decap_6
X_14723_ _05005_ net1505 _01731_ VGND VGND VPWR VPWR _01732_ sky130_fd_sc_hd__mux2_1
X_11935_ _05619_ _05620_ _05621_ VGND VGND VPWR VPWR _05622_ sky130_fd_sc_hd__and3b_1
X_14654_ _01683_ VGND VGND VPWR VPWR _01695_ sky130_fd_sc_hd__buf_4
XFILLER_0_86_236 VGND VGND VPWR VPWR sky130_fd_sc_hd__decap_4
XFILLER_0_129_327 VGND VGND VPWR VPWR sky130_fd_sc_hd__fill_1
X_13605_ _06794_ _07079_ VGND VGND VPWR VPWR _07080_ sky130_fd_sc_hd__and2_1
X_11866_ net471 _05567_ _05571_ VGND VGND VPWR VPWR _00599_ sky130_fd_sc_hd__o21a_1
X_10817_ _04969_ VGND VGND VPWR VPWR _00152_ sky130_fd_sc_hd__clkbuf_1
X_14585_ _01658_ VGND VGND VPWR VPWR _01166_ sky130_fd_sc_hd__clkbuf_1
X_11797_ _05519_ count_instr\[0\] _05520_ VGND VGND VPWR VPWR _05521_ sky130_fd_sc_hd__and3_1
X_10748_ _04931_ VGND VGND VPWR VPWR _00121_ sky130_fd_sc_hd__clkbuf_1
X_13536_ _06387_ VGND VGND VPWR VPWR _07013_ sky130_fd_sc_hd__clkbuf_4
XFILLER_0_15_509 VGND VGND VPWR VPWR sky130_fd_sc_hd__fill_1
X_16324_ clknet_leaf_14_clk _00909_ VGND VGND VPWR VPWR decoded_imm_j\[3\] sky130_fd_sc_hd__dfxtp_2
XFILLER_0_137_393 VGND VGND VPWR VPWR sky130_fd_sc_hd__fill_2
X_16255_ clknet_leaf_38_clk alu_out\[28\] VGND VGND VPWR VPWR alu_out_q\[28\] sky130_fd_sc_hd__dfxtp_1
XFILLER_0_125_555 VGND VGND VPWR VPWR sky130_fd_sc_hd__decap_4
X_13467_ cpuregs\[16\]\[20\] cpuregs\[17\]\[20\] cpuregs\[18\]\[20\] cpuregs\[19\]\[20\]
+ _06945_ _06648_ VGND VGND VPWR VPWR _06946_ sky130_fd_sc_hd__mux4_1
XFILLER_0_54_188 VGND VGND VPWR VPWR sky130_fd_sc_hd__fill_1
XFILLER_0_42_306 VGND VGND VPWR VPWR sky130_fd_sc_hd__fill_2
X_12418_ _05763_ net528 _06020_ _06024_ _05697_ VGND VGND VPWR VPWR _00698_ sky130_fd_sc_hd__o221a_1
X_10679_ cpuregs\[2\]\[30\] cpuregs\[3\]\[30\] _03898_ VGND VGND VPWR VPWR _04885_
+ sky130_fd_sc_hd__mux2_1
X_15206_ _03532_ net1113 _01984_ VGND VGND VPWR VPWR _01988_ sky130_fd_sc_hd__mux2_1
XFILLER_0_140_558 VGND VGND VPWR VPWR sky130_fd_sc_hd__fill_2
Xoutput217 net217 VGND VGND VPWR VPWR pcpi_rs2[22] sky130_fd_sc_hd__clkbuf_4
Xoutput206 net206 VGND VGND VPWR VPWR pcpi_rs2[12] sky130_fd_sc_hd__clkbuf_4
X_13398_ cpuregs\[0\]\[18\] cpuregs\[1\]\[18\] cpuregs\[2\]\[18\] cpuregs\[3\]\[18\]
+ _06740_ _06708_ VGND VGND VPWR VPWR _06879_ sky130_fd_sc_hd__mux4_1
XFILLER_0_2_436 VGND VGND VPWR VPWR sky130_fd_sc_hd__fill_1
X_16186_ clknet_leaf_4_clk _00804_ VGND VGND VPWR VPWR mem_do_rdata sky130_fd_sc_hd__dfxtp_2
X_12349_ decoded_imm_j\[18\] _05731_ VGND VGND VPWR VPWR _05961_ sky130_fd_sc_hd__or2_1
Xoutput228 net228 VGND VGND VPWR VPWR pcpi_rs2[3] sky130_fd_sc_hd__clkbuf_4
X_15137_ _01951_ VGND VGND VPWR VPWR _01425_ sky130_fd_sc_hd__clkbuf_1
X_15068_ net734 _05186_ _01912_ VGND VGND VPWR VPWR _01915_ sky130_fd_sc_hd__mux2_1
X_14019_ decoded_imm_j\[6\] _01119_ _03430_ VGND VGND VPWR VPWR _07426_ sky130_fd_sc_hd__mux2_1
X_07890_ _02242_ _02294_ _02297_ _02194_ _02199_ VGND VGND VPWR VPWR _02298_ sky130_fd_sc_hd__a221o_1
XFILLER_0_65_43 VPWR VGND VPWR VGND sky130_ef_sc_hd__decap_12
XFILLER_0_4_68 VGND VGND VPWR VPWR sky130_fd_sc_hd__fill_1
X_09560_ _03656_ VGND VGND VPWR VPWR _03794_ sky130_fd_sc_hd__clkbuf_4
X_08511_ _02280_ _02886_ VGND VGND VPWR VPWR _02888_ sky130_fd_sc_hd__and2_1
X_09491_ _03668_ VGND VGND VPWR VPWR _03726_ sky130_fd_sc_hd__clkbuf_8
X_08442_ net192 _02812_ _02739_ _02820_ _02822_ VGND VGND VPWR VPWR _02823_ sky130_fd_sc_hd__o221a_1
XFILLER_0_77_225 VPWR VGND VPWR VGND sky130_ef_sc_hd__decap_12
X_08373_ net196 _02753_ VGND VGND VPWR VPWR _02754_ sky130_fd_sc_hd__xnor2_1
XFILLER_0_46_623 VGND VGND VPWR VPWR sky130_fd_sc_hd__fill_1
XFILLER_0_45_144 VGND VGND VPWR VPWR sky130_fd_sc_hd__fill_2
XFILLER_0_18_347 VGND VGND VPWR VPWR sky130_fd_sc_hd__fill_1
XFILLER_0_90_3 VGND VGND VPWR VPWR sky130_fd_sc_hd__decap_8
XFILLER_0_116_566 VGND VGND VPWR VPWR sky130_fd_sc_hd__fill_1
XFILLER_0_61_648 VGND VGND VPWR VPWR sky130_fd_sc_hd__fill_2
XFILLER_0_131_525 VGND VGND VPWR VPWR sky130_fd_sc_hd__fill_1
XFILLER_0_14_586 VGND VGND VPWR VPWR sky130_fd_sc_hd__fill_2
XFILLER_0_10_781 VPWR VGND VPWR VGND sky130_ef_sc_hd__decap_12
XTAP_291 VGND VPWR sky130_fd_sc_hd__tapvpwrvgnd_1
X_09827_ _04020_ _04051_ _04055_ _03658_ VGND VGND VPWR VPWR _04056_ sky130_fd_sc_hd__o211a_1
X_09758_ _03979_ _03986_ _03988_ VGND VGND VPWR VPWR _03989_ sky130_fd_sc_hd__a21o_1
XTAP_2114 VGND VPWR sky130_fd_sc_hd__tapvpwrvgnd_1
XTAP_2125 VGND VPWR sky130_fd_sc_hd__tapvpwrvgnd_1
XTAP_2103 VGND VPWR sky130_fd_sc_hd__tapvpwrvgnd_1
X_08709_ net181 VGND VGND VPWR VPWR _03070_ sky130_fd_sc_hd__inv_2
XTAP_2158 VGND VPWR sky130_fd_sc_hd__tapvpwrvgnd_1
XTAP_2147 VGND VPWR sky130_fd_sc_hd__tapvpwrvgnd_1
XTAP_2136 VGND VPWR sky130_fd_sc_hd__tapvpwrvgnd_1
X_11720_ _05479_ VGND VGND VPWR VPWR _00545_ sky130_fd_sc_hd__clkbuf_1
XTAP_1424 VGND VPWR sky130_fd_sc_hd__tapvpwrvgnd_1
XTAP_1413 VGND VPWR sky130_fd_sc_hd__tapvpwrvgnd_1
XTAP_1402 VGND VPWR sky130_fd_sc_hd__tapvpwrvgnd_1
X_09689_ cpuregs\[26\]\[4\] cpuregs\[27\]\[4\] _03902_ VGND VGND VPWR VPWR _03921_
+ sky130_fd_sc_hd__mux2_1
XTAP_2169 VGND VPWR sky130_fd_sc_hd__tapvpwrvgnd_1
XFILLER_0_84_729 VGND VGND VPWR VPWR sky130_fd_sc_hd__fill_1
XTAP_1446 VGND VPWR sky130_fd_sc_hd__tapvpwrvgnd_1
XTAP_1457 VGND VPWR sky130_fd_sc_hd__tapvpwrvgnd_1
XTAP_1435 VGND VPWR sky130_fd_sc_hd__tapvpwrvgnd_1
X_11651_ _05045_ net1042 _05433_ VGND VGND VPWR VPWR _05443_ sky130_fd_sc_hd__mux2_1
XTAP_1479 VGND VPWR sky130_fd_sc_hd__tapvpwrvgnd_1
XTAP_1468 VGND VPWR sky130_fd_sc_hd__tapvpwrvgnd_1
X_11582_ _05406_ VGND VGND VPWR VPWR _00480_ sky130_fd_sc_hd__clkbuf_1
X_10602_ _03929_ _04807_ _04809_ VGND VGND VPWR VPWR _04810_ sky130_fd_sc_hd__a21o_1
XFILLER_0_126_319 VGND VGND VPWR VPWR sky130_fd_sc_hd__fill_1
X_14370_ _04993_ net861 _07616_ VGND VGND VPWR VPWR _01545_ sky130_fd_sc_hd__mux2_1
X_10533_ cpuregs\[24\]\[26\] cpuregs\[25\]\[26\] cpuregs\[26\]\[26\] cpuregs\[27\]\[26\]
+ _03935_ _04200_ VGND VGND VPWR VPWR _04743_ sky130_fd_sc_hd__mux4_1
XFILLER_0_119_393 VPWR VGND VPWR VGND sky130_ef_sc_hd__decap_12
X_13321_ _06804_ VGND VGND VPWR VPWR _00821_ sky130_fd_sc_hd__clkbuf_1
XFILLER_0_64_486 VGND VGND VPWR VPWR sky130_fd_sc_hd__fill_1
XFILLER_0_134_363 VGND VGND VPWR VPWR sky130_fd_sc_hd__fill_1
X_16040_ clknet_leaf_28_clk _00690_ VGND VGND VPWR VPWR reg_next_pc\[15\] sky130_fd_sc_hd__dfxtp_1
XFILLER_0_91_294 VPWR VGND VPWR VGND sky130_ef_sc_hd__decap_12
XFILLER_0_51_147 VGND VGND VPWR VPWR sky130_fd_sc_hd__decap_8
X_10464_ _04671_ _04675_ VGND VGND VPWR VPWR _04676_ sky130_fd_sc_hd__nand2_1
X_13252_ cpuregs\[6\]\[14\] cpuregs\[7\]\[14\] _06511_ VGND VGND VPWR VPWR _06737_
+ sky130_fd_sc_hd__mux2_1
XFILLER_0_110_709 VGND VGND VPWR VPWR sky130_fd_sc_hd__decap_3
X_10395_ _03862_ _04588_ _04608_ VGND VGND VPWR VPWR _04609_ sky130_fd_sc_hd__o21a_1
X_12203_ _05741_ net445 _05816_ _05826_ VGND VGND VPWR VPWR _00681_ sky130_fd_sc_hd__o211a_1
X_13183_ _06535_ _06664_ _06669_ _06542_ VGND VGND VPWR VPWR _06670_ sky130_fd_sc_hd__o211a_1
X_12134_ _05519_ VGND VGND VPWR VPWR _05763_ sky130_fd_sc_hd__clkbuf_4
X_16942_ clknet_leaf_67_clk _01506_ VGND VGND VPWR VPWR cpuregs\[0\]\[29\] sky130_fd_sc_hd__dfxtp_1
X_12065_ _02108_ _05714_ VGND VGND VPWR VPWR _05715_ sky130_fd_sc_hd__or2_1
X_16873_ clknet_leaf_61_clk _01437_ VGND VGND VPWR VPWR cpuregs\[22\]\[24\] sky130_fd_sc_hd__dfxtp_1
X_11016_ net814 _03456_ _05088_ VGND VGND VPWR VPWR _05091_ sky130_fd_sc_hd__mux2_1
X_15824_ clknet_leaf_46_clk _00474_ VGND VGND VPWR VPWR cpuregs\[16\]\[22\] sky130_fd_sc_hd__dfxtp_1
XFILLER_0_126_15 VPWR VGND VPWR VGND sky130_ef_sc_hd__decap_12
X_15755_ clknet_leaf_89_clk _00405_ VGND VGND VPWR VPWR cpuregs\[15\]\[17\] sky130_fd_sc_hd__dfxtp_1
XFILLER_0_59_214 VGND VGND VPWR VPWR sky130_fd_sc_hd__fill_1
X_12967_ _03324_ VGND VGND VPWR VPWR _06461_ sky130_fd_sc_hd__clkbuf_4
XFILLER_0_59_269 VGND VGND VPWR VPWR sky130_fd_sc_hd__decap_6
X_15686_ clknet_leaf_137_clk _00336_ VGND VGND VPWR VPWR cpuregs\[27\]\[12\] sky130_fd_sc_hd__dfxtp_1
X_14706_ _04989_ net1559 _01720_ VGND VGND VPWR VPWR _01723_ sky130_fd_sc_hd__mux2_1
X_12898_ _06392_ _06393_ _06395_ VGND VGND VPWR VPWR _06396_ sky130_fd_sc_hd__a21o_1
X_11918_ count_instr\[33\] count_instr\[32\] count_instr\[31\] _05602_ VGND VGND VPWR
+ VPWR _05609_ sky130_fd_sc_hd__and4_1
XFILLER_0_74_217 VGND VGND VPWR VPWR sky130_fd_sc_hd__fill_1
X_14637_ _01686_ VGND VGND VPWR VPWR _01190_ sky130_fd_sc_hd__clkbuf_1
X_11849_ _05559_ VGND VGND VPWR VPWR _00594_ sky130_fd_sc_hd__clkbuf_1
XFILLER_0_27_111 VGND VGND VPWR VPWR sky130_fd_sc_hd__fill_1
XTAP_1991 VGND VPWR sky130_fd_sc_hd__tapvpwrvgnd_1
XTAP_1980 VGND VPWR sky130_fd_sc_hd__tapvpwrvgnd_1
X_14568_ _04987_ net992 _01648_ VGND VGND VPWR VPWR _01650_ sky130_fd_sc_hd__mux2_1
XFILLER_0_27_133 VGND VGND VPWR VPWR sky130_fd_sc_hd__decap_6
X_16307_ clknet_leaf_27_clk _00892_ VGND VGND VPWR VPWR decoded_imm_j\[12\] sky130_fd_sc_hd__dfxtp_1
XFILLER_0_27_177 VGND VGND VPWR VPWR sky130_fd_sc_hd__decap_3
XFILLER_0_43_615 VGND VGND VPWR VPWR sky130_fd_sc_hd__fill_1
X_13519_ cpuregs\[8\]\[22\] cpuregs\[9\]\[22\] _06764_ VGND VGND VPWR VPWR _06996_
+ sky130_fd_sc_hd__mux2_1
X_14499_ _01613_ VGND VGND VPWR VPWR _01125_ sky130_fd_sc_hd__clkbuf_1
XFILLER_0_27_199 VGND VGND VPWR VPWR sky130_fd_sc_hd__fill_1
XFILLER_0_42_136 VGND VGND VPWR VPWR sky130_fd_sc_hd__decap_4
XFILLER_0_113_525 VGND VGND VPWR VPWR sky130_fd_sc_hd__decap_4
X_16238_ clknet_leaf_23_clk alu_out\[11\] VGND VGND VPWR VPWR alu_out_q\[11\] sky130_fd_sc_hd__dfxtp_1
X_16169_ clknet_leaf_29_clk _00787_ VGND VGND VPWR VPWR net42 sky130_fd_sc_hd__dfxtp_1
XFILLER_0_2_277 VGND VGND VPWR VPWR sky130_fd_sc_hd__fill_1
X_08991_ _02632_ _03285_ _03268_ VGND VGND VPWR VPWR _03286_ sky130_fd_sc_hd__mux2_1
X_07942_ net411 _02232_ _02345_ VGND VGND VPWR VPWR _02346_ sky130_fd_sc_hd__a21oi_2
X_07873_ net13 _02216_ _02281_ _02212_ VGND VGND VPWR VPWR _02282_ sky130_fd_sc_hd__a22o_1
X_09612_ _02208_ _03845_ VGND VGND VPWR VPWR _03846_ sky130_fd_sc_hd__nand2_1
X_09543_ _02132_ _02243_ _03651_ VGND VGND VPWR VPWR _03778_ sky130_fd_sc_hd__mux2_1
XFILLER_0_78_589 VGND VGND VPWR VPWR sky130_fd_sc_hd__fill_2
X_09474_ instr_srl instr_sll instr_srli instr_slli VGND VGND VPWR VPWR _03710_ sky130_fd_sc_hd__nor4_1
X_08425_ _02689_ _02804_ _02805_ VGND VGND VPWR VPWR _02806_ sky130_fd_sc_hd__a21o_1
XFILLER_0_19_612 VGND VGND VPWR VPWR sky130_fd_sc_hd__decap_4
XFILLER_0_135_105 VGND VGND VPWR VPWR sky130_fd_sc_hd__decap_6
X_08356_ net191 net223 VGND VGND VPWR VPWR _02737_ sky130_fd_sc_hd__or2_1
XFILLER_0_108_319 VGND VGND VPWR VPWR sky130_fd_sc_hd__decap_8
XFILLER_0_58_280 VGND VGND VPWR VPWR sky130_fd_sc_hd__fill_1
XFILLER_0_19_645 VGND VGND VPWR VPWR sky130_fd_sc_hd__fill_2
XFILLER_0_132_80 VGND VGND VPWR VPWR sky130_fd_sc_hd__decap_4
XFILLER_0_18_177 VGND VGND VPWR VPWR sky130_fd_sc_hd__fill_1
X_08287_ net197 net251 VGND VGND VPWR VPWR _02668_ sky130_fd_sc_hd__nand2_1
XFILLER_0_116_396 VGND VGND VPWR VPWR sky130_fd_sc_hd__fill_2
XFILLER_0_131_333 VGND VGND VPWR VPWR sky130_fd_sc_hd__decap_3
XFILLER_0_41_191 VGND VGND VPWR VPWR sky130_fd_sc_hd__decap_6
X_10180_ _03862_ _04379_ _04399_ VGND VGND VPWR VPWR _04400_ sky130_fd_sc_hd__o21a_1
Xfanout252 net119 VGND VGND VPWR VPWR net252 sky130_fd_sc_hd__buf_4
X_13870_ _07320_ _07306_ _07322_ VGND VGND VPWR VPWR _00846_ sky130_fd_sc_hd__a21o_1
X_12821_ _06325_ VGND VGND VPWR VPWR _00800_ sky130_fd_sc_hd__clkbuf_1
X_15540_ clknet_leaf_80_clk _00190_ VGND VGND VPWR VPWR cpuregs\[13\]\[26\] sky130_fd_sc_hd__dfxtp_1
XTAP_1232 VGND VPWR sky130_fd_sc_hd__tapvpwrvgnd_1
XTAP_1221 VGND VPWR sky130_fd_sc_hd__tapvpwrvgnd_1
XTAP_1210 VGND VPWR sky130_fd_sc_hd__tapvpwrvgnd_1
X_12752_ _03653_ net244 _03648_ _02158_ VGND VGND VPWR VPWR _06286_ sky130_fd_sc_hd__a211o_1
X_15471_ clknet_leaf_78_clk _00121_ VGND VGND VPWR VPWR cpuregs\[12\]\[21\] sky130_fd_sc_hd__dfxtp_1
X_11703_ net1584 _05205_ _05469_ VGND VGND VPWR VPWR _05471_ sky130_fd_sc_hd__mux2_1
XTAP_1265 VGND VPWR sky130_fd_sc_hd__tapvpwrvgnd_1
XTAP_1254 VGND VPWR sky130_fd_sc_hd__tapvpwrvgnd_1
XTAP_1243 VGND VPWR sky130_fd_sc_hd__tapvpwrvgnd_1
X_12683_ net418 _06225_ _06227_ VGND VGND VPWR VPWR _00760_ sky130_fd_sc_hd__a21oi_1
X_14422_ _05045_ net1465 _01562_ VGND VGND VPWR VPWR _01572_ sky130_fd_sc_hd__mux2_1
XFILLER_0_112_17 VGND VGND VPWR VPWR sky130_fd_sc_hd__fill_2
X_11634_ _05434_ VGND VGND VPWR VPWR _00504_ sky130_fd_sc_hd__clkbuf_1
XFILLER_0_84_559 VGND VGND VPWR VPWR sky130_fd_sc_hd__fill_1
XTAP_1298 VGND VPWR sky130_fd_sc_hd__tapvpwrvgnd_1
XTAP_1287 VGND VPWR sky130_fd_sc_hd__tapvpwrvgnd_1
XTAP_1276 VGND VPWR sky130_fd_sc_hd__tapvpwrvgnd_1
X_11565_ _05026_ net1012 _05397_ VGND VGND VPWR VPWR _05398_ sky130_fd_sc_hd__mux2_1
XFILLER_0_64_283 VGND VGND VPWR VPWR sky130_fd_sc_hd__fill_2
X_14353_ net1009 _07575_ _07609_ _07610_ VGND VGND VPWR VPWR _01026_ sky130_fd_sc_hd__o22a_1
X_10516_ _04723_ _04725_ VGND VGND VPWR VPWR _04726_ sky130_fd_sc_hd__xnor2_1
X_11496_ net687 _05202_ _05360_ VGND VGND VPWR VPWR _05361_ sky130_fd_sc_hd__mux2_1
X_13304_ _06682_ _06787_ VGND VGND VPWR VPWR _06788_ sky130_fd_sc_hd__and2_1
X_14284_ _02118_ VGND VGND VPWR VPWR _07570_ sky130_fd_sc_hd__buf_2
X_16023_ clknet_leaf_38_clk _00673_ VGND VGND VPWR VPWR reg_pc\[29\] sky130_fd_sc_hd__dfxtp_2
X_10447_ _04020_ _04656_ _04658_ _00015_ VGND VGND VPWR VPWR _04659_ sky130_fd_sc_hd__a31o_1
X_13235_ cpuregs\[30\]\[13\] cpuregs\[31\]\[13\] _06462_ VGND VGND VPWR VPWR _06721_
+ sky130_fd_sc_hd__mux2_1
XFILLER_0_0_726 VGND VGND VPWR VPWR sky130_fd_sc_hd__fill_2
X_10378_ _03868_ _04591_ _03870_ VGND VGND VPWR VPWR _04592_ sky130_fd_sc_hd__a21o_1
X_13166_ _06447_ _06651_ _06653_ _06453_ VGND VGND VPWR VPWR _06654_ sky130_fd_sc_hd__a211o_1
X_12117_ _05737_ reg_pc\[26\] VGND VGND VPWR VPWR _05752_ sky130_fd_sc_hd__or2_1
X_13097_ cpuregs\[20\]\[9\] cpuregs\[21\]\[9\] _06448_ VGND VGND VPWR VPWR _06587_
+ sky130_fd_sc_hd__mux2_1
X_12048_ _05688_ _05702_ _05703_ _02142_ VGND VGND VPWR VPWR _00649_ sky130_fd_sc_hd__o211a_1
X_16925_ clknet_leaf_109_clk _01489_ VGND VGND VPWR VPWR cpuregs\[0\]\[12\] sky130_fd_sc_hd__dfxtp_1
XFILLER_0_46_12 VGND VGND VPWR VPWR sky130_fd_sc_hd__decap_4
XFILLER_0_137_69 VPWR VGND VPWR VGND sky130_ef_sc_hd__decap_12
X_16856_ clknet_leaf_133_clk _01420_ VGND VGND VPWR VPWR cpuregs\[22\]\[7\] sky130_fd_sc_hd__dfxtp_1
X_15807_ clknet_leaf_142_clk _00457_ VGND VGND VPWR VPWR cpuregs\[16\]\[5\] sky130_fd_sc_hd__dfxtp_1
X_13999_ _07325_ _07413_ VGND VGND VPWR VPWR _07414_ sky130_fd_sc_hd__nor2_1
X_16787_ clknet_leaf_100_clk _01351_ VGND VGND VPWR VPWR cpuregs\[6\]\[2\] sky130_fd_sc_hd__dfxtp_1
X_15738_ clknet_leaf_119_clk _00388_ VGND VGND VPWR VPWR cpuregs\[15\]\[0\] sky130_fd_sc_hd__dfxtp_1
X_15669_ clknet_leaf_71_clk _00319_ VGND VGND VPWR VPWR cpuregs\[14\]\[27\] sky130_fd_sc_hd__dfxtp_1
XFILLER_0_118_639 VGND VGND VPWR VPWR sky130_fd_sc_hd__decap_4
X_08210_ count_instr\[59\] _02203_ VGND VGND VPWR VPWR _02596_ sky130_fd_sc_hd__and2_1
X_09190_ _03455_ VGND VGND VPWR VPWR _03456_ sky130_fd_sc_hd__buf_2
X_08141_ _02517_ _02528_ _02531_ VGND VGND VPWR VPWR _02532_ sky130_fd_sc_hd__o21ai_1
XFILLER_0_83_581 VGND VGND VPWR VPWR sky130_fd_sc_hd__decap_4
X_08072_ net179 VGND VGND VPWR VPWR _02468_ sky130_fd_sc_hd__clkbuf_4
XFILLER_0_15_169 VGND VGND VPWR VPWR sky130_fd_sc_hd__decap_4
XFILLER_0_125_193 VGND VGND VPWR VPWR sky130_fd_sc_hd__decap_4
XFILLER_0_102_83 VGND VGND VPWR VPWR sky130_fd_sc_hd__fill_1
XFILLER_0_140_163 VGND VGND VPWR VPWR sky130_fd_sc_hd__decap_4
XFILLER_0_87_30 VGND VGND VPWR VPWR sky130_fd_sc_hd__fill_2
X_08974_ _03274_ VGND VGND VPWR VPWR net79 sky130_fd_sc_hd__buf_4
X_07925_ net1629 _02330_ VGND VGND VPWR VPWR _07647_ sky130_fd_sc_hd__nor2_1
Xhold27 count_instr\[63\] VGND VGND VPWR VPWR net385 sky130_fd_sc_hd__dlygate4sd3_1
Xhold38 decoded_rd\[0\] VGND VGND VPWR VPWR net396 sky130_fd_sc_hd__dlygate4sd3_1
Xhold49 count_cycle\[16\] VGND VGND VPWR VPWR net407 sky130_fd_sc_hd__dlygate4sd3_1
X_07856_ _02207_ _02263_ _02199_ _02265_ VGND VGND VPWR VPWR _02266_ sky130_fd_sc_hd__a22o_1
X_07787_ instr_rdinstr VGND VGND VPWR VPWR _02201_ sky130_fd_sc_hd__clkbuf_4
X_09526_ cpuregs\[8\]\[1\] cpuregs\[9\]\[1\] _03756_ VGND VGND VPWR VPWR _03761_ sky130_fd_sc_hd__mux2_1
X_09457_ cpuregs\[12\]\[0\] cpuregs\[13\]\[0\] cpuregs\[14\]\[0\] cpuregs\[15\]\[0\]
+ _03667_ _03670_ VGND VGND VPWR VPWR _03693_ sky130_fd_sc_hd__mux4_1
XFILLER_0_108_105 VPWR VGND VPWR VGND sky130_ef_sc_hd__decap_12
X_08408_ net250 VGND VGND VPWR VPWR _02789_ sky130_fd_sc_hd__inv_2
X_09388_ _03546_ _03624_ _03625_ _03627_ VGND VGND VPWR VPWR _03628_ sky130_fd_sc_hd__a22o_2
XFILLER_0_136_469 VGND VGND VPWR VPWR sky130_fd_sc_hd__fill_1
XFILLER_0_124_609 VGND VGND VPWR VPWR sky130_fd_sc_hd__fill_1
X_08339_ _02717_ _02718_ _02719_ VGND VGND VPWR VPWR _02720_ sky130_fd_sc_hd__a21bo_1
X_11350_ _05283_ VGND VGND VPWR VPWR _00371_ sky130_fd_sc_hd__clkbuf_1
X_10301_ _02445_ _02493_ _02567_ _02522_ _03847_ _03916_ VGND VGND VPWR VPWR _04517_
+ sky130_fd_sc_hd__mux4_1
X_11281_ _05246_ VGND VGND VPWR VPWR _00339_ sky130_fd_sc_hd__clkbuf_1
X_13020_ cpuregs\[6\]\[7\] cpuregs\[7\]\[7\] _06511_ VGND VGND VPWR VPWR _06512_ sky130_fd_sc_hd__mux2_1
XFILLER_0_104_399 VGND VGND VPWR VPWR sky130_fd_sc_hd__fill_1
X_10232_ _03653_ _04447_ _04449_ _02159_ VGND VGND VPWR VPWR _04450_ sky130_fd_sc_hd__o211a_1
X_10163_ _03901_ _04382_ _03870_ VGND VGND VPWR VPWR _04383_ sky130_fd_sc_hd__a21o_1
X_16710_ clknet_leaf_59_clk _01277_ VGND VGND VPWR VPWR cpuregs\[3\]\[24\] sky130_fd_sc_hd__dfxtp_1
X_10094_ cpuregs\[28\]\[14\] cpuregs\[29\]\[14\] cpuregs\[30\]\[14\] cpuregs\[31\]\[14\]
+ _03865_ _03942_ VGND VGND VPWR VPWR _04316_ sky130_fd_sc_hd__mux4_1
X_14971_ _03646_ net1180 _01828_ VGND VGND VPWR VPWR _01863_ sky130_fd_sc_hd__mux2_1
X_13922_ _07359_ _07361_ VGND VGND VPWR VPWR _07362_ sky130_fd_sc_hd__and2_1
X_16641_ clknet_leaf_56_clk _01208_ VGND VGND VPWR VPWR cpuregs\[23\]\[19\] sky130_fd_sc_hd__dfxtp_1
X_13853_ _07311_ VGND VGND VPWR VPWR _01095_ sky130_fd_sc_hd__buf_1
X_16572_ clknet_leaf_57_clk _01149_ VGND VGND VPWR VPWR cpuregs\[24\]\[24\] sky130_fd_sc_hd__dfxtp_1
XFILLER_0_69_331 VGND VGND VPWR VPWR sky130_fd_sc_hd__fill_1
X_12804_ net47 net78 _06313_ VGND VGND VPWR VPWR _06317_ sky130_fd_sc_hd__mux2_1
X_10996_ _05037_ net1067 _05074_ VGND VGND VPWR VPWR _05080_ sky130_fd_sc_hd__mux2_1
XFILLER_0_139_241 VGND VGND VPWR VPWR sky130_fd_sc_hd__fill_1
X_13784_ cpuregs\[30\]\[30\] cpuregs\[31\]\[30\] _06510_ VGND VGND VPWR VPWR _07253_
+ sky130_fd_sc_hd__mux2_1
XFILLER_0_97_673 VGND VGND VPWR VPWR sky130_fd_sc_hd__fill_2
XTAP_1040 VGND VPWR sky130_fd_sc_hd__tapvpwrvgnd_1
X_15523_ clknet_leaf_110_clk _00173_ VGND VGND VPWR VPWR cpuregs\[13\]\[9\] sky130_fd_sc_hd__dfxtp_1
XFILLER_0_139_263 VGND VGND VPWR VPWR sky130_fd_sc_hd__fill_2
X_12735_ _03795_ _06262_ _06268_ VGND VGND VPWR VPWR _06269_ sky130_fd_sc_hd__or3_2
XTAP_1062 VGND VPWR sky130_fd_sc_hd__tapvpwrvgnd_1
XTAP_1073 VGND VPWR sky130_fd_sc_hd__tapvpwrvgnd_1
XTAP_1051 VGND VPWR sky130_fd_sc_hd__tapvpwrvgnd_1
XFILLER_0_127_447 VGND VGND VPWR VPWR sky130_fd_sc_hd__fill_1
XTAP_1095 VGND VPWR sky130_fd_sc_hd__tapvpwrvgnd_1
XTAP_1084 VGND VPWR sky130_fd_sc_hd__tapvpwrvgnd_1
X_15454_ clknet_leaf_124_clk _00104_ VGND VGND VPWR VPWR cpuregs\[12\]\[4\] sky130_fd_sc_hd__dfxtp_1
X_12666_ _06215_ VGND VGND VPWR VPWR _00755_ sky130_fd_sc_hd__clkbuf_1
X_14405_ _01563_ VGND VGND VPWR VPWR _01049_ sky130_fd_sc_hd__clkbuf_1
X_11617_ _05425_ VGND VGND VPWR VPWR _00496_ sky130_fd_sc_hd__clkbuf_1
X_15385_ clknet_leaf_121_clk _00040_ VGND VGND VPWR VPWR cpuregs\[11\]\[3\] sky130_fd_sc_hd__dfxtp_1
X_12597_ _06165_ _06128_ _06166_ VGND VGND VPWR VPWR _06167_ sky130_fd_sc_hd__and3b_1
X_14336_ _07320_ decoded_imm_j\[10\] _07588_ mem_rdata_q\[30\] _07382_ VGND VGND VPWR
+ VPWR _07601_ sky130_fd_sc_hd__a221o_1
X_11548_ _05010_ net1334 _05386_ VGND VGND VPWR VPWR _05389_ sky130_fd_sc_hd__mux2_1
XFILLER_0_52_253 VGND VGND VPWR VPWR sky130_fd_sc_hd__fill_1
XFILLER_0_122_130 VGND VGND VPWR VPWR sky130_fd_sc_hd__fill_1
Xhold508 cpuregs\[3\]\[14\] VGND VGND VPWR VPWR net866 sky130_fd_sc_hd__dlygate4sd3_1
Xhold519 cpuregs\[24\]\[23\] VGND VGND VPWR VPWR net877 sky130_fd_sc_hd__dlygate4sd3_1
XFILLER_0_122_163 VGND VGND VPWR VPWR sky130_fd_sc_hd__decap_4
XFILLER_0_110_303 VGND VGND VPWR VPWR sky130_fd_sc_hd__fill_2
X_11479_ net889 _05186_ _05349_ VGND VGND VPWR VPWR _05352_ sky130_fd_sc_hd__mux2_1
X_14267_ _07559_ VGND VGND VPWR VPWR _07560_ sky130_fd_sc_hd__clkbuf_2
X_16006_ clknet_leaf_28_clk _00656_ VGND VGND VPWR VPWR reg_pc\[12\] sky130_fd_sc_hd__dfxtp_2
X_14198_ _07523_ VGND VGND VPWR VPWR _00958_ sky130_fd_sc_hd__clkbuf_1
X_13218_ cpuregs\[4\]\[13\] cpuregs\[5\]\[13\] _06575_ VGND VGND VPWR VPWR _06704_
+ sky130_fd_sc_hd__mux2_1
XFILLER_0_57_11 VGND VGND VPWR VPWR sky130_fd_sc_hd__fill_2
X_13149_ _06535_ _06632_ _06636_ _06542_ VGND VGND VPWR VPWR _06637_ sky130_fd_sc_hd__o211a_1
XTAP_802 VGND VPWR sky130_fd_sc_hd__tapvpwrvgnd_1
XTAP_813 VGND VPWR sky130_fd_sc_hd__tapvpwrvgnd_1
XTAP_824 VGND VPWR sky130_fd_sc_hd__tapvpwrvgnd_1
XTAP_835 VGND VPWR sky130_fd_sc_hd__tapvpwrvgnd_1
XFILLER_0_57_55 VGND VGND VPWR VPWR sky130_fd_sc_hd__fill_1
XTAP_846 VGND VPWR sky130_fd_sc_hd__tapvpwrvgnd_1
XTAP_857 VGND VPWR sky130_fd_sc_hd__tapvpwrvgnd_1
XTAP_868 VGND VPWR sky130_fd_sc_hd__tapvpwrvgnd_1
Xhold1219 cpuregs\[29\]\[13\] VGND VGND VPWR VPWR net1577 sky130_fd_sc_hd__dlygate4sd3_1
X_07710_ _02132_ _02133_ _02135_ mem_wordsize\[0\] VGND VGND VPWR VPWR _02136_ sky130_fd_sc_hd__a22o_1
Xhold1208 cpuregs\[2\]\[3\] VGND VGND VPWR VPWR net1566 sky130_fd_sc_hd__dlygate4sd3_1
XTAP_879 VGND VPWR sky130_fd_sc_hd__tapvpwrvgnd_1
X_16908_ clknet_leaf_80_clk _01472_ VGND VGND VPWR VPWR cpuregs\[8\]\[27\] sky130_fd_sc_hd__dfxtp_1
X_08690_ _02849_ _03049_ _03052_ VGND VGND VPWR VPWR alu_out\[18\] sky130_fd_sc_hd__a21o_1
X_16839_ clknet_leaf_77_clk _01403_ VGND VGND VPWR VPWR cpuregs\[7\]\[22\] sky130_fd_sc_hd__dfxtp_1
X_09311_ reg_pc\[18\] _03554_ VGND VGND VPWR VPWR _03561_ sky130_fd_sc_hd__nand2_1
XFILLER_0_118_403 VGND VGND VPWR VPWR sky130_fd_sc_hd__fill_1
XFILLER_0_75_356 VGND VGND VPWR VPWR sky130_fd_sc_hd__fill_1
XFILLER_0_48_559 VGND VGND VPWR VPWR sky130_fd_sc_hd__fill_1
X_09242_ reg_pc\[9\] _03494_ _03460_ VGND VGND VPWR VPWR _03501_ sky130_fd_sc_hd__o21ai_1
XFILLER_0_8_634 VGND VGND VPWR VPWR sky130_fd_sc_hd__fill_1
XFILLER_0_56_592 VGND VGND VPWR VPWR sky130_fd_sc_hd__fill_2
X_09173_ latched_rd\[4\] latched_rd\[2\] latched_rd\[3\] VGND VGND VPWR VPWR _03441_
+ sky130_fd_sc_hd__or3b_4
XFILLER_0_44_710 VGND VGND VPWR VPWR sky130_fd_sc_hd__fill_1
X_08124_ count_cycle\[21\] _02454_ _02514_ _02515_ VGND VGND VPWR VPWR _02516_ sky130_fd_sc_hd__a211o_2
XFILLER_0_16_445 VGND VGND VPWR VPWR sky130_fd_sc_hd__decap_8
XFILLER_0_71_595 VGND VGND VPWR VPWR sky130_fd_sc_hd__fill_2
XFILLER_0_113_152 VGND VGND VPWR VPWR sky130_fd_sc_hd__fill_1
X_08055_ net1664 _02269_ _02235_ _02451_ VGND VGND VPWR VPWR _02452_ sky130_fd_sc_hd__a211o_1
Xoutput39 net39 VGND VGND VPWR VPWR mem_addr[14] sky130_fd_sc_hd__clkbuf_4
Xpicorv32_261 VGND VGND VPWR VPWR picorv32_261/HI eoi[8] sky130_fd_sc_hd__conb_1
XFILLER_0_113_196 VGND VGND VPWR VPWR sky130_fd_sc_hd__fill_1
Xpicorv32_272 VGND VGND VPWR VPWR picorv32_272/HI eoi[19] sky130_fd_sc_hd__conb_1
Xpicorv32_294 VGND VGND VPWR VPWR picorv32_294/HI pcpi_insn[5] sky130_fd_sc_hd__conb_1
Xpicorv32_283 VGND VGND VPWR VPWR picorv32_283/HI eoi[30] sky130_fd_sc_hd__conb_1
XFILLER_0_11_161 VGND VGND VPWR VPWR sky130_fd_sc_hd__fill_1
XFILLER_0_12_695 VGND VGND VPWR VPWR sky130_fd_sc_hd__fill_1
X_08957_ _03262_ VGND VGND VPWR VPWR net74 sky130_fd_sc_hd__buf_4
X_08888_ _03219_ VGND VGND VPWR VPWR net111 sky130_fd_sc_hd__clkbuf_2
X_07908_ _02197_ _02308_ _02314_ VGND VGND VPWR VPWR _02315_ sky130_fd_sc_hd__a21oi_1
X_07839_ count_instr\[34\] instr_rdinstrh count_cycle\[34\] instr_rdcycleh VGND VGND
+ VPWR VPWR _02250_ sky130_fd_sc_hd__a22o_1
X_10850_ _03455_ VGND VGND VPWR VPWR _04989_ sky130_fd_sc_hd__buf_2
XFILLER_0_66_301 VGND VGND VPWR VPWR sky130_fd_sc_hd__fill_1
XFILLER_0_78_183 VGND VGND VPWR VPWR sky130_fd_sc_hd__fill_1
XPHY_134 VGND VGND VPWR VPWR sky130_fd_sc_hd__decap_3
XPHY_123 VGND VGND VPWR VPWR sky130_fd_sc_hd__decap_3
XPHY_112 VGND VGND VPWR VPWR sky130_fd_sc_hd__decap_3
XPHY_101 VGND VGND VPWR VPWR sky130_fd_sc_hd__decap_3
X_09509_ _03676_ VGND VGND VPWR VPWR _03744_ sky130_fd_sc_hd__clkbuf_8
X_10781_ _04950_ VGND VGND VPWR VPWR _00135_ sky130_fd_sc_hd__clkbuf_1
XFILLER_0_94_698 VGND VGND VPWR VPWR sky130_fd_sc_hd__fill_2
XFILLER_0_94_676 VGND VGND VPWR VPWR sky130_fd_sc_hd__decap_3
XPHY_167 VGND VGND VPWR VPWR sky130_fd_sc_hd__decap_3
XPHY_156 VGND VGND VPWR VPWR sky130_fd_sc_hd__decap_3
XPHY_145 VGND VGND VPWR VPWR sky130_fd_sc_hd__decap_3
X_12520_ _06110_ _05661_ _06111_ VGND VGND VPWR VPWR _06112_ sky130_fd_sc_hd__and3b_1
XFILLER_0_137_767 VPWR VGND VPWR VGND sky130_ef_sc_hd__decap_12
X_12451_ _05687_ _06053_ _06054_ _05768_ VGND VGND VPWR VPWR _00701_ sky130_fd_sc_hd__o211a_1
XPHY_189 VGND VGND VPWR VPWR sky130_fd_sc_hd__decap_3
XFILLER_0_93_175 VGND VGND VPWR VPWR sky130_fd_sc_hd__fill_1
XPHY_178 VGND VGND VPWR VPWR sky130_fd_sc_hd__decap_3
X_15170_ _01968_ VGND VGND VPWR VPWR _01441_ sky130_fd_sc_hd__clkbuf_1
X_11402_ net1339 _05177_ _05302_ VGND VGND VPWR VPWR _05311_ sky130_fd_sc_hd__mux2_1
XANTENNA_90 net125 VGND VGND VPWR VPWR sky130_fd_sc_hd__diode_2
X_12382_ _05960_ VGND VGND VPWR VPWR _05991_ sky130_fd_sc_hd__inv_2
X_14121_ _05001_ net1332 _07471_ VGND VGND VPWR VPWR _07480_ sky130_fd_sc_hd__mux2_1
X_11333_ _05274_ VGND VGND VPWR VPWR _00363_ sky130_fd_sc_hd__clkbuf_1
X_11264_ _05237_ VGND VGND VPWR VPWR _00331_ sky130_fd_sc_hd__clkbuf_1
X_14052_ _07442_ VGND VGND VPWR VPWR _00897_ sky130_fd_sc_hd__clkbuf_1
X_10215_ _03687_ _04427_ _04433_ VGND VGND VPWR VPWR _04434_ sky130_fd_sc_hd__or3_1
X_13003_ _06461_ _06495_ VGND VGND VPWR VPWR _06496_ sky130_fd_sc_hd__and2_1
X_11195_ net609 _05192_ _05182_ VGND VGND VPWR VPWR _05193_ sky130_fd_sc_hd__mux2_1
XFILLER_0_118_27 VGND VGND VPWR VPWR sky130_fd_sc_hd__fill_1
X_10146_ _04153_ _04186_ VGND VGND VPWR VPWR _04366_ sky130_fd_sc_hd__or2_1
X_14954_ _01854_ VGND VGND VPWR VPWR _01339_ sky130_fd_sc_hd__clkbuf_1
X_10077_ _04296_ _04297_ VGND VGND VPWR VPWR _04299_ sky130_fd_sc_hd__or2_1
X_13905_ _07332_ _07351_ VGND VGND VPWR VPWR _07352_ sky130_fd_sc_hd__and2_1
X_14885_ _03591_ net993 _01815_ VGND VGND VPWR VPWR _01818_ sky130_fd_sc_hd__mux2_1
X_16624_ clknet_leaf_134_clk _01191_ VGND VGND VPWR VPWR cpuregs\[23\]\[2\] sky130_fd_sc_hd__dfxtp_1
XFILLER_0_58_813 VGND VGND VPWR VPWR sky130_fd_sc_hd__fill_1
XPHY_3 VGND VGND VPWR VPWR sky130_fd_sc_hd__decap_3
X_13836_ _02108_ cpu_state\[6\] _07299_ VGND VGND VPWR VPWR _07300_ sky130_fd_sc_hd__o21ba_1
XFILLER_0_128_701 VGND VGND VPWR VPWR sky130_fd_sc_hd__fill_2
X_13767_ _06430_ _07231_ _07235_ _03335_ VGND VGND VPWR VPWR _07236_ sky130_fd_sc_hd__o211a_1
X_10979_ _05020_ net1365 _05063_ VGND VGND VPWR VPWR _05071_ sky130_fd_sc_hd__mux2_1
X_16555_ clknet_leaf_129_clk _01132_ VGND VGND VPWR VPWR cpuregs\[24\]\[7\] sky130_fd_sc_hd__dfxtp_1
X_15506_ clknet_leaf_58_clk _00156_ VGND VGND VPWR VPWR cpuregs\[30\]\[24\] sky130_fd_sc_hd__dfxtp_1
XFILLER_0_72_304 VGND VGND VPWR VPWR sky130_fd_sc_hd__fill_1
X_12718_ net401 _06250_ _06252_ VGND VGND VPWR VPWR _00770_ sky130_fd_sc_hd__a21oi_1
X_16486_ clknet_leaf_128_clk _01068_ VGND VGND VPWR VPWR cpuregs\[19\]\[7\] sky130_fd_sc_hd__dfxtp_1
X_13698_ _06377_ _07159_ _07163_ _07169_ _06341_ VGND VGND VPWR VPWR _07170_ sky130_fd_sc_hd__a311o_1
X_15437_ clknet_leaf_52_clk _00087_ VGND VGND VPWR VPWR net180 sky130_fd_sc_hd__dfxtp_4
XFILLER_0_85_698 VGND VGND VPWR VPWR sky130_fd_sc_hd__decap_3
XFILLER_0_84_197 VGND VGND VPWR VPWR sky130_fd_sc_hd__decap_8
XFILLER_0_127_277 VGND VGND VPWR VPWR sky130_fd_sc_hd__decap_3
XFILLER_0_108_480 VGND VGND VPWR VPWR sky130_fd_sc_hd__decap_3
X_12649_ count_cycle\[44\] _06200_ _05539_ VGND VGND VPWR VPWR _06203_ sky130_fd_sc_hd__a21oi_1
X_15368_ _02071_ VGND VGND VPWR VPWR _01536_ sky130_fd_sc_hd__clkbuf_1
X_15299_ net492 VGND VGND VPWR VPWR _02035_ sky130_fd_sc_hd__clkbuf_1
X_14319_ _07320_ decoded_imm_j\[18\] _07570_ mem_rdata_q\[18\] _07357_ VGND VGND VPWR
+ VPWR _07592_ sky130_fd_sc_hd__a221o_1
Xhold305 cpuregs\[27\]\[11\] VGND VGND VPWR VPWR net663 sky130_fd_sc_hd__dlygate4sd3_1
Xhold316 cpuregs\[24\]\[9\] VGND VGND VPWR VPWR net674 sky130_fd_sc_hd__dlygate4sd3_1
Xhold327 cpuregs\[20\]\[26\] VGND VGND VPWR VPWR net685 sky130_fd_sc_hd__dlygate4sd3_1
XFILLER_0_110_122 VGND VGND VPWR VPWR sky130_fd_sc_hd__fill_1
Xhold349 cpuregs\[22\]\[11\] VGND VGND VPWR VPWR net707 sky130_fd_sc_hd__dlygate4sd3_1
XFILLER_0_7_57 VGND VGND VPWR VPWR sky130_fd_sc_hd__fill_2
Xhold338 cpuregs\[2\]\[6\] VGND VGND VPWR VPWR net696 sky130_fd_sc_hd__dlygate4sd3_1
X_09860_ _03897_ _04085_ _04087_ VGND VGND VPWR VPWR _04088_ sky130_fd_sc_hd__a21o_1
XTAP_610 VGND VPWR sky130_fd_sc_hd__tapvpwrvgnd_1
XTAP_621 VGND VPWR sky130_fd_sc_hd__tapvpwrvgnd_1
XTAP_632 VGND VPWR sky130_fd_sc_hd__tapvpwrvgnd_1
XTAP_643 VGND VPWR sky130_fd_sc_hd__tapvpwrvgnd_1
X_08811_ _03162_ _03164_ VGND VGND VPWR VPWR _03165_ sky130_fd_sc_hd__xnor2_1
Xhold1005 cpuregs\[17\]\[15\] VGND VGND VPWR VPWR net1363 sky130_fd_sc_hd__dlygate4sd3_1
XTAP_654 VGND VPWR sky130_fd_sc_hd__tapvpwrvgnd_1
XTAP_665 VGND VPWR sky130_fd_sc_hd__tapvpwrvgnd_1
X_09791_ _03979_ _04019_ _04020_ VGND VGND VPWR VPWR _04021_ sky130_fd_sc_hd__a21o_1
XTAP_676 VGND VPWR sky130_fd_sc_hd__tapvpwrvgnd_1
Xhold1016 cpuregs\[11\]\[22\] VGND VGND VPWR VPWR net1374 sky130_fd_sc_hd__dlygate4sd3_1
X_08742_ _02548_ net218 _02942_ _03031_ VGND VGND VPWR VPWR _03100_ sky130_fd_sc_hd__a31o_1
Xhold1049 cpuregs\[23\]\[23\] VGND VGND VPWR VPWR net1407 sky130_fd_sc_hd__dlygate4sd3_1
Xhold1027 cpuregs\[20\]\[10\] VGND VGND VPWR VPWR net1385 sky130_fd_sc_hd__dlygate4sd3_1
Xhold1038 cpuregs\[9\]\[0\] VGND VGND VPWR VPWR net1396 sky130_fd_sc_hd__dlygate4sd3_1
XTAP_698 VGND VPWR sky130_fd_sc_hd__tapvpwrvgnd_1
XTAP_687 VGND VPWR sky130_fd_sc_hd__tapvpwrvgnd_1
X_08673_ net179 _03035_ VGND VGND VPWR VPWR _03037_ sky130_fd_sc_hd__and2b_1
XFILLER_0_108_93 VGND VGND VPWR VPWR sky130_fd_sc_hd__decap_6
XTAP_1809 VGND VPWR sky130_fd_sc_hd__tapvpwrvgnd_1
XFILLER_0_48_323 VGND VGND VPWR VPWR sky130_fd_sc_hd__fill_2
XFILLER_0_119_767 VGND VGND VPWR VPWR sky130_fd_sc_hd__fill_2
XFILLER_0_91_635 VGND VGND VPWR VPWR sky130_fd_sc_hd__fill_2
XFILLER_0_63_337 VGND VGND VPWR VPWR sky130_fd_sc_hd__decap_4
X_09225_ reg_pc\[6\] _03474_ reg_pc\[7\] VGND VGND VPWR VPWR _03486_ sky130_fd_sc_hd__a21oi_1
XFILLER_0_29_570 VGND VGND VPWR VPWR sky130_fd_sc_hd__fill_2
XFILLER_0_36_529 VGND VGND VPWR VPWR sky130_fd_sc_hd__decap_3
XFILLER_0_91_668 VGND VGND VPWR VPWR sky130_fd_sc_hd__decap_4
XFILLER_0_133_258 VGND VGND VPWR VPWR sky130_fd_sc_hd__fill_1
X_09156_ _03427_ VGND VGND VPWR VPWR _01116_ sky130_fd_sc_hd__buf_1
XFILLER_0_16_253 VGND VGND VPWR VPWR sky130_fd_sc_hd__decap_4
X_08107_ _02440_ _02459_ _02460_ _02476_ _02489_ VGND VGND VPWR VPWR _02500_ sky130_fd_sc_hd__a2111o_1
Xclkbuf_leaf_110_clk clknet_4_11_0_clk VGND VGND VPWR VPWR clknet_leaf_110_clk sky130_fd_sc_hd__clkbuf_16
X_09087_ _03367_ VGND VGND VPWR VPWR _00004_ sky130_fd_sc_hd__clkbuf_1
XFILLER_0_101_122 VGND VGND VPWR VPWR sky130_fd_sc_hd__fill_2
XFILLER_0_101_111 VGND VGND VPWR VPWR sky130_fd_sc_hd__fill_1
X_08038_ _02422_ _02435_ VGND VGND VPWR VPWR _07624_ sky130_fd_sc_hd__nor2_1
XFILLER_0_101_144 VGND VGND VPWR VPWR sky130_fd_sc_hd__fill_2
Xhold872 cpuregs\[29\]\[31\] VGND VGND VPWR VPWR net1230 sky130_fd_sc_hd__dlygate4sd3_1
Xhold861 cpuregs\[9\]\[4\] VGND VGND VPWR VPWR net1219 sky130_fd_sc_hd__dlygate4sd3_1
Xhold850 cpuregs\[10\]\[5\] VGND VGND VPWR VPWR net1208 sky130_fd_sc_hd__dlygate4sd3_1
Xhold883 cpuregs\[26\]\[27\] VGND VGND VPWR VPWR net1241 sky130_fd_sc_hd__dlygate4sd3_1
X_10000_ _04224_ VGND VGND VPWR VPWR _00080_ sky130_fd_sc_hd__clkbuf_1
Xhold894 cpuregs\[13\]\[17\] VGND VGND VPWR VPWR net1252 sky130_fd_sc_hd__dlygate4sd3_1
XFILLER_0_7_6 VGND VGND VPWR VPWR sky130_fd_sc_hd__decap_6
X_09989_ cpuregs\[24\]\[11\] cpuregs\[25\]\[11\] cpuregs\[26\]\[11\] cpuregs\[27\]\[11\]
+ _04192_ _04200_ VGND VGND VPWR VPWR _04214_ sky130_fd_sc_hd__mux4_1
X_11951_ net461 net377 _05633_ VGND VGND VPWR VPWR _00622_ sky130_fd_sc_hd__o21a_1
X_10902_ _03570_ VGND VGND VPWR VPWR _05024_ sky130_fd_sc_hd__buf_2
X_14670_ _01703_ VGND VGND VPWR VPWR _01206_ sky130_fd_sc_hd__clkbuf_1
X_11882_ _05583_ VGND VGND VPWR VPWR _00603_ sky130_fd_sc_hd__clkbuf_1
X_10833_ _04977_ VGND VGND VPWR VPWR _00160_ sky130_fd_sc_hd__clkbuf_1
X_13621_ _06773_ _07094_ VGND VGND VPWR VPWR _07095_ sky130_fd_sc_hd__and2_1
XFILLER_0_137_531 VGND VGND VPWR VPWR sky130_fd_sc_hd__fill_2
X_13552_ cpuregs\[12\]\[23\] cpuregs\[13\]\[23\] cpuregs\[14\]\[23\] cpuregs\[15\]\[23\]
+ _07027_ _06728_ VGND VGND VPWR VPWR _07028_ sky130_fd_sc_hd__mux4_1
X_10764_ _04939_ VGND VGND VPWR VPWR _00129_ sky130_fd_sc_hd__clkbuf_1
XFILLER_0_109_222 VGND VGND VPWR VPWR sky130_fd_sc_hd__fill_2
X_16340_ clknet_leaf_122_clk _00922_ VGND VGND VPWR VPWR cpuregs\[1\]\[5\] sky130_fd_sc_hd__dfxtp_1
XFILLER_0_109_233 VGND VGND VPWR VPWR sky130_fd_sc_hd__decap_3
XFILLER_0_66_197 VGND VGND VPWR VPWR sky130_fd_sc_hd__fill_2
X_12503_ net399 net415 _05640_ VGND VGND VPWR VPWR _06100_ sky130_fd_sc_hd__a21oi_1
XFILLER_0_124_203 VGND VGND VPWR VPWR sky130_fd_sc_hd__fill_1
XFILLER_0_109_288 VGND VGND VPWR VPWR sky130_fd_sc_hd__decap_8
X_13483_ _06961_ VGND VGND VPWR VPWR _00826_ sky130_fd_sc_hd__clkbuf_1
X_10695_ latched_rd\[4\] VGND VGND VPWR VPWR _04900_ sky130_fd_sc_hd__buf_4
X_16271_ clknet_leaf_4_clk net481 VGND VGND VPWR VPWR instr_lw sky130_fd_sc_hd__dfxtp_1
XFILLER_0_124_236 VGND VGND VPWR VPWR sky130_fd_sc_hd__decap_3
X_12434_ _06004_ _05749_ VGND VGND VPWR VPWR _06039_ sky130_fd_sc_hd__and2_1
X_15222_ _01996_ VGND VGND VPWR VPWR _01465_ sky130_fd_sc_hd__clkbuf_1
XFILLER_0_81_167 VGND VGND VPWR VPWR sky130_fd_sc_hd__fill_1
X_15153_ net561 _03576_ _01959_ VGND VGND VPWR VPWR _01960_ sky130_fd_sc_hd__mux2_1
X_12365_ _05733_ _05965_ VGND VGND VPWR VPWR _05976_ sky130_fd_sc_hd__xnor2_1
Xclkbuf_leaf_101_clk clknet_4_11_0_clk VGND VGND VPWR VPWR clknet_leaf_101_clk sky130_fd_sc_hd__clkbuf_16
X_15084_ _01900_ VGND VGND VPWR VPWR _01923_ sky130_fd_sc_hd__buf_4
X_11316_ _04983_ _05264_ VGND VGND VPWR VPWR _05265_ sky130_fd_sc_hd__or2_4
XFILLER_0_50_554 VGND VGND VPWR VPWR sky130_fd_sc_hd__decap_6
X_14104_ _07470_ VGND VGND VPWR VPWR _07471_ sky130_fd_sc_hd__buf_4
X_12296_ _05718_ _05897_ _05912_ VGND VGND VPWR VPWR _05913_ sky130_fd_sc_hd__o21a_1
X_14035_ decoded_imm_j\[10\] _01123_ _03430_ VGND VGND VPWR VPWR _07434_ sky130_fd_sc_hd__mux2_1
X_11247_ _03444_ _05227_ VGND VGND VPWR VPWR _05228_ sky130_fd_sc_hd__nor2_2
X_11178_ _03510_ VGND VGND VPWR VPWR _05181_ sky130_fd_sc_hd__buf_4
X_10129_ cpuregs\[24\]\[15\] cpuregs\[25\]\[15\] cpuregs\[26\]\[15\] cpuregs\[27\]\[15\]
+ _03831_ _03832_ VGND VGND VPWR VPWR _04350_ sky130_fd_sc_hd__mux4_1
X_15986_ clknet_leaf_153_clk _00636_ VGND VGND VPWR VPWR count_instr\[55\] sky130_fd_sc_hd__dfxtp_1
X_14937_ _01845_ VGND VGND VPWR VPWR _01331_ sky130_fd_sc_hd__clkbuf_1
X_14868_ _03538_ net831 _01804_ VGND VGND VPWR VPWR _01809_ sky130_fd_sc_hd__mux2_1
X_13819_ _06415_ _07273_ _07286_ _02181_ decoded_imm\[31\] VGND VGND VPWR VPWR _07287_
+ sky130_fd_sc_hd__a32o_1
X_16607_ clknet_leaf_89_clk _01174_ VGND VGND VPWR VPWR cpuregs\[9\]\[17\] sky130_fd_sc_hd__dfxtp_1
X_14799_ net866 _05190_ _01767_ VGND VGND VPWR VPWR _01772_ sky130_fd_sc_hd__mux2_1
XFILLER_0_58_654 VGND VGND VPWR VPWR sky130_fd_sc_hd__fill_2
X_16538_ clknet_leaf_14_clk _01115_ VGND VGND VPWR VPWR mem_rdata_q\[22\] sky130_fd_sc_hd__dfxtp_1
XFILLER_0_9_228 VGND VGND VPWR VPWR sky130_fd_sc_hd__fill_1
XFILLER_0_9_217 VGND VGND VPWR VPWR sky130_fd_sc_hd__fill_2
XFILLER_0_73_646 VGND VGND VPWR VPWR sky130_fd_sc_hd__decap_4
XFILLER_0_45_315 VGND VGND VPWR VPWR sky130_fd_sc_hd__decap_6
XFILLER_0_128_586 VGND VGND VPWR VPWR sky130_fd_sc_hd__fill_2
X_16469_ clknet_leaf_47_clk _01051_ VGND VGND VPWR VPWR cpuregs\[18\]\[22\] sky130_fd_sc_hd__dfxtp_1
XFILLER_0_116_726 VGND VGND VPWR VPWR sky130_fd_sc_hd__fill_1
X_09010_ decoded_imm_j\[16\] _01109_ _03296_ VGND VGND VPWR VPWR _03299_ sky130_fd_sc_hd__mux2_2
XFILLER_0_5_401 VGND VGND VPWR VPWR sky130_fd_sc_hd__fill_1
XFILLER_0_115_225 VPWR VGND VPWR VGND sky130_ef_sc_hd__decap_12
XFILLER_0_72_178 VGND VGND VPWR VPWR sky130_fd_sc_hd__decap_3
XFILLER_0_72_167 VGND VGND VPWR VPWR sky130_fd_sc_hd__decap_4
XFILLER_0_115_258 VGND VGND VPWR VPWR sky130_fd_sc_hd__fill_1
Xhold135 cpuregs\[0\]\[26\] VGND VGND VPWR VPWR net493 sky130_fd_sc_hd__dlygate4sd3_1
Xhold113 count_instr\[18\] VGND VGND VPWR VPWR net471 sky130_fd_sc_hd__dlygate4sd3_1
Xhold124 net149 VGND VGND VPWR VPWR net482 sky130_fd_sc_hd__dlygate4sd3_1
Xhold102 cpuregs\[0\]\[6\] VGND VGND VPWR VPWR net460 sky130_fd_sc_hd__dlygate4sd3_1
Xhold157 net165 VGND VGND VPWR VPWR net515 sky130_fd_sc_hd__dlygate4sd3_1
XFILLER_0_111_464 VGND VGND VPWR VPWR sky130_fd_sc_hd__decap_3
XFILLER_0_110_94 VGND VGND VPWR VPWR sky130_fd_sc_hd__fill_1
XFILLER_0_110_83 VGND VGND VPWR VPWR sky130_fd_sc_hd__fill_1
Xhold146 cpuregs\[0\]\[15\] VGND VGND VPWR VPWR net504 sky130_fd_sc_hd__dlygate4sd3_1
Xhold168 net44 VGND VGND VPWR VPWR net526 sky130_fd_sc_hd__dlygate4sd3_1
XFILLER_0_13_278 VGND VGND VPWR VPWR sky130_fd_sc_hd__fill_2
Xhold179 reg_next_pc\[22\] VGND VGND VPWR VPWR net537 sky130_fd_sc_hd__dlygate4sd3_1
XFILLER_0_111_486 VGND VGND VPWR VPWR sky130_fd_sc_hd__fill_1
X_09912_ _03818_ _04134_ _04138_ _03829_ VGND VGND VPWR VPWR _04139_ sky130_fd_sc_hd__o211a_1
XFILLER_0_1_695 VGND VGND VPWR VPWR sky130_fd_sc_hd__fill_1
X_09843_ _04003_ _04006_ _04002_ VGND VGND VPWR VPWR _04072_ sky130_fd_sc_hd__a21o_1
XTAP_440 VGND VPWR sky130_fd_sc_hd__tapvpwrvgnd_1
XTAP_451 VGND VPWR sky130_fd_sc_hd__tapvpwrvgnd_1
XTAP_462 VGND VPWR sky130_fd_sc_hd__tapvpwrvgnd_1
XTAP_473 VGND VPWR sky130_fd_sc_hd__tapvpwrvgnd_1
XTAP_484 VGND VPWR sky130_fd_sc_hd__tapvpwrvgnd_1
X_09774_ decoded_imm\[4\] net197 VGND VGND VPWR VPWR _04004_ sky130_fd_sc_hd__and2_1
XTAP_495 VGND VPWR sky130_fd_sc_hd__tapvpwrvgnd_1
XTAP_2307 VGND VPWR sky130_fd_sc_hd__tapvpwrvgnd_1
X_08725_ _02708_ _03077_ _03084_ _03020_ VGND VGND VPWR VPWR alu_out\[21\] sky130_fd_sc_hd__a22o_1
XTAP_2329 VGND VPWR sky130_fd_sc_hd__tapvpwrvgnd_1
XTAP_2318 VGND VPWR sky130_fd_sc_hd__tapvpwrvgnd_1
X_08656_ _03016_ _03018_ _03015_ VGND VGND VPWR VPWR _03021_ sky130_fd_sc_hd__a21o_1
XTAP_1606 VGND VPWR sky130_fd_sc_hd__tapvpwrvgnd_1
XTAP_1639 VGND VPWR sky130_fd_sc_hd__tapvpwrvgnd_1
XTAP_1628 VGND VPWR sky130_fd_sc_hd__tapvpwrvgnd_1
XTAP_1617 VGND VPWR sky130_fd_sc_hd__tapvpwrvgnd_1
X_08587_ _02956_ _02957_ VGND VGND VPWR VPWR _02958_ sky130_fd_sc_hd__and2_1
XFILLER_0_76_473 VGND VGND VPWR VPWR sky130_fd_sc_hd__decap_3
XFILLER_0_134_501 VGND VGND VPWR VPWR sky130_fd_sc_hd__fill_1
XFILLER_0_63_134 VGND VGND VPWR VPWR sky130_fd_sc_hd__fill_1
XFILLER_0_48_197 VGND VGND VPWR VPWR sky130_fd_sc_hd__decap_3
X_10480_ cpuregs\[8\]\[25\] cpuregs\[9\]\[25\] cpuregs\[10\]\[25\] cpuregs\[11\]\[25\]
+ _03875_ _03726_ VGND VGND VPWR VPWR _04691_ sky130_fd_sc_hd__mux4_1
X_09208_ _03471_ VGND VGND VPWR VPWR _03472_ sky130_fd_sc_hd__buf_2
X_09139_ _03335_ _03407_ _03411_ _03417_ _03357_ VGND VGND VPWR VPWR _03418_ sky130_fd_sc_hd__a311o_1
XFILLER_0_32_510 VGND VGND VPWR VPWR sky130_fd_sc_hd__fill_2
XFILLER_0_121_228 VGND VGND VPWR VPWR sky130_fd_sc_hd__fill_1
X_12150_ decoded_imm_j\[2\] _05693_ VGND VGND VPWR VPWR _05777_ sky130_fd_sc_hd__nand2_1
X_11101_ net974 _03511_ _05135_ VGND VGND VPWR VPWR _05136_ sky130_fd_sc_hd__mux2_1
Xhold680 cpuregs\[19\]\[25\] VGND VGND VPWR VPWR net1038 sky130_fd_sc_hd__dlygate4sd3_1
X_12081_ _03547_ reg_next_pc\[16\] _03222_ VGND VGND VPWR VPWR _05726_ sky130_fd_sc_hd__mux2_2
X_11032_ _05087_ VGND VGND VPWR VPWR _05099_ sky130_fd_sc_hd__buf_4
Xhold691 cpuregs\[6\]\[8\] VGND VGND VPWR VPWR net1049 sky130_fd_sc_hd__dlygate4sd3_1
X_15840_ clknet_leaf_143_clk _00490_ VGND VGND VPWR VPWR cpuregs\[25\]\[6\] sky130_fd_sc_hd__dfxtp_1
XFILLER_0_99_532 VGND VGND VPWR VPWR sky130_fd_sc_hd__fill_1
X_15771_ clknet_leaf_144_clk _00421_ VGND VGND VPWR VPWR cpuregs\[26\]\[1\] sky130_fd_sc_hd__dfxtp_1
X_12983_ _06351_ _06475_ _03377_ VGND VGND VPWR VPWR _06476_ sky130_fd_sc_hd__a21o_1
XFILLER_0_115_28 VGND VGND VPWR VPWR sky130_fd_sc_hd__decap_4
XFILLER_0_115_17 VGND VGND VPWR VPWR sky130_fd_sc_hd__decap_4
X_14722_ _01719_ VGND VGND VPWR VPWR _01731_ sky130_fd_sc_hd__buf_4
XFILLER_0_87_727 VGND VGND VPWR VPWR sky130_fd_sc_hd__fill_1
X_11934_ count_instr\[36\] _05614_ count_instr\[37\] VGND VGND VPWR VPWR _05621_ sky130_fd_sc_hd__a21o_1
X_14653_ _01694_ VGND VGND VPWR VPWR _01198_ sky130_fd_sc_hd__clkbuf_1
X_13604_ cpuregs\[30\]\[24\] cpuregs\[31\]\[24\] _06510_ VGND VGND VPWR VPWR _07079_
+ sky130_fd_sc_hd__mux2_1
X_11865_ _05539_ _05570_ VGND VGND VPWR VPWR _05571_ sky130_fd_sc_hd__nor2_1
X_10816_ net692 _03577_ _04968_ VGND VGND VPWR VPWR _04969_ sky130_fd_sc_hd__mux2_1
XFILLER_0_95_782 VGND VGND VPWR VPWR sky130_fd_sc_hd__fill_2
XFILLER_0_54_101 VGND VGND VPWR VPWR sky130_fd_sc_hd__fill_1
X_11796_ decoder_trigger VGND VGND VPWR VPWR _05520_ sky130_fd_sc_hd__buf_4
X_14584_ _05003_ net1553 _01648_ VGND VGND VPWR VPWR _01658_ sky130_fd_sc_hd__mux2_1
X_10747_ net1178 _03584_ _04929_ VGND VGND VPWR VPWR _04931_ sky130_fd_sc_hd__mux2_1
X_13535_ cpuregs\[20\]\[22\] cpuregs\[21\]\[22\] _06784_ VGND VGND VPWR VPWR _07012_
+ sky130_fd_sc_hd__mux2_1
XFILLER_0_55_657 VGND VGND VPWR VPWR sky130_fd_sc_hd__fill_1
X_16323_ clknet_leaf_14_clk _00908_ VGND VGND VPWR VPWR decoded_imm_j\[2\] sky130_fd_sc_hd__dfxtp_2
X_16254_ clknet_leaf_39_clk alu_out\[27\] VGND VGND VPWR VPWR alu_out_q\[27\] sky130_fd_sc_hd__dfxtp_1
X_13466_ _03323_ VGND VGND VPWR VPWR _06945_ sky130_fd_sc_hd__buf_4
X_10678_ cpuregs\[4\]\[30\] cpuregs\[5\]\[30\] cpuregs\[6\]\[30\] cpuregs\[7\]\[30\]
+ _03894_ _04090_ VGND VGND VPWR VPWR _04884_ sky130_fd_sc_hd__mux4_1
XFILLER_0_82_465 VGND VGND VPWR VPWR sky130_fd_sc_hd__fill_2
XFILLER_0_55_679 VGND VGND VPWR VPWR sky130_fd_sc_hd__fill_1
X_12417_ _02166_ _06021_ _06023_ _05790_ _05746_ VGND VGND VPWR VPWR _06024_ sky130_fd_sc_hd__a32o_1
XFILLER_0_112_206 VGND VGND VPWR VPWR sky130_fd_sc_hd__fill_1
X_15205_ _01987_ VGND VGND VPWR VPWR _01457_ sky130_fd_sc_hd__clkbuf_1
XFILLER_0_23_532 VGND VGND VPWR VPWR sky130_fd_sc_hd__fill_2
Xoutput207 net207 VGND VGND VPWR VPWR pcpi_rs2[13] sky130_fd_sc_hd__clkbuf_4
X_13397_ _06773_ _06877_ VGND VGND VPWR VPWR _06878_ sky130_fd_sc_hd__and2_1
X_16185_ clknet_leaf_5_clk _00803_ VGND VGND VPWR VPWR mem_do_rinst sky130_fd_sc_hd__dfxtp_2
X_12348_ decoded_imm_j\[18\] _05731_ VGND VGND VPWR VPWR _05960_ sky130_fd_sc_hd__nand2_1
X_15136_ net694 _03524_ _01948_ VGND VGND VPWR VPWR _01951_ sky130_fd_sc_hd__mux2_1
XFILLER_0_50_362 VGND VGND VPWR VPWR sky130_fd_sc_hd__fill_2
XFILLER_0_10_204 VPWR VGND VPWR VGND sky130_ef_sc_hd__decap_12
Xoutput218 net218 VGND VGND VPWR VPWR pcpi_rs2[23] sky130_fd_sc_hd__clkbuf_4
Xoutput229 net229 VGND VGND VPWR VPWR pcpi_rs2[4] sky130_fd_sc_hd__clkbuf_4
XFILLER_0_120_261 VGND VGND VPWR VPWR sky130_fd_sc_hd__fill_2
XFILLER_0_120_250 VGND VGND VPWR VPWR sky130_fd_sc_hd__fill_2
X_12279_ _05852_ net545 _05816_ _05896_ VGND VGND VPWR VPWR _00687_ sky130_fd_sc_hd__o211a_1
X_15067_ _01914_ VGND VGND VPWR VPWR _01392_ sky130_fd_sc_hd__clkbuf_1
X_14018_ _07425_ VGND VGND VPWR VPWR _01119_ sky130_fd_sc_hd__clkbuf_1
XFILLER_0_65_66 VGND VGND VPWR VPWR sky130_fd_sc_hd__fill_1
XFILLER_0_65_55 VGND VGND VPWR VPWR sky130_fd_sc_hd__fill_1
X_15969_ clknet_leaf_148_clk _00619_ VGND VGND VPWR VPWR count_instr\[38\] sky130_fd_sc_hd__dfxtp_1
X_08510_ _02280_ _02886_ VGND VGND VPWR VPWR _02887_ sky130_fd_sc_hd__nor2_1
X_09490_ cpuregs\[30\]\[1\] cpuregs\[31\]\[1\] _03680_ VGND VGND VPWR VPWR _03725_
+ sky130_fd_sc_hd__mux2_1
X_08441_ _02735_ _02736_ net191 _02821_ VGND VGND VPWR VPWR _02822_ sky130_fd_sc_hd__a211o_1
XFILLER_0_81_32 VGND VGND VPWR VPWR sky130_fd_sc_hd__decap_8
XFILLER_0_77_248 VGND VGND VPWR VPWR sky130_fd_sc_hd__decap_8
XFILLER_0_77_237 VGND VGND VPWR VPWR sky130_fd_sc_hd__decap_8
XFILLER_0_14_70 VGND VGND VPWR VPWR sky130_fd_sc_hd__fill_1
X_08372_ net122 VGND VGND VPWR VPWR _02753_ sky130_fd_sc_hd__buf_4
XFILLER_0_18_337 VGND VGND VPWR VPWR sky130_fd_sc_hd__fill_1
XFILLER_0_6_754 VGND VGND VPWR VPWR sky130_fd_sc_hd__fill_2
XFILLER_0_6_743 VGND VGND VPWR VPWR sky130_fd_sc_hd__fill_2
XFILLER_0_83_3 VGND VGND VPWR VPWR sky130_fd_sc_hd__decap_4
XFILLER_0_5_242 VPWR VGND VPWR VGND sky130_ef_sc_hd__decap_12
XFILLER_0_112_773 VGND VGND VPWR VPWR sky130_fd_sc_hd__fill_1
XFILLER_0_10_793 VPWR VGND VPWR VGND sky130_ef_sc_hd__decap_12
XTAP_292 VGND VPWR sky130_fd_sc_hd__tapvpwrvgnd_1
X_09826_ _03984_ _04052_ _04054_ VGND VGND VPWR VPWR _04055_ sky130_fd_sc_hd__a21o_1
X_09757_ _03811_ _03987_ _03661_ VGND VGND VPWR VPWR _03988_ sky130_fd_sc_hd__a21o_1
XTAP_2115 VGND VPWR sky130_fd_sc_hd__tapvpwrvgnd_1
XTAP_2126 VGND VPWR sky130_fd_sc_hd__tapvpwrvgnd_1
XTAP_2104 VGND VPWR sky130_fd_sc_hd__tapvpwrvgnd_1
X_08708_ _03026_ _03038_ _03046_ _03057_ VGND VGND VPWR VPWR _03069_ sky130_fd_sc_hd__and4_1
XTAP_2159 VGND VPWR sky130_fd_sc_hd__tapvpwrvgnd_1
XTAP_2148 VGND VPWR sky130_fd_sc_hd__tapvpwrvgnd_1
XTAP_2137 VGND VPWR sky130_fd_sc_hd__tapvpwrvgnd_1
XTAP_1414 VGND VPWR sky130_fd_sc_hd__tapvpwrvgnd_1
XTAP_1403 VGND VPWR sky130_fd_sc_hd__tapvpwrvgnd_1
XFILLER_0_68_215 VGND VGND VPWR VPWR sky130_fd_sc_hd__fill_2
X_09688_ cpuregs\[24\]\[4\] cpuregs\[25\]\[4\] _03898_ VGND VGND VPWR VPWR _03920_
+ sky130_fd_sc_hd__mux2_1
X_08639_ _03005_ _02996_ _02993_ VGND VGND VPWR VPWR _03006_ sky130_fd_sc_hd__a21oi_1
XTAP_1447 VGND VPWR sky130_fd_sc_hd__tapvpwrvgnd_1
XTAP_1436 VGND VPWR sky130_fd_sc_hd__tapvpwrvgnd_1
XTAP_1425 VGND VPWR sky130_fd_sc_hd__tapvpwrvgnd_1
X_11650_ _05442_ VGND VGND VPWR VPWR _00512_ sky130_fd_sc_hd__clkbuf_1
XTAP_1469 VGND VPWR sky130_fd_sc_hd__tapvpwrvgnd_1
XTAP_1458 VGND VPWR sky130_fd_sc_hd__tapvpwrvgnd_1
XFILLER_0_77_793 VGND VGND VPWR VPWR sky130_fd_sc_hd__decap_4
X_11581_ _05043_ net1544 _05397_ VGND VGND VPWR VPWR _05406_ sky130_fd_sc_hd__mux2_1
X_10601_ _03900_ _04808_ _03730_ VGND VGND VPWR VPWR _04809_ sky130_fd_sc_hd__a21o_1
XFILLER_0_126_309 VGND VGND VPWR VPWR sky130_fd_sc_hd__fill_1
XFILLER_0_9_570 VGND VGND VPWR VPWR sky130_fd_sc_hd__fill_2
X_10532_ cpuregs\[28\]\[26\] cpuregs\[29\]\[26\] cpuregs\[30\]\[26\] cpuregs\[31\]\[26\]
+ _03941_ _03942_ VGND VGND VPWR VPWR _04742_ sky130_fd_sc_hd__mux4_1
X_13320_ _06803_ net209 _06629_ VGND VGND VPWR VPWR _06804_ sky130_fd_sc_hd__mux2_1
XFILLER_0_91_251 VGND VGND VPWR VPWR sky130_fd_sc_hd__decap_6
XFILLER_0_9_581 VGND VGND VPWR VPWR sky130_fd_sc_hd__decap_4
XFILLER_0_107_589 VGND VGND VPWR VPWR sky130_fd_sc_hd__fill_1
XFILLER_0_33_830 VGND VGND VPWR VPWR sky130_fd_sc_hd__fill_2
X_10463_ _04516_ _04544_ _04672_ _04674_ VGND VGND VPWR VPWR _04675_ sky130_fd_sc_hd__o31a_1
X_13251_ _06639_ _06735_ VGND VGND VPWR VPWR _06736_ sky130_fd_sc_hd__and2_1
X_10394_ reg_pc\[22\] _03992_ _04601_ _04607_ _03702_ VGND VGND VPWR VPWR _04608_
+ sky130_fd_sc_hd__a221o_1
X_12202_ _05817_ _05825_ _05695_ VGND VGND VPWR VPWR _05826_ sky130_fd_sc_hd__o21ai_1
X_13182_ _06537_ _06665_ _06668_ VGND VGND VPWR VPWR _06669_ sky130_fd_sc_hd__a21o_1
X_12133_ _05741_ net1639 _05725_ _05762_ VGND VGND VPWR VPWR _00675_ sky130_fd_sc_hd__o211a_1
X_16941_ clknet_leaf_72_clk _01505_ VGND VGND VPWR VPWR cpuregs\[0\]\[28\] sky130_fd_sc_hd__dfxtp_1
X_12064_ _03514_ reg_next_pc\[11\] _03222_ VGND VGND VPWR VPWR _05714_ sky130_fd_sc_hd__mux2_2
X_11015_ _05090_ VGND VGND VPWR VPWR _00229_ sky130_fd_sc_hd__clkbuf_1
X_16872_ clknet_leaf_63_clk _01436_ VGND VGND VPWR VPWR cpuregs\[22\]\[23\] sky130_fd_sc_hd__dfxtp_1
X_15823_ clknet_leaf_43_clk _00473_ VGND VGND VPWR VPWR cpuregs\[16\]\[21\] sky130_fd_sc_hd__dfxtp_1
XFILLER_0_126_27 VGND VGND VPWR VPWR sky130_fd_sc_hd__fill_1
XFILLER_0_87_513 VGND VGND VPWR VPWR sky130_fd_sc_hd__fill_1
X_15754_ clknet_leaf_88_clk _00404_ VGND VGND VPWR VPWR cpuregs\[15\]\[16\] sky130_fd_sc_hd__dfxtp_1
X_14705_ _01722_ VGND VGND VPWR VPWR _01222_ sky130_fd_sc_hd__clkbuf_1
X_12966_ cpuregs\[28\]\[5\] cpuregs\[29\]\[5\] _06349_ VGND VGND VPWR VPWR _06460_
+ sky130_fd_sc_hd__mux2_1
X_15685_ clknet_leaf_132_clk _00335_ VGND VGND VPWR VPWR cpuregs\[27\]\[11\] sky130_fd_sc_hd__dfxtp_1
X_12897_ _03345_ _06394_ _03310_ VGND VGND VPWR VPWR _06395_ sky130_fd_sc_hd__a21o_1
X_11917_ _05608_ VGND VGND VPWR VPWR _00613_ sky130_fd_sc_hd__clkbuf_1
XFILLER_0_129_136 VPWR VGND VPWR VGND sky130_ef_sc_hd__decap_12
XTAP_1970 VGND VPWR sky130_fd_sc_hd__tapvpwrvgnd_1
X_11848_ _05557_ _05530_ _05558_ VGND VGND VPWR VPWR _05559_ sky130_fd_sc_hd__and3b_1
X_14636_ net1635 _05163_ _01684_ VGND VGND VPWR VPWR _01686_ sky130_fd_sc_hd__mux2_1
XTAP_1992 VGND VPWR sky130_fd_sc_hd__tapvpwrvgnd_1
XTAP_1981 VGND VPWR sky130_fd_sc_hd__tapvpwrvgnd_1
XFILLER_0_67_281 VGND VGND VPWR VPWR sky130_fd_sc_hd__fill_2
XFILLER_0_51_57 VGND VGND VPWR VPWR sky130_fd_sc_hd__decap_3
X_14567_ _01649_ VGND VGND VPWR VPWR _01157_ sky130_fd_sc_hd__clkbuf_1
X_11779_ _05037_ net1007 _05505_ VGND VGND VPWR VPWR _05511_ sky130_fd_sc_hd__mux2_1
X_13518_ cpuregs\[12\]\[22\] cpuregs\[13\]\[22\] cpuregs\[14\]\[22\] cpuregs\[15\]\[22\]
+ _06696_ _06728_ VGND VGND VPWR VPWR _06995_ sky130_fd_sc_hd__mux4_1
XFILLER_0_82_251 VGND VGND VPWR VPWR sky130_fd_sc_hd__fill_1
X_16306_ clknet_leaf_26_clk _00891_ VGND VGND VPWR VPWR decoded_imm_j\[10\] sky130_fd_sc_hd__dfxtp_1
XFILLER_0_55_465 VGND VGND VPWR VPWR sky130_fd_sc_hd__decap_4
XFILLER_0_27_145 VPWR VGND VPWR VGND sky130_ef_sc_hd__decap_12
XFILLER_0_70_446 VGND VGND VPWR VPWR sky130_fd_sc_hd__decap_4
X_14498_ net1137 _05159_ _01612_ VGND VGND VPWR VPWR _01613_ sky130_fd_sc_hd__mux2_1
XFILLER_0_15_329 VGND VGND VPWR VPWR sky130_fd_sc_hd__decap_4
X_13449_ _06762_ _06915_ _06928_ _06802_ decoded_imm\[19\] VGND VGND VPWR VPWR _06929_
+ sky130_fd_sc_hd__a32o_1
X_16237_ clknet_leaf_20_clk alu_out\[10\] VGND VGND VPWR VPWR alu_out_q\[10\] sky130_fd_sc_hd__dfxtp_1
XFILLER_0_3_735 VPWR VGND VPWR VGND sky130_ef_sc_hd__decap_12
X_16168_ clknet_leaf_7_clk _00786_ VGND VGND VPWR VPWR net41 sky130_fd_sc_hd__dfxtp_1
XFILLER_0_11_502 VGND VGND VPWR VPWR sky130_fd_sc_hd__fill_2
XFILLER_0_50_192 VGND VGND VPWR VPWR sky130_fd_sc_hd__fill_1
X_15119_ net796 _03471_ _01937_ VGND VGND VPWR VPWR _01942_ sky130_fd_sc_hd__mux2_1
X_08990_ reg_out\[29\] reg_next_pc\[29\] _03270_ VGND VGND VPWR VPWR _03285_ sky130_fd_sc_hd__mux2_1
XFILLER_0_121_581 VGND VGND VPWR VPWR sky130_fd_sc_hd__decap_8
X_16099_ clknet_leaf_145_clk _00749_ VGND VGND VPWR VPWR count_cycle\[42\] sky130_fd_sc_hd__dfxtp_1
XFILLER_0_76_65 VGND VGND VPWR VPWR sky130_fd_sc_hd__fill_2
X_07941_ count_instr\[41\] _02269_ _02235_ _02344_ VGND VGND VPWR VPWR _02345_ sky130_fd_sc_hd__a211o_1
X_07872_ net4 net21 _02213_ VGND VGND VPWR VPWR _02281_ sky130_fd_sc_hd__mux2_1
X_09611_ instr_srl instr_srli _03648_ VGND VGND VPWR VPWR _03845_ sky130_fd_sc_hd__nor3_4
X_09542_ _03657_ _03748_ _03773_ _03776_ reg_pc\[1\] VGND VGND VPWR VPWR _03777_ sky130_fd_sc_hd__a32o_1
XFILLER_0_93_505 VGND VGND VPWR VPWR sky130_fd_sc_hd__decap_3
Xclkbuf_leaf_90_clk clknet_4_14_0_clk VGND VGND VPWR VPWR clknet_leaf_90_clk sky130_fd_sc_hd__clkbuf_16
X_09473_ cpu_state\[4\] _02080_ VGND VGND VPWR VPWR _03709_ sky130_fd_sc_hd__nor2_2
X_08424_ net176 _02688_ VGND VGND VPWR VPWR _02805_ sky130_fd_sc_hd__and2b_1
XFILLER_0_59_782 VGND VGND VPWR VPWR sky130_fd_sc_hd__fill_2
X_08355_ net192 net224 VGND VGND VPWR VPWR _02736_ sky130_fd_sc_hd__or2_1
XFILLER_0_108_309 VGND VGND VPWR VPWR sky130_fd_sc_hd__decap_4
XFILLER_0_74_752 VGND VGND VPWR VPWR sky130_fd_sc_hd__decap_4
XFILLER_0_46_421 VGND VGND VPWR VPWR sky130_fd_sc_hd__decap_3
XFILLER_0_132_70 VGND VGND VPWR VPWR sky130_fd_sc_hd__fill_2
XFILLER_0_73_262 VGND VGND VPWR VPWR sky130_fd_sc_hd__decap_4
XFILLER_0_18_145 VGND VGND VPWR VPWR sky130_fd_sc_hd__fill_2
XFILLER_0_132_813 VPWR VGND VPWR VGND sky130_ef_sc_hd__decap_12
XFILLER_0_73_273 VGND VGND VPWR VPWR sky130_fd_sc_hd__decap_4
X_08286_ net197 net251 VGND VGND VPWR VPWR _02667_ sky130_fd_sc_hd__or2_1
XFILLER_0_15_830 VGND VGND VPWR VPWR sky130_fd_sc_hd__fill_2
XFILLER_0_116_375 VGND VGND VPWR VPWR sky130_fd_sc_hd__fill_1
XFILLER_0_6_584 VGND VGND VPWR VPWR sky130_fd_sc_hd__fill_2
XFILLER_0_100_787 VGND VGND VPWR VPWR sky130_fd_sc_hd__fill_2
X_09809_ cpuregs\[14\]\[7\] cpuregs\[15\]\[7\] _03665_ VGND VGND VPWR VPWR _04038_
+ sky130_fd_sc_hd__mux2_1
X_12820_ net56 net87 _06293_ VGND VGND VPWR VPWR _06325_ sky130_fd_sc_hd__mux2_1
X_12751_ _06254_ _06255_ _06284_ VGND VGND VPWR VPWR _06285_ sky130_fd_sc_hd__o21bai_1
XTAP_1222 VGND VPWR sky130_fd_sc_hd__tapvpwrvgnd_1
XTAP_1211 VGND VPWR sky130_fd_sc_hd__tapvpwrvgnd_1
XTAP_1200 VGND VPWR sky130_fd_sc_hd__tapvpwrvgnd_1
Xclkbuf_leaf_81_clk clknet_4_14_0_clk VGND VGND VPWR VPWR clknet_leaf_81_clk sky130_fd_sc_hd__clkbuf_16
X_11702_ _05470_ VGND VGND VPWR VPWR _00536_ sky130_fd_sc_hd__clkbuf_1
X_15470_ clknet_leaf_83_clk _00120_ VGND VGND VPWR VPWR cpuregs\[12\]\[20\] sky130_fd_sc_hd__dfxtp_1
XTAP_1266 VGND VPWR sky130_fd_sc_hd__tapvpwrvgnd_1
XTAP_1255 VGND VPWR sky130_fd_sc_hd__tapvpwrvgnd_1
XTAP_1244 VGND VPWR sky130_fd_sc_hd__tapvpwrvgnd_1
XTAP_1233 VGND VPWR sky130_fd_sc_hd__tapvpwrvgnd_1
X_12682_ net418 _06225_ _02185_ VGND VGND VPWR VPWR _06227_ sky130_fd_sc_hd__o21ai_1
X_14421_ _01571_ VGND VGND VPWR VPWR _01057_ sky130_fd_sc_hd__clkbuf_1
XFILLER_0_108_810 VGND VGND VPWR VPWR sky130_fd_sc_hd__fill_2
X_11633_ _05026_ net676 _05433_ VGND VGND VPWR VPWR _05434_ sky130_fd_sc_hd__mux2_1
XTAP_1299 VGND VPWR sky130_fd_sc_hd__tapvpwrvgnd_1
XTAP_1288 VGND VPWR sky130_fd_sc_hd__tapvpwrvgnd_1
XTAP_1277 VGND VPWR sky130_fd_sc_hd__tapvpwrvgnd_1
XFILLER_0_135_673 VGND VGND VPWR VPWR sky130_fd_sc_hd__fill_2
X_11564_ _05374_ VGND VGND VPWR VPWR _05397_ sky130_fd_sc_hd__buf_4
X_14352_ _06025_ decoded_imm_j\[3\] _07567_ net585 _07388_ VGND VGND VPWR VPWR _07610_
+ sky130_fd_sc_hd__a221o_1
XFILLER_0_135_695 VGND VGND VPWR VPWR sky130_fd_sc_hd__fill_1
X_10515_ _04724_ _04688_ _04686_ VGND VGND VPWR VPWR _04725_ sky130_fd_sc_hd__o21a_1
X_11495_ _05337_ VGND VGND VPWR VPWR _05360_ sky130_fd_sc_hd__buf_4
X_13303_ cpuregs\[22\]\[15\] cpuregs\[23\]\[15\] _06786_ VGND VGND VPWR VPWR _06787_
+ sky130_fd_sc_hd__mux2_1
X_14283_ _07568_ VGND VGND VPWR VPWR _07569_ sky130_fd_sc_hd__buf_2
XFILLER_0_134_194 VGND VGND VPWR VPWR sky130_fd_sc_hd__fill_2
X_16022_ clknet_leaf_35_clk _00672_ VGND VGND VPWR VPWR reg_pc\[28\] sky130_fd_sc_hd__dfxtp_2
X_10446_ _03719_ _04657_ VGND VGND VPWR VPWR _04658_ sky130_fd_sc_hd__nand2_1
X_13234_ cpuregs\[28\]\[13\] cpuregs\[29\]\[13\] _06687_ VGND VGND VPWR VPWR _06720_
+ sky130_fd_sc_hd__mux2_1
XFILLER_0_110_507 VGND VGND VPWR VPWR sky130_fd_sc_hd__fill_2
X_10377_ cpuregs\[12\]\[22\] cpuregs\[13\]\[22\] _03976_ VGND VGND VPWR VPWR _04591_
+ sky130_fd_sc_hd__mux2_1
X_13165_ _03341_ _06652_ VGND VGND VPWR VPWR _06653_ sky130_fd_sc_hd__and2_1
XFILLER_0_0_749 VGND VGND VPWR VPWR sky130_fd_sc_hd__decap_6
X_12116_ _03614_ reg_next_pc\[26\] _03224_ VGND VGND VPWR VPWR _05751_ sky130_fd_sc_hd__mux2_4
X_13096_ _06518_ _06585_ VGND VGND VPWR VPWR _06586_ sky130_fd_sc_hd__or2_1
X_12047_ _05690_ reg_pc\[5\] VGND VGND VPWR VPWR _05703_ sky130_fd_sc_hd__or2_1
X_16924_ clknet_leaf_102_clk _01488_ VGND VGND VPWR VPWR cpuregs\[0\]\[11\] sky130_fd_sc_hd__dfxtp_1
X_16855_ clknet_leaf_141_clk _01419_ VGND VGND VPWR VPWR cpuregs\[22\]\[6\] sky130_fd_sc_hd__dfxtp_1
XFILLER_0_88_811 VGND VGND VPWR VPWR sky130_fd_sc_hd__fill_1
X_15806_ clknet_leaf_126_clk _00456_ VGND VGND VPWR VPWR cpuregs\[16\]\[4\] sky130_fd_sc_hd__dfxtp_1
X_13998_ mem_rdata_q\[25\] mem_rdata_q\[24\] mem_rdata_q\[23\] mem_rdata_q\[22\] VGND
+ VGND VPWR VPWR _07413_ sky130_fd_sc_hd__or4_1
X_16786_ clknet_leaf_120_clk _01350_ VGND VGND VPWR VPWR cpuregs\[6\]\[1\] sky130_fd_sc_hd__dfxtp_1
XFILLER_0_1_26 VGND VGND VPWR VPWR sky130_fd_sc_hd__fill_1
XFILLER_0_87_354 VGND VGND VPWR VPWR sky130_fd_sc_hd__fill_2
X_15737_ clknet_leaf_96_clk _00387_ VGND VGND VPWR VPWR cpuregs\[21\]\[31\] sky130_fd_sc_hd__dfxtp_1
X_12949_ _03323_ VGND VGND VPWR VPWR _06443_ sky130_fd_sc_hd__buf_6
Xclkbuf_leaf_72_clk clknet_4_15_0_clk VGND VGND VPWR VPWR clknet_leaf_72_clk sky130_fd_sc_hd__clkbuf_16
X_15668_ clknet_leaf_80_clk _00318_ VGND VGND VPWR VPWR cpuregs\[14\]\[26\] sky130_fd_sc_hd__dfxtp_1
XFILLER_0_62_56 VGND VGND VPWR VPWR sky130_fd_sc_hd__fill_1
XFILLER_0_8_805 VGND VGND VPWR VPWR sky130_fd_sc_hd__decap_6
X_14619_ _01676_ VGND VGND VPWR VPWR _01182_ sky130_fd_sc_hd__clkbuf_1
X_15599_ clknet_leaf_60_clk _00249_ VGND VGND VPWR VPWR cpuregs\[28\]\[21\] sky130_fd_sc_hd__dfxtp_1
X_08140_ _02529_ _02530_ VGND VGND VPWR VPWR _02531_ sky130_fd_sc_hd__nand2_1
XFILLER_0_126_640 VGND VGND VPWR VPWR sky130_fd_sc_hd__fill_1
X_08071_ net9 _02466_ _02428_ VGND VGND VPWR VPWR _02467_ sky130_fd_sc_hd__a21o_1
XFILLER_0_3_521 VGND VGND VPWR VPWR sky130_fd_sc_hd__fill_2
XFILLER_0_140_197 VGND VGND VPWR VPWR sky130_fd_sc_hd__fill_2
X_08973_ _02548_ _03273_ _03268_ VGND VGND VPWR VPWR _03274_ sky130_fd_sc_hd__mux2_1
XFILLER_0_11_387 VGND VGND VPWR VPWR sky130_fd_sc_hd__fill_2
X_07924_ _02323_ _02324_ _02329_ VGND VGND VPWR VPWR _02330_ sky130_fd_sc_hd__a21oi_1
Xhold28 instr_lbu VGND VGND VPWR VPWR net386 sky130_fd_sc_hd__dlygate4sd3_1
Xhold39 decoded_rd\[1\] VGND VGND VPWR VPWR net397 sky130_fd_sc_hd__dlygate4sd3_1
X_07855_ count_instr\[3\] _02236_ count_cycle\[3\] _02173_ _02264_ VGND VGND VPWR
+ VPWR _02265_ sky130_fd_sc_hd__a221o_1
X_07786_ _02199_ VGND VGND VPWR VPWR _02200_ sky130_fd_sc_hd__clkbuf_4
XFILLER_0_78_332 VGND VGND VPWR VPWR sky130_fd_sc_hd__fill_1
X_09525_ _03724_ _03759_ VGND VGND VPWR VPWR _03760_ sky130_fd_sc_hd__or2_1
Xclkbuf_leaf_63_clk clknet_4_13_0_clk VGND VGND VPWR VPWR clknet_leaf_63_clk sky130_fd_sc_hd__clkbuf_16
XFILLER_0_78_376 VGND VGND VPWR VPWR sky130_fd_sc_hd__fill_2
XFILLER_0_66_505 VGND VGND VPWR VPWR sky130_fd_sc_hd__fill_1
X_09456_ _03663_ _03691_ VGND VGND VPWR VPWR _03692_ sky130_fd_sc_hd__nor2_1
X_08407_ net199 _02664_ VGND VGND VPWR VPWR _02788_ sky130_fd_sc_hd__or2b_1
X_09387_ _03433_ _03626_ VGND VGND VPWR VPWR _03627_ sky130_fd_sc_hd__nor2_1
XFILLER_0_108_139 VGND VGND VPWR VPWR sky130_fd_sc_hd__fill_1
XFILLER_0_108_117 VPWR VGND VPWR VGND sky130_ef_sc_hd__decap_12
XFILLER_0_47_785 VGND VGND VPWR VPWR sky130_fd_sc_hd__fill_1
XFILLER_0_117_640 VGND VGND VPWR VPWR sky130_fd_sc_hd__fill_1
X_08338_ net180 net246 VGND VGND VPWR VPWR _02719_ sky130_fd_sc_hd__xnor2_1
XFILLER_0_117_673 VGND VGND VPWR VPWR sky130_fd_sc_hd__fill_2
X_08269_ _02639_ _02644_ _02650_ VGND VGND VPWR VPWR _02651_ sky130_fd_sc_hd__a21oi_1
XFILLER_0_105_824 VGND VGND VPWR VPWR sky130_fd_sc_hd__fill_2
XFILLER_0_62_755 VGND VGND VPWR VPWR sky130_fd_sc_hd__fill_1
XFILLER_0_61_254 VGND VGND VPWR VPWR sky130_fd_sc_hd__fill_2
XFILLER_0_132_643 VGND VGND VPWR VPWR sky130_fd_sc_hd__fill_1
XFILLER_0_116_183 VGND VGND VPWR VPWR sky130_fd_sc_hd__fill_2
X_10300_ _04511_ _04514_ VGND VGND VPWR VPWR _04516_ sky130_fd_sc_hd__nand2_2
X_11280_ net1002 _05192_ _05240_ VGND VGND VPWR VPWR _05246_ sky130_fd_sc_hd__mux2_1
XFILLER_0_62_799 VGND VGND VPWR VPWR sky130_fd_sc_hd__fill_1
XFILLER_0_61_276 VGND VGND VPWR VPWR sky130_fd_sc_hd__decap_4
X_10231_ _03365_ _04448_ VGND VGND VPWR VPWR _04449_ sky130_fd_sc_hd__or2_1
X_10162_ cpuregs\[12\]\[16\] cpuregs\[13\]\[16\] _03976_ VGND VGND VPWR VPWR _04382_
+ sky130_fd_sc_hd__mux2_1
XFILLER_0_100_573 VGND VGND VPWR VPWR sky130_fd_sc_hd__fill_1
X_14970_ _01862_ VGND VGND VPWR VPWR _01347_ sky130_fd_sc_hd__clkbuf_1
X_10093_ _03747_ _04308_ _04314_ VGND VGND VPWR VPWR _04315_ sky130_fd_sc_hd__or3_2
X_13921_ _07327_ _07360_ VGND VGND VPWR VPWR _07361_ sky130_fd_sc_hd__nor2_1
X_16640_ clknet_leaf_56_clk _01207_ VGND VGND VPWR VPWR cpuregs\[23\]\[18\] sky130_fd_sc_hd__dfxtp_1
X_13852_ mem_rdata_q\[2\] net23 _03291_ VGND VGND VPWR VPWR _07311_ sky130_fd_sc_hd__mux2_1
X_16571_ clknet_leaf_45_clk _01148_ VGND VGND VPWR VPWR cpuregs\[24\]\[23\] sky130_fd_sc_hd__dfxtp_1
X_13783_ cpuregs\[28\]\[30\] cpuregs\[29\]\[30\] _07018_ VGND VGND VPWR VPWR _07252_
+ sky130_fd_sc_hd__mux2_1
XFILLER_0_85_803 VGND VGND VPWR VPWR sky130_fd_sc_hd__fill_2
X_12803_ _06316_ VGND VGND VPWR VPWR _00791_ sky130_fd_sc_hd__clkbuf_1
X_10995_ _05079_ VGND VGND VPWR VPWR _00220_ sky130_fd_sc_hd__clkbuf_1
Xclkbuf_leaf_54_clk clknet_4_6_0_clk VGND VGND VPWR VPWR clknet_leaf_54_clk sky130_fd_sc_hd__clkbuf_16
XFILLER_0_85_814 VGND VGND VPWR VPWR sky130_fd_sc_hd__fill_1
XFILLER_0_84_313 VGND VGND VPWR VPWR sky130_fd_sc_hd__fill_1
X_12734_ _03796_ _06263_ _06267_ _03658_ VGND VGND VPWR VPWR _06268_ sky130_fd_sc_hd__o211a_1
XTAP_1030 VGND VPWR sky130_fd_sc_hd__tapvpwrvgnd_1
X_15522_ clknet_leaf_113_clk _00172_ VGND VGND VPWR VPWR cpuregs\[13\]\[8\] sky130_fd_sc_hd__dfxtp_1
XFILLER_0_123_28 VPWR VGND VPWR VGND sky130_ef_sc_hd__decap_12
XFILLER_0_96_195 VGND VGND VPWR VPWR sky130_fd_sc_hd__fill_1
XFILLER_0_84_335 VGND VGND VPWR VPWR sky130_fd_sc_hd__decap_8
XTAP_1063 VGND VPWR sky130_fd_sc_hd__tapvpwrvgnd_1
XTAP_1074 VGND VPWR sky130_fd_sc_hd__tapvpwrvgnd_1
XTAP_1052 VGND VPWR sky130_fd_sc_hd__tapvpwrvgnd_1
XTAP_1041 VGND VPWR sky130_fd_sc_hd__tapvpwrvgnd_1
XFILLER_0_32_26 VGND VGND VPWR VPWR sky130_fd_sc_hd__fill_2
XTAP_1096 VGND VPWR sky130_fd_sc_hd__tapvpwrvgnd_1
XTAP_1085 VGND VPWR sky130_fd_sc_hd__tapvpwrvgnd_1
X_12665_ _02141_ _06213_ _06214_ VGND VGND VPWR VPWR _06215_ sky130_fd_sc_hd__and3_1
X_15453_ clknet_leaf_122_clk _00103_ VGND VGND VPWR VPWR cpuregs\[12\]\[3\] sky130_fd_sc_hd__dfxtp_1
XFILLER_0_32_59 VGND VGND VPWR VPWR sky130_fd_sc_hd__decap_3
X_14404_ _05026_ net1091 _01562_ VGND VGND VPWR VPWR _01563_ sky130_fd_sc_hd__mux2_1
X_11616_ _05010_ net746 _05422_ VGND VGND VPWR VPWR _05425_ sky130_fd_sc_hd__mux2_1
X_12596_ count_cycle\[26\] count_cycle\[27\] _06156_ count_cycle\[28\] VGND VGND VPWR
+ VPWR _06166_ sky130_fd_sc_hd__a31o_1
XFILLER_0_25_413 VGND VGND VPWR VPWR sky130_fd_sc_hd__decap_3
XFILLER_0_37_273 VGND VGND VPWR VPWR sky130_fd_sc_hd__decap_6
X_15384_ clknet_leaf_101_clk _00039_ VGND VGND VPWR VPWR cpuregs\[11\]\[2\] sky130_fd_sc_hd__dfxtp_1
XFILLER_0_114_109 VGND VGND VPWR VPWR sky130_fd_sc_hd__fill_2
XFILLER_0_108_695 VGND VGND VPWR VPWR sky130_fd_sc_hd__fill_2
XFILLER_0_80_530 VGND VGND VPWR VPWR sky130_fd_sc_hd__fill_2
X_11547_ _05388_ VGND VGND VPWR VPWR _00463_ sky130_fd_sc_hd__clkbuf_1
X_14335_ decoded_imm\[11\] _07587_ _07599_ _07600_ VGND VGND VPWR VPWR _01018_ sky130_fd_sc_hd__o22a_1
XFILLER_0_123_643 VGND VGND VPWR VPWR sky130_fd_sc_hd__fill_1
Xhold509 cpuregs\[17\]\[8\] VGND VGND VPWR VPWR net867 sky130_fd_sc_hd__dlygate4sd3_1
Xmax_cap239 _02559_ VGND VGND VPWR VPWR net239 sky130_fd_sc_hd__buf_1
X_16005_ clknet_leaf_25_clk _00655_ VGND VGND VPWR VPWR reg_pc\[11\] sky130_fd_sc_hd__dfxtp_2
X_11478_ _05351_ VGND VGND VPWR VPWR _00431_ sky130_fd_sc_hd__clkbuf_1
X_14266_ _02085_ _07292_ _07294_ VGND VGND VPWR VPWR _07559_ sky130_fd_sc_hd__or3_1
X_10429_ _03817_ _04635_ _04641_ VGND VGND VPWR VPWR _04642_ sky130_fd_sc_hd__or3_1
XFILLER_0_122_197 VGND VGND VPWR VPWR sky130_fd_sc_hd__fill_1
X_14197_ net514 _02753_ _07519_ VGND VGND VPWR VPWR _07523_ sky130_fd_sc_hd__mux2_1
X_13217_ _06535_ _06697_ _06702_ _06542_ VGND VGND VPWR VPWR _06703_ sky130_fd_sc_hd__o211a_1
X_13148_ _06537_ _06633_ _06635_ VGND VGND VPWR VPWR _06636_ sky130_fd_sc_hd__a21o_1
XTAP_803 VGND VPWR sky130_fd_sc_hd__tapvpwrvgnd_1
XTAP_814 VGND VPWR sky130_fd_sc_hd__tapvpwrvgnd_1
XTAP_825 VGND VPWR sky130_fd_sc_hd__tapvpwrvgnd_1
XTAP_836 VGND VPWR sky130_fd_sc_hd__tapvpwrvgnd_1
XTAP_847 VGND VPWR sky130_fd_sc_hd__tapvpwrvgnd_1
XTAP_858 VGND VPWR sky130_fd_sc_hd__tapvpwrvgnd_1
Xhold1209 cpuregs\[16\]\[8\] VGND VGND VPWR VPWR net1567 sky130_fd_sc_hd__dlygate4sd3_1
XTAP_869 VGND VPWR sky130_fd_sc_hd__tapvpwrvgnd_1
X_13079_ cpuregs\[12\]\[9\] cpuregs\[13\]\[9\] cpuregs\[14\]\[9\] cpuregs\[15\]\[9\]
+ _06418_ _06419_ VGND VGND VPWR VPWR _06569_ sky130_fd_sc_hd__mux4_1
X_16907_ clknet_leaf_81_clk _01471_ VGND VGND VPWR VPWR cpuregs\[8\]\[26\] sky130_fd_sc_hd__dfxtp_1
X_16838_ clknet_leaf_74_clk _01402_ VGND VGND VPWR VPWR cpuregs\[7\]\[21\] sky130_fd_sc_hd__dfxtp_1
X_16769_ clknet_leaf_86_clk _01333_ VGND VGND VPWR VPWR cpuregs\[5\]\[16\] sky130_fd_sc_hd__dfxtp_1
XFILLER_0_18_7 VGND VGND VPWR VPWR sky130_fd_sc_hd__fill_2
Xclkbuf_leaf_45_clk clknet_4_7_0_clk VGND VGND VPWR VPWR clknet_leaf_45_clk sky130_fd_sc_hd__clkbuf_16
X_09310_ reg_out\[18\] alu_out_q\[18\] _03436_ VGND VGND VPWR VPWR _03560_ sky130_fd_sc_hd__mux2_1
XFILLER_0_8_613 VGND VGND VPWR VPWR sky130_fd_sc_hd__decap_4
X_09241_ reg_pc\[9\] reg_pc\[8\] _03487_ VGND VGND VPWR VPWR _03500_ sky130_fd_sc_hd__and3_1
XFILLER_0_113_50 VGND VGND VPWR VPWR sky130_fd_sc_hd__fill_1
XFILLER_0_56_571 VGND VGND VPWR VPWR sky130_fd_sc_hd__fill_1
XFILLER_0_7_156 VGND VGND VPWR VPWR sky130_fd_sc_hd__fill_1
X_09172_ _03439_ VGND VGND VPWR VPWR _03440_ sky130_fd_sc_hd__buf_2
XFILLER_0_44_755 VGND VGND VPWR VPWR sky130_fd_sc_hd__fill_1
X_08123_ count_instr\[21\] _02201_ _02233_ count_instr\[53\] VGND VGND VPWR VPWR _02515_
+ sky130_fd_sc_hd__a22o_1
XFILLER_0_43_221 VGND VGND VPWR VPWR sky130_fd_sc_hd__decap_3
X_08054_ count_instr\[16\] _02236_ count_cycle\[48\] _02237_ VGND VGND VPWR VPWR _02451_
+ sky130_fd_sc_hd__a22o_1
XFILLER_0_43_265 VGND VGND VPWR VPWR sky130_fd_sc_hd__fill_1
XFILLER_0_98_85 VPWR VGND VPWR VGND sky130_ef_sc_hd__decap_12
Xpicorv32_262 VGND VGND VPWR VPWR picorv32_262/HI eoi[9] sky130_fd_sc_hd__conb_1
Xpicorv32_284 VGND VGND VPWR VPWR picorv32_284/HI eoi[31] sky130_fd_sc_hd__conb_1
Xpicorv32_273 VGND VGND VPWR VPWR picorv32_273/HI eoi[20] sky130_fd_sc_hd__conb_1
Xpicorv32_295 VGND VGND VPWR VPWR picorv32_295/HI pcpi_insn[6] sky130_fd_sc_hd__conb_1
X_08956_ _02480_ _03261_ _03246_ VGND VGND VPWR VPWR _03262_ sky130_fd_sc_hd__mux2_1
X_08887_ _02664_ net217 _02209_ VGND VGND VPWR VPWR _03219_ sky130_fd_sc_hd__mux2_2
X_07907_ _02309_ _02310_ _02313_ _02194_ _02199_ VGND VGND VPWR VPWR _02314_ sky130_fd_sc_hd__a221o_1
X_07838_ net23 net130 _02248_ _02219_ VGND VGND VPWR VPWR _02249_ sky130_fd_sc_hd__a22o_1
Xclkbuf_leaf_36_clk clknet_4_5_0_clk VGND VGND VPWR VPWR clknet_leaf_36_clk sky130_fd_sc_hd__clkbuf_16
XFILLER_0_78_151 VPWR VGND VPWR VGND sky130_ef_sc_hd__decap_12
X_09508_ cpuregs\[16\]\[1\] cpuregs\[17\]\[1\] _03680_ VGND VGND VPWR VPWR _03743_
+ sky130_fd_sc_hd__mux2_1
X_07769_ _02179_ _02184_ _02186_ VGND VGND VPWR VPWR _00021_ sky130_fd_sc_hd__a21oi_1
XPHY_124 VGND VGND VPWR VPWR sky130_fd_sc_hd__decap_3
XPHY_113 VGND VGND VPWR VPWR sky130_fd_sc_hd__decap_3
XPHY_102 VGND VGND VPWR VPWR sky130_fd_sc_hd__decap_3
X_10780_ net713 _03464_ _04946_ VGND VGND VPWR VPWR _04950_ sky130_fd_sc_hd__mux2_1
XFILLER_0_94_666 VGND VGND VPWR VPWR sky130_fd_sc_hd__fill_1
XPHY_157 VGND VGND VPWR VPWR sky130_fd_sc_hd__decap_3
XPHY_146 VGND VGND VPWR VPWR sky130_fd_sc_hd__decap_3
XPHY_135 VGND VGND VPWR VPWR sky130_fd_sc_hd__decap_3
X_09439_ _03674_ VGND VGND VPWR VPWR _03675_ sky130_fd_sc_hd__buf_4
XFILLER_0_137_779 VGND VGND VPWR VPWR sky130_fd_sc_hd__decap_4
X_12450_ _05519_ reg_next_pc\[26\] VGND VGND VPWR VPWR _06054_ sky130_fd_sc_hd__or2_1
XFILLER_0_93_198 VGND VGND VPWR VPWR sky130_fd_sc_hd__fill_2
XPHY_179 VGND VGND VPWR VPWR sky130_fd_sc_hd__decap_3
XPHY_168 VGND VGND VPWR VPWR sky130_fd_sc_hd__decap_3
XFILLER_0_124_418 VGND VGND VPWR VPWR sky130_fd_sc_hd__fill_2
X_11401_ _05310_ VGND VGND VPWR VPWR _00395_ sky130_fd_sc_hd__clkbuf_1
XANTENNA_91 net127 VGND VGND VPWR VPWR sky130_fd_sc_hd__diode_2
X_12381_ _05971_ _05982_ VGND VGND VPWR VPWR _05990_ sky130_fd_sc_hd__and2_1
XANTENNA_80 net112 VGND VGND VPWR VPWR sky130_fd_sc_hd__diode_2
X_14120_ _07479_ VGND VGND VPWR VPWR _00924_ sky130_fd_sc_hd__clkbuf_1
X_11332_ _04999_ net1599 _05266_ VGND VGND VPWR VPWR _05274_ sky130_fd_sc_hd__mux2_1
XFILLER_0_104_197 VGND VGND VPWR VPWR sky130_fd_sc_hd__decap_3
XFILLER_0_104_175 VGND VGND VPWR VPWR sky130_fd_sc_hd__decap_4
X_11263_ net1074 _05175_ _05229_ VGND VGND VPWR VPWR _05237_ sky130_fd_sc_hd__mux2_1
X_14051_ net396 _01100_ _07420_ VGND VGND VPWR VPWR _07442_ sky130_fd_sc_hd__mux2_1
X_11194_ _03543_ VGND VGND VPWR VPWR _05192_ sky130_fd_sc_hd__clkbuf_4
X_10214_ _04116_ _04428_ _04432_ _04063_ VGND VGND VPWR VPWR _04433_ sky130_fd_sc_hd__o211a_1
X_13002_ cpuregs\[30\]\[6\] cpuregs\[31\]\[6\] _06462_ VGND VGND VPWR VPWR _06495_
+ sky130_fd_sc_hd__mux2_1
X_10145_ _04296_ _04327_ _04364_ VGND VGND VPWR VPWR _04365_ sky130_fd_sc_hd__or3_1
XFILLER_0_27_15 VPWR VGND VPWR VGND sky130_ef_sc_hd__decap_12
X_14953_ _03591_ net1202 _01851_ VGND VGND VPWR VPWR _01854_ sky130_fd_sc_hd__mux2_1
X_10076_ _04296_ _04297_ VGND VGND VPWR VPWR _04298_ sky130_fd_sc_hd__nand2_1
X_14884_ _01817_ VGND VGND VPWR VPWR _01306_ sky130_fd_sc_hd__clkbuf_1
X_13904_ instr_bgeu _07325_ _07347_ _07350_ VGND VGND VPWR VPWR _07351_ sky130_fd_sc_hd__a22o_1
X_16623_ clknet_leaf_144_clk _01190_ VGND VGND VPWR VPWR cpuregs\[23\]\[1\] sky130_fd_sc_hd__dfxtp_1
X_13835_ mem_do_rdata cpu_state\[6\] _02104_ VGND VGND VPWR VPWR _07299_ sky130_fd_sc_hd__and3b_1
Xclkbuf_leaf_27_clk clknet_4_4_0_clk VGND VGND VPWR VPWR clknet_leaf_27_clk sky130_fd_sc_hd__clkbuf_16
X_13766_ _06431_ _07232_ _07234_ VGND VGND VPWR VPWR _07235_ sky130_fd_sc_hd__a21o_1
XFILLER_0_84_110 VGND VGND VPWR VPWR sky130_fd_sc_hd__fill_2
X_10978_ _05070_ VGND VGND VPWR VPWR _00212_ sky130_fd_sc_hd__clkbuf_1
XPHY_4 VGND VGND VPWR VPWR sky130_fd_sc_hd__decap_3
X_16554_ clknet_leaf_143_clk _01131_ VGND VGND VPWR VPWR cpuregs\[24\]\[6\] sky130_fd_sc_hd__dfxtp_1
X_13697_ _06442_ _07164_ _07168_ _06428_ VGND VGND VPWR VPWR _07169_ sky130_fd_sc_hd__o211a_1
XFILLER_0_127_223 VGND VGND VPWR VPWR sky130_fd_sc_hd__fill_1
X_15505_ clknet_leaf_69_clk _00155_ VGND VGND VPWR VPWR cpuregs\[30\]\[23\] sky130_fd_sc_hd__dfxtp_1
X_16485_ clknet_leaf_145_clk _01067_ VGND VGND VPWR VPWR cpuregs\[19\]\[6\] sky130_fd_sc_hd__dfxtp_1
X_12717_ net401 _06250_ _02185_ VGND VGND VPWR VPWR _06252_ sky130_fd_sc_hd__o21ai_1
XFILLER_0_128_757 VGND VGND VPWR VPWR sky130_fd_sc_hd__fill_2
X_15436_ clknet_leaf_52_clk _00086_ VGND VGND VPWR VPWR net179 sky130_fd_sc_hd__dfxtp_4
X_12648_ _06202_ VGND VGND VPWR VPWR _00750_ sky130_fd_sc_hd__clkbuf_1
XFILLER_0_127_289 VPWR VGND VPWR VGND sky130_ef_sc_hd__decap_12
XFILLER_0_25_243 VGND VGND VPWR VPWR sky130_fd_sc_hd__fill_1
X_15367_ _03622_ net1361 _02063_ VGND VGND VPWR VPWR _02071_ sky130_fd_sc_hd__mux2_1
X_12579_ _06152_ _06128_ _06153_ VGND VGND VPWR VPWR _06154_ sky130_fd_sc_hd__and3b_1
Xhold317 cpuregs\[30\]\[29\] VGND VGND VPWR VPWR net675 sky130_fd_sc_hd__dlygate4sd3_1
X_15298_ _02034_ VGND VGND VPWR VPWR _01503_ sky130_fd_sc_hd__clkbuf_1
X_14318_ net1619 _07587_ _07590_ _07591_ VGND VGND VPWR VPWR _01010_ sky130_fd_sc_hd__o22a_1
Xhold306 cpuregs\[11\]\[3\] VGND VGND VPWR VPWR net664 sky130_fd_sc_hd__dlygate4sd3_1
X_14249_ net1213 net117 _07541_ VGND VGND VPWR VPWR _07550_ sky130_fd_sc_hd__mux2_1
XFILLER_0_110_101 VGND VGND VPWR VPWR sky130_fd_sc_hd__decap_4
Xhold339 cpuregs\[20\]\[30\] VGND VGND VPWR VPWR net697 sky130_fd_sc_hd__dlygate4sd3_1
XFILLER_0_68_44 VGND VGND VPWR VPWR sky130_fd_sc_hd__fill_2
XFILLER_0_68_22 VGND VGND VPWR VPWR sky130_fd_sc_hd__fill_1
Xhold328 cpuregs\[12\]\[17\] VGND VGND VPWR VPWR net686 sky130_fd_sc_hd__dlygate4sd3_1
XFILLER_0_40_257 VGND VGND VPWR VPWR sky130_fd_sc_hd__fill_1
XFILLER_0_110_156 VGND VGND VPWR VPWR sky130_fd_sc_hd__decap_3
XFILLER_0_110_145 VGND VGND VPWR VPWR sky130_fd_sc_hd__fill_1
XTAP_600 VGND VPWR sky130_fd_sc_hd__tapvpwrvgnd_1
X_08810_ _03163_ _03153_ _03146_ VGND VGND VPWR VPWR _03164_ sky130_fd_sc_hd__a21o_1
XFILLER_0_68_88 VGND VGND VPWR VPWR sky130_fd_sc_hd__decap_6
XFILLER_0_21_493 VGND VGND VPWR VPWR sky130_fd_sc_hd__fill_1
XTAP_611 VGND VPWR sky130_fd_sc_hd__tapvpwrvgnd_1
XTAP_622 VGND VPWR sky130_fd_sc_hd__tapvpwrvgnd_1
XTAP_633 VGND VPWR sky130_fd_sc_hd__tapvpwrvgnd_1
X_09790_ _03661_ VGND VGND VPWR VPWR _04020_ sky130_fd_sc_hd__clkbuf_8
Xhold1006 cpuregs\[10\]\[10\] VGND VGND VPWR VPWR net1364 sky130_fd_sc_hd__dlygate4sd3_1
XTAP_644 VGND VPWR sky130_fd_sc_hd__tapvpwrvgnd_1
XTAP_655 VGND VPWR sky130_fd_sc_hd__tapvpwrvgnd_1
XTAP_666 VGND VPWR sky130_fd_sc_hd__tapvpwrvgnd_1
XTAP_677 VGND VPWR sky130_fd_sc_hd__tapvpwrvgnd_1
X_08741_ _02867_ _03096_ _03097_ _03099_ _02704_ VGND VGND VPWR VPWR alu_out\[22\]
+ sky130_fd_sc_hd__a32o_1
Xhold1039 cpuregs\[29\]\[24\] VGND VGND VPWR VPWR net1397 sky130_fd_sc_hd__dlygate4sd3_1
Xhold1028 cpuregs\[5\]\[16\] VGND VGND VPWR VPWR net1386 sky130_fd_sc_hd__dlygate4sd3_1
Xhold1017 cpuregs\[22\]\[2\] VGND VGND VPWR VPWR net1375 sky130_fd_sc_hd__dlygate4sd3_1
XTAP_688 VGND VPWR sky130_fd_sc_hd__tapvpwrvgnd_1
XTAP_699 VGND VPWR sky130_fd_sc_hd__tapvpwrvgnd_1
X_08672_ _03035_ _02468_ VGND VGND VPWR VPWR _03036_ sky130_fd_sc_hd__and2b_1
XFILLER_0_17_92 VGND VGND VPWR VPWR sky130_fd_sc_hd__decap_4
Xclkbuf_leaf_18_clk clknet_4_6_0_clk VGND VGND VPWR VPWR clknet_leaf_18_clk sky130_fd_sc_hd__clkbuf_16
XFILLER_0_75_110 VGND VGND VPWR VPWR sky130_fd_sc_hd__fill_2
XFILLER_0_124_60 VGND VGND VPWR VPWR sky130_fd_sc_hd__fill_1
XFILLER_0_118_201 VGND VGND VPWR VPWR sky130_fd_sc_hd__fill_1
XFILLER_0_118_245 VGND VGND VPWR VPWR sky130_fd_sc_hd__fill_1
XFILLER_0_76_699 VGND VGND VPWR VPWR sky130_fd_sc_hd__fill_1
X_09224_ _03485_ VGND VGND VPWR VPWR _00043_ sky130_fd_sc_hd__clkbuf_1
XFILLER_0_118_267 VGND VGND VPWR VPWR sky130_fd_sc_hd__decap_4
XFILLER_0_16_232 VGND VGND VPWR VPWR sky130_fd_sc_hd__fill_2
XFILLER_0_90_179 VGND VGND VPWR VPWR sky130_fd_sc_hd__fill_1
X_09155_ mem_rdata_q\[23\] net16 _03291_ VGND VGND VPWR VPWR _03427_ sky130_fd_sc_hd__mux2_1
XFILLER_0_16_265 VGND VGND VPWR VPWR sky130_fd_sc_hd__decap_8
XFILLER_0_17_777 VGND VGND VPWR VPWR sky130_fd_sc_hd__decap_6
XFILLER_0_31_202 VGND VGND VPWR VPWR sky130_fd_sc_hd__decap_8
XFILLER_0_114_451 VPWR VGND VPWR VGND sky130_ef_sc_hd__decap_12
X_08106_ _02487_ VGND VGND VPWR VPWR _02499_ sky130_fd_sc_hd__inv_2
X_09086_ _03362_ _03366_ _02508_ VGND VGND VPWR VPWR _03367_ sky130_fd_sc_hd__mux2_1
X_08037_ _02197_ _02425_ _02434_ VGND VGND VPWR VPWR _02435_ sky130_fd_sc_hd__a21oi_1
Xhold873 cpuregs\[17\]\[29\] VGND VGND VPWR VPWR net1231 sky130_fd_sc_hd__dlygate4sd3_1
Xhold851 cpuregs\[10\]\[16\] VGND VGND VPWR VPWR net1209 sky130_fd_sc_hd__dlygate4sd3_1
Xhold840 cpuregs\[10\]\[1\] VGND VGND VPWR VPWR net1198 sky130_fd_sc_hd__dlygate4sd3_1
Xhold862 cpuregs\[31\]\[3\] VGND VGND VPWR VPWR net1220 sky130_fd_sc_hd__dlygate4sd3_1
Xhold895 cpuregs\[17\]\[23\] VGND VGND VPWR VPWR net1253 sky130_fd_sc_hd__dlygate4sd3_1
XFILLER_0_101_189 VGND VGND VPWR VPWR sky130_fd_sc_hd__decap_3
Xhold884 cpuregs\[4\]\[31\] VGND VGND VPWR VPWR net1242 sky130_fd_sc_hd__dlygate4sd3_1
X_09988_ _03732_ _04208_ _04212_ _03659_ VGND VGND VPWR VPWR _04213_ sky130_fd_sc_hd__o211a_1
X_08939_ _03250_ VGND VGND VPWR VPWR net68 sky130_fd_sc_hd__buf_4
XFILLER_0_98_213 VGND VGND VPWR VPWR sky130_fd_sc_hd__fill_2
X_11950_ _05631_ _05632_ VGND VGND VPWR VPWR _05633_ sky130_fd_sc_hd__nor2_1
X_10901_ _05023_ VGND VGND VPWR VPWR _00182_ sky130_fd_sc_hd__clkbuf_1
X_11881_ _05581_ _05576_ _05582_ VGND VGND VPWR VPWR _05583_ sky130_fd_sc_hd__and3b_1
X_10832_ net1141 _03629_ _04968_ VGND VGND VPWR VPWR _04977_ sky130_fd_sc_hd__mux2_1
X_13620_ cpuregs\[6\]\[25\] cpuregs\[7\]\[25\] _06842_ VGND VGND VPWR VPWR _07094_
+ sky130_fd_sc_hd__mux2_1
XFILLER_0_79_493 VGND VGND VPWR VPWR sky130_fd_sc_hd__decap_3
X_10763_ net910 _03635_ _04929_ VGND VGND VPWR VPWR _04939_ sky130_fd_sc_hd__mux2_1
XFILLER_0_94_463 VGND VGND VPWR VPWR sky130_fd_sc_hd__fill_1
XFILLER_0_66_132 VGND VGND VPWR VPWR sky130_fd_sc_hd__decap_3
X_13551_ _03336_ VGND VGND VPWR VPWR _07027_ sky130_fd_sc_hd__clkbuf_8
XFILLER_0_54_305 VGND VGND VPWR VPWR sky130_fd_sc_hd__decap_3
X_12502_ net399 _02164_ VGND VGND VPWR VPWR _00707_ sky130_fd_sc_hd__nor2_1
X_16270_ clknet_leaf_4_clk net423 VGND VGND VPWR VPWR instr_lh sky130_fd_sc_hd__dfxtp_1
X_10694_ _04899_ VGND VGND VPWR VPWR _00099_ sky130_fd_sc_hd__clkbuf_1
X_15221_ _03577_ net1595 _01995_ VGND VGND VPWR VPWR _01996_ sky130_fd_sc_hd__mux2_1
X_13482_ _06959_ net215 _06960_ VGND VGND VPWR VPWR _06961_ sky130_fd_sc_hd__mux2_1
X_12433_ _06035_ _06037_ VGND VGND VPWR VPWR _06038_ sky130_fd_sc_hd__or2_1
XFILLER_0_23_725 VGND VGND VPWR VPWR sky130_fd_sc_hd__decap_3
XFILLER_0_105_440 VGND VGND VPWR VPWR sky130_fd_sc_hd__fill_2
X_12364_ _05973_ _05974_ _05769_ VGND VGND VPWR VPWR _05975_ sky130_fd_sc_hd__and3b_1
X_15152_ _01936_ VGND VGND VPWR VPWR _01959_ sky130_fd_sc_hd__buf_4
XFILLER_0_120_421 VGND VGND VPWR VPWR sky130_fd_sc_hd__fill_2
X_15083_ _01922_ VGND VGND VPWR VPWR _01400_ sky130_fd_sc_hd__clkbuf_1
X_14103_ _04902_ _04900_ _04901_ _04983_ VGND VGND VPWR VPWR _07470_ sky130_fd_sc_hd__or4_4
X_11315_ _04902_ _04900_ _04901_ VGND VGND VPWR VPWR _05264_ sky130_fd_sc_hd__nand3b_4
X_12295_ _05792_ _05907_ _05909_ _05911_ VGND VGND VPWR VPWR _05912_ sky130_fd_sc_hd__a31o_1
X_14034_ _07433_ VGND VGND VPWR VPWR _01123_ sky130_fd_sc_hd__clkbuf_1
XFILLER_0_10_419 VGND VGND VPWR VPWR sky130_fd_sc_hd__fill_1
X_11246_ _04901_ _04900_ _04902_ VGND VGND VPWR VPWR _05227_ sky130_fd_sc_hd__nand3b_4
X_11177_ _05180_ VGND VGND VPWR VPWR _00301_ sky130_fd_sc_hd__clkbuf_1
X_10128_ _03818_ _04344_ _04348_ _03829_ VGND VGND VPWR VPWR _04349_ sky130_fd_sc_hd__o211a_1
X_15985_ clknet_leaf_152_clk _00635_ VGND VGND VPWR VPWR count_instr\[54\] sky130_fd_sc_hd__dfxtp_1
X_14936_ _03538_ net1053 _01840_ VGND VGND VPWR VPWR _01845_ sky130_fd_sc_hd__mux2_1
X_10059_ _03818_ _04277_ _04281_ _03829_ VGND VGND VPWR VPWR _04282_ sky130_fd_sc_hd__o211a_1
XFILLER_0_89_279 VGND VGND VPWR VPWR sky130_fd_sc_hd__fill_1
X_14867_ _01808_ VGND VGND VPWR VPWR _01298_ sky130_fd_sc_hd__clkbuf_1
X_16606_ clknet_leaf_86_clk _01173_ VGND VGND VPWR VPWR cpuregs\[9\]\[16\] sky130_fd_sc_hd__dfxtp_1
X_13818_ _06377_ _07275_ _07279_ _07285_ _06341_ VGND VGND VPWR VPWR _07286_ sky130_fd_sc_hd__a311o_1
XFILLER_0_58_611 VGND VGND VPWR VPWR sky130_fd_sc_hd__decap_3
X_14798_ _01771_ VGND VGND VPWR VPWR _01266_ sky130_fd_sc_hd__clkbuf_1
X_13749_ cpuregs\[22\]\[29\] cpuregs\[23\]\[29\] _06386_ VGND VGND VPWR VPWR _07219_
+ sky130_fd_sc_hd__mux2_1
XFILLER_0_58_677 VGND VGND VPWR VPWR sky130_fd_sc_hd__fill_2
XFILLER_0_57_154 VGND VGND VPWR VPWR sky130_fd_sc_hd__decap_8
X_16537_ clknet_leaf_14_clk _01114_ VGND VGND VPWR VPWR mem_rdata_q\[21\] sky130_fd_sc_hd__dfxtp_2
XFILLER_0_85_474 VGND VGND VPWR VPWR sky130_fd_sc_hd__fill_1
XFILLER_0_72_113 VGND VGND VPWR VPWR sky130_fd_sc_hd__fill_1
XFILLER_0_72_102 VGND VGND VPWR VPWR sky130_fd_sc_hd__fill_2
XFILLER_0_58_699 VGND VGND VPWR VPWR sky130_fd_sc_hd__fill_1
X_16468_ clknet_leaf_43_clk _01050_ VGND VGND VPWR VPWR cpuregs\[18\]\[21\] sky130_fd_sc_hd__dfxtp_1
XFILLER_0_128_598 VGND VGND VPWR VPWR sky130_fd_sc_hd__fill_1
XFILLER_0_115_237 VGND VGND VPWR VPWR sky130_fd_sc_hd__fill_2
X_16399_ clknet_leaf_84_clk _00981_ VGND VGND VPWR VPWR net153 sky130_fd_sc_hd__dfxtp_1
X_15419_ clknet_leaf_15_clk _00069_ VGND VGND VPWR VPWR net171 sky130_fd_sc_hd__dfxtp_4
XFILLER_0_124_771 VGND VGND VPWR VPWR sky130_fd_sc_hd__fill_1
XFILLER_0_124_760 VGND VGND VPWR VPWR sky130_fd_sc_hd__fill_2
XFILLER_0_79_54 VGND VGND VPWR VPWR sky130_fd_sc_hd__fill_2
XFILLER_0_79_43 VGND VGND VPWR VPWR sky130_fd_sc_hd__decap_4
XFILLER_0_53_393 VGND VGND VPWR VPWR sky130_fd_sc_hd__fill_2
XFILLER_0_41_522 VGND VGND VPWR VPWR sky130_fd_sc_hd__decap_4
Xhold114 cpuregs\[0\]\[29\] VGND VGND VPWR VPWR net472 sky130_fd_sc_hd__dlygate4sd3_1
Xhold125 cpuregs\[0\]\[25\] VGND VGND VPWR VPWR net483 sky130_fd_sc_hd__dlygate4sd3_1
Xhold103 count_instr\[41\] VGND VGND VPWR VPWR net461 sky130_fd_sc_hd__dlygate4sd3_1
Xhold158 net153 VGND VGND VPWR VPWR net516 sky130_fd_sc_hd__dlygate4sd3_1
Xclkbuf_leaf_7_clk clknet_4_1_0_clk VGND VGND VPWR VPWR clknet_leaf_7_clk sky130_fd_sc_hd__clkbuf_16
X_09911_ _03695_ _04135_ _04137_ VGND VGND VPWR VPWR _04138_ sky130_fd_sc_hd__a21o_1
Xhold147 count_instr\[14\] VGND VGND VPWR VPWR net505 sky130_fd_sc_hd__dlygate4sd3_1
Xhold136 net141 VGND VGND VPWR VPWR net494 sky130_fd_sc_hd__dlygate4sd3_1
Xhold169 net139 VGND VGND VPWR VPWR net527 sky130_fd_sc_hd__dlygate4sd3_1
XFILLER_0_95_64 VGND VGND VPWR VPWR sky130_fd_sc_hd__fill_2
X_09842_ _04002_ _04008_ VGND VGND VPWR VPWR _04071_ sky130_fd_sc_hd__nor2_1
XTAP_441 VGND VPWR sky130_fd_sc_hd__tapvpwrvgnd_1
XTAP_430 VGND VPWR sky130_fd_sc_hd__tapvpwrvgnd_1
X_09773_ _04001_ _04002_ VGND VGND VPWR VPWR _04003_ sky130_fd_sc_hd__nor2_1
XTAP_452 VGND VPWR sky130_fd_sc_hd__tapvpwrvgnd_1
XTAP_463 VGND VPWR sky130_fd_sc_hd__tapvpwrvgnd_1
XTAP_474 VGND VPWR sky130_fd_sc_hd__tapvpwrvgnd_1
XTAP_485 VGND VPWR sky130_fd_sc_hd__tapvpwrvgnd_1
X_08724_ _03080_ _03083_ VGND VGND VPWR VPWR _03084_ sky130_fd_sc_hd__xor2_1
XTAP_496 VGND VPWR sky130_fd_sc_hd__tapvpwrvgnd_1
XTAP_2308 VGND VPWR sky130_fd_sc_hd__tapvpwrvgnd_1
XTAP_2319 VGND VPWR sky130_fd_sc_hd__tapvpwrvgnd_1
X_08655_ _02694_ _03012_ _03019_ _03020_ VGND VGND VPWR VPWR alu_out\[15\] sky130_fd_sc_hd__a22o_1
XFILLER_0_135_81 VPWR VGND VPWR VGND sky130_ef_sc_hd__decap_12
XTAP_1629 VGND VPWR sky130_fd_sc_hd__tapvpwrvgnd_1
XTAP_1618 VGND VPWR sky130_fd_sc_hd__tapvpwrvgnd_1
XTAP_1607 VGND VPWR sky130_fd_sc_hd__tapvpwrvgnd_1
X_08586_ _02366_ _02955_ VGND VGND VPWR VPWR _02957_ sky130_fd_sc_hd__or2_1
XFILLER_0_48_165 VGND VGND VPWR VPWR sky130_fd_sc_hd__decap_8
XFILLER_0_119_565 VGND VGND VPWR VPWR sky130_fd_sc_hd__decap_4
XFILLER_0_64_669 VGND VGND VPWR VPWR sky130_fd_sc_hd__fill_1
XFILLER_0_9_785 VPWR VGND VPWR VGND sky130_ef_sc_hd__decap_12
XFILLER_0_17_530 VGND VGND VPWR VPWR sky130_fd_sc_hd__fill_2
XFILLER_0_106_226 VGND VGND VPWR VPWR sky130_fd_sc_hd__decap_8
X_09207_ _03434_ _03466_ _03469_ _03470_ VGND VGND VPWR VPWR _03471_ sky130_fd_sc_hd__a22o_4
XFILLER_0_17_574 VGND VGND VPWR VPWR sky130_fd_sc_hd__decap_3
XFILLER_0_121_207 VGND VGND VPWR VPWR sky130_fd_sc_hd__fill_2
XFILLER_0_60_831 VGND VGND VPWR VPWR sky130_fd_sc_hd__fill_1
X_09138_ _03311_ _03412_ _03416_ _03308_ VGND VGND VPWR VPWR _03417_ sky130_fd_sc_hd__o211a_1
X_11100_ _05123_ VGND VGND VPWR VPWR _05135_ sky130_fd_sc_hd__buf_4
X_09069_ _03341_ _03344_ _03349_ VGND VGND VPWR VPWR _03350_ sky130_fd_sc_hd__a21o_1
Xhold681 cpuregs\[23\]\[19\] VGND VGND VPWR VPWR net1039 sky130_fd_sc_hd__dlygate4sd3_1
X_12080_ _05523_ VGND VGND VPWR VPWR _05725_ sky130_fd_sc_hd__clkbuf_4
Xhold670 cpuregs\[8\]\[7\] VGND VGND VPWR VPWR net1028 sky130_fd_sc_hd__dlygate4sd3_1
Xhold692 cpuregs\[3\]\[24\] VGND VGND VPWR VPWR net1050 sky130_fd_sc_hd__dlygate4sd3_1
X_11031_ _05098_ VGND VGND VPWR VPWR _00237_ sky130_fd_sc_hd__clkbuf_1
X_15770_ clknet_leaf_125_clk _00420_ VGND VGND VPWR VPWR cpuregs\[26\]\[0\] sky130_fd_sc_hd__dfxtp_1
X_12982_ cpuregs\[10\]\[6\] cpuregs\[11\]\[6\] _06424_ VGND VGND VPWR VPWR _06475_
+ sky130_fd_sc_hd__mux2_1
X_11933_ _02140_ VGND VGND VPWR VPWR _05620_ sky130_fd_sc_hd__buf_2
X_14721_ _01730_ VGND VGND VPWR VPWR _01230_ sky130_fd_sc_hd__clkbuf_1
X_11864_ count_instr\[18\] _05567_ VGND VGND VPWR VPWR _05570_ sky130_fd_sc_hd__and2_1
X_14652_ net986 _05179_ _01684_ VGND VGND VPWR VPWR _01694_ sky130_fd_sc_hd__mux2_1
X_13603_ cpuregs\[28\]\[24\] cpuregs\[29\]\[24\] _07018_ VGND VGND VPWR VPWR _07078_
+ sky130_fd_sc_hd__mux2_1
X_10815_ _04945_ VGND VGND VPWR VPWR _04968_ sky130_fd_sc_hd__buf_4
XFILLER_0_67_441 VGND VGND VPWR VPWR sky130_fd_sc_hd__decap_6
XFILLER_0_39_132 VGND VGND VPWR VPWR sky130_fd_sc_hd__decap_4
XFILLER_0_67_463 VGND VGND VPWR VPWR sky130_fd_sc_hd__decap_8
X_14583_ _01657_ VGND VGND VPWR VPWR _01165_ sky130_fd_sc_hd__clkbuf_1
X_11795_ cpu_state\[1\] VGND VGND VPWR VPWR _05519_ sky130_fd_sc_hd__buf_4
X_16322_ clknet_leaf_14_clk _00907_ VGND VGND VPWR VPWR decoded_imm_j\[1\] sky130_fd_sc_hd__dfxtp_2
X_13534_ _06849_ _07010_ VGND VGND VPWR VPWR _07011_ sky130_fd_sc_hd__or2_1
X_10746_ _04930_ VGND VGND VPWR VPWR _00120_ sky130_fd_sc_hd__clkbuf_1
X_16253_ clknet_leaf_43_clk alu_out\[26\] VGND VGND VPWR VPWR alu_out_q\[26\] sky130_fd_sc_hd__dfxtp_1
X_10677_ _03739_ _04878_ _04882_ _03873_ VGND VGND VPWR VPWR _04883_ sky130_fd_sc_hd__o211a_1
X_13465_ _06631_ _06936_ _06943_ VGND VGND VPWR VPWR _06944_ sky130_fd_sc_hd__or3_2
XFILLER_0_82_477 VGND VGND VPWR VPWR sky130_fd_sc_hd__fill_1
X_12416_ _06022_ VGND VGND VPWR VPWR _06023_ sky130_fd_sc_hd__inv_2
XFILLER_0_106_760 VGND VGND VPWR VPWR sky130_fd_sc_hd__fill_2
X_15204_ _03525_ net1077 _01984_ VGND VGND VPWR VPWR _01987_ sky130_fd_sc_hd__mux2_1
X_16184_ clknet_leaf_5_clk _00802_ VGND VGND VPWR VPWR mem_do_prefetch sky130_fd_sc_hd__dfxtp_2
XFILLER_0_35_393 VGND VGND VPWR VPWR sky130_fd_sc_hd__decap_6
Xoutput208 net208 VGND VGND VPWR VPWR pcpi_rs2[14] sky130_fd_sc_hd__clkbuf_4
X_13396_ cpuregs\[6\]\[18\] cpuregs\[7\]\[18\] _06842_ VGND VGND VPWR VPWR _06877_
+ sky130_fd_sc_hd__mux2_1
X_15135_ _01950_ VGND VGND VPWR VPWR _01424_ sky130_fd_sc_hd__clkbuf_1
XFILLER_0_50_341 VGND VGND VPWR VPWR sky130_fd_sc_hd__decap_4
XFILLER_0_105_281 VGND VGND VPWR VPWR sky130_fd_sc_hd__fill_2
X_12347_ _05852_ net420 _05816_ _05959_ VGND VGND VPWR VPWR _00692_ sky130_fd_sc_hd__o211a_1
XFILLER_0_10_216 VGND VGND VPWR VPWR sky130_fd_sc_hd__decap_6
Xoutput219 net219 VGND VGND VPWR VPWR pcpi_rs2[24] sky130_fd_sc_hd__clkbuf_4
X_12278_ _05790_ _05717_ _05895_ _05802_ VGND VGND VPWR VPWR _05896_ sky130_fd_sc_hd__a22o_1
X_15066_ net1422 _05184_ _01912_ VGND VGND VPWR VPWR _01914_ sky130_fd_sc_hd__mux2_1
X_11229_ net1177 _05215_ _05203_ VGND VGND VPWR VPWR _05216_ sky130_fd_sc_hd__mux2_1
X_14017_ mem_rdata_q\[26\] net19 _07422_ VGND VGND VPWR VPWR _07425_ sky130_fd_sc_hd__mux2_1
XFILLER_0_4_37 VGND VGND VPWR VPWR sky130_fd_sc_hd__fill_1
X_15968_ clknet_leaf_149_clk _00618_ VGND VGND VPWR VPWR count_instr\[37\] sky130_fd_sc_hd__dfxtp_1
X_15899_ clknet_leaf_144_clk _00549_ VGND VGND VPWR VPWR cpuregs\[17\]\[1\] sky130_fd_sc_hd__dfxtp_1
X_14919_ _03484_ net1063 _01829_ VGND VGND VPWR VPWR _01836_ sky130_fd_sc_hd__mux2_1
X_08440_ net223 VGND VGND VPWR VPWR _02821_ sky130_fd_sc_hd__inv_2
XFILLER_0_86_761 VGND VGND VPWR VPWR sky130_fd_sc_hd__fill_1
XFILLER_0_19_806 VGND VGND VPWR VPWR sky130_fd_sc_hd__fill_2
XFILLER_0_92_208 VGND VGND VPWR VPWR sky130_fd_sc_hd__decap_4
X_08371_ _02749_ _02750_ _02215_ _02751_ VGND VGND VPWR VPWR _02752_ sky130_fd_sc_hd__o2bb2a_1
XFILLER_0_45_113 VGND VGND VPWR VPWR sky130_fd_sc_hd__decap_3
XFILLER_0_116_524 VGND VGND VPWR VPWR sky130_fd_sc_hd__decap_8
XFILLER_0_73_466 VGND VGND VPWR VPWR sky130_fd_sc_hd__fill_1
XFILLER_0_131_505 VGND VGND VPWR VPWR sky130_fd_sc_hd__decap_3
XFILLER_0_60_138 VGND VGND VPWR VPWR sky130_fd_sc_hd__fill_2
XFILLER_0_5_254 VGND VGND VPWR VPWR sky130_fd_sc_hd__fill_2
X_09825_ _03722_ _04053_ _03674_ VGND VGND VPWR VPWR _04054_ sky130_fd_sc_hd__a21o_1
XTAP_282 VGND VPWR sky130_fd_sc_hd__tapvpwrvgnd_1
XTAP_293 VGND VPWR sky130_fd_sc_hd__tapvpwrvgnd_1
X_09756_ cpuregs\[18\]\[5\] cpuregs\[19\]\[5\] _03665_ VGND VGND VPWR VPWR _03987_
+ sky130_fd_sc_hd__mux2_1
XTAP_2116 VGND VPWR sky130_fd_sc_hd__tapvpwrvgnd_1
XTAP_2105 VGND VPWR sky130_fd_sc_hd__tapvpwrvgnd_1
X_08707_ _02509_ _03067_ VGND VGND VPWR VPWR _03068_ sky130_fd_sc_hd__xor2_2
X_09687_ cpuregs\[28\]\[4\] cpuregs\[29\]\[4\] cpuregs\[30\]\[4\] cpuregs\[31\]\[4\]
+ _03894_ _03895_ VGND VGND VPWR VPWR _03919_ sky130_fd_sc_hd__mux4_1
XTAP_2149 VGND VPWR sky130_fd_sc_hd__tapvpwrvgnd_1
XTAP_2138 VGND VPWR sky130_fd_sc_hd__tapvpwrvgnd_1
XTAP_2127 VGND VPWR sky130_fd_sc_hd__tapvpwrvgnd_1
X_08638_ _02994_ VGND VGND VPWR VPWR _03005_ sky130_fd_sc_hd__inv_2
XTAP_1415 VGND VPWR sky130_fd_sc_hd__tapvpwrvgnd_1
XTAP_1404 VGND VPWR sky130_fd_sc_hd__tapvpwrvgnd_1
XTAP_1448 VGND VPWR sky130_fd_sc_hd__tapvpwrvgnd_1
XTAP_1437 VGND VPWR sky130_fd_sc_hd__tapvpwrvgnd_1
XTAP_1426 VGND VPWR sky130_fd_sc_hd__tapvpwrvgnd_1
X_08569_ _02672_ _02930_ _02941_ _02849_ VGND VGND VPWR VPWR alu_out\[8\] sky130_fd_sc_hd__a22o_1
XTAP_1459 VGND VPWR sky130_fd_sc_hd__tapvpwrvgnd_1
X_11580_ _05405_ VGND VGND VPWR VPWR _00479_ sky130_fd_sc_hd__clkbuf_1
X_10600_ cpuregs\[0\]\[28\] cpuregs\[1\]\[28\] _03880_ VGND VGND VPWR VPWR _04808_
+ sky130_fd_sc_hd__mux2_1
XFILLER_0_64_433 VGND VGND VPWR VPWR sky130_fd_sc_hd__decap_3
XFILLER_0_107_535 VGND VGND VPWR VPWR sky130_fd_sc_hd__fill_2
X_10531_ _03863_ _04734_ _04740_ VGND VGND VPWR VPWR _04741_ sky130_fd_sc_hd__or3_2
XFILLER_0_91_263 VGND VGND VPWR VPWR sky130_fd_sc_hd__fill_2
XFILLER_0_134_365 VGND VGND VPWR VPWR sky130_fd_sc_hd__decap_4
XFILLER_0_134_354 VGND VGND VPWR VPWR sky130_fd_sc_hd__fill_1
X_13250_ cpuregs\[4\]\[14\] cpuregs\[5\]\[14\] _06575_ VGND VGND VPWR VPWR _06735_
+ sky130_fd_sc_hd__mux2_1
XFILLER_0_51_127 VGND VGND VPWR VPWR sky130_fd_sc_hd__decap_3
X_10462_ _04578_ _04611_ _04672_ _04673_ _04612_ VGND VGND VPWR VPWR _04674_ sky130_fd_sc_hd__o221a_1
X_12201_ _05792_ _05818_ _05824_ _05520_ VGND VGND VPWR VPWR _05825_ sky130_fd_sc_hd__o211a_1
XFILLER_0_122_549 VGND VGND VPWR VPWR sky130_fd_sc_hd__decap_3
XFILLER_0_115_590 VGND VGND VPWR VPWR sky130_fd_sc_hd__decap_3
X_10393_ _03690_ _04606_ _03959_ VGND VGND VPWR VPWR _04607_ sky130_fd_sc_hd__o21a_1
X_13181_ _06351_ _06666_ _06667_ VGND VGND VPWR VPWR _06668_ sky130_fd_sc_hd__a21o_1
XFILLER_0_60_672 VGND VGND VPWR VPWR sky130_fd_sc_hd__fill_1
XFILLER_0_60_661 VGND VGND VPWR VPWR sky130_fd_sc_hd__fill_2
X_12132_ _05686_ _05761_ VGND VGND VPWR VPWR _05762_ sky130_fd_sc_hd__or2_1
XFILLER_0_103_785 VGND VGND VPWR VPWR sky130_fd_sc_hd__fill_1
XFILLER_0_102_262 VGND VGND VPWR VPWR sky130_fd_sc_hd__fill_1
X_16940_ clknet_leaf_73_clk _01504_ VGND VGND VPWR VPWR cpuregs\[0\]\[27\] sky130_fd_sc_hd__dfxtp_1
X_12063_ _05688_ _05712_ _05713_ _02142_ VGND VGND VPWR VPWR _00654_ sky130_fd_sc_hd__o211a_1
X_11014_ net590 _03451_ _05088_ VGND VGND VPWR VPWR _05090_ sky130_fd_sc_hd__mux2_1
X_16871_ clknet_leaf_49_clk _01435_ VGND VGND VPWR VPWR cpuregs\[22\]\[22\] sky130_fd_sc_hd__dfxtp_1
X_15822_ clknet_leaf_52_clk _00472_ VGND VGND VPWR VPWR cpuregs\[16\]\[20\] sky130_fd_sc_hd__dfxtp_1
X_15753_ clknet_leaf_90_clk _00403_ VGND VGND VPWR VPWR cpuregs\[15\]\[15\] sky130_fd_sc_hd__dfxtp_1
X_12965_ _03346_ VGND VGND VPWR VPWR _06459_ sky130_fd_sc_hd__buf_4
X_14704_ _04987_ net1597 _01720_ VGND VGND VPWR VPWR _01722_ sky130_fd_sc_hd__mux2_1
X_11916_ _05606_ _05576_ _05607_ VGND VGND VPWR VPWR _05608_ sky130_fd_sc_hd__and3b_1
XFILLER_0_75_709 VGND VGND VPWR VPWR sky130_fd_sc_hd__decap_3
X_15684_ clknet_leaf_137_clk _00334_ VGND VGND VPWR VPWR cpuregs\[27\]\[10\] sky130_fd_sc_hd__dfxtp_1
X_12896_ cpuregs\[28\]\[1\] cpuregs\[29\]\[1\] _03312_ VGND VGND VPWR VPWR _06394_
+ sky130_fd_sc_hd__mux2_1
XFILLER_0_136_6 VGND VGND VPWR VPWR sky130_fd_sc_hd__fill_2
XTAP_1960 VGND VPWR sky130_fd_sc_hd__tapvpwrvgnd_1
XFILLER_0_51_36 VPWR VGND VPWR VGND sky130_ef_sc_hd__decap_12
XFILLER_0_51_25 VGND VGND VPWR VPWR sky130_fd_sc_hd__fill_2
X_11847_ count_instr\[12\] _05552_ count_instr\[13\] VGND VGND VPWR VPWR _05558_ sky130_fd_sc_hd__a21o_1
X_14635_ _01685_ VGND VGND VPWR VPWR _01189_ sky130_fd_sc_hd__clkbuf_1
XTAP_1993 VGND VPWR sky130_fd_sc_hd__tapvpwrvgnd_1
XTAP_1982 VGND VPWR sky130_fd_sc_hd__tapvpwrvgnd_1
XTAP_1971 VGND VPWR sky130_fd_sc_hd__tapvpwrvgnd_1
X_11778_ _05510_ VGND VGND VPWR VPWR _00572_ sky130_fd_sc_hd__clkbuf_1
X_14566_ _04981_ net1396 _01648_ VGND VGND VPWR VPWR _01649_ sky130_fd_sc_hd__mux2_1
X_13517_ _06994_ VGND VGND VPWR VPWR _00827_ sky130_fd_sc_hd__clkbuf_1
X_16305_ clknet_leaf_27_clk _00890_ VGND VGND VPWR VPWR decoded_imm_j\[9\] sky130_fd_sc_hd__dfxtp_1
X_10729_ _04921_ VGND VGND VPWR VPWR _00112_ sky130_fd_sc_hd__clkbuf_1
XFILLER_0_27_157 VGND VGND VPWR VPWR sky130_fd_sc_hd__decap_6
X_16236_ clknet_leaf_25_clk alu_out\[9\] VGND VGND VPWR VPWR alu_out_q\[9\] sky130_fd_sc_hd__dfxtp_1
XFILLER_0_70_436 VGND VGND VPWR VPWR sky130_fd_sc_hd__fill_1
X_14497_ _01611_ VGND VGND VPWR VPWR _01612_ sky130_fd_sc_hd__buf_4
XFILLER_0_43_628 VGND VGND VPWR VPWR sky130_fd_sc_hd__fill_1
X_13448_ _06780_ _06917_ _06921_ _06927_ _06800_ VGND VGND VPWR VPWR _06928_ sky130_fd_sc_hd__a311o_1
XFILLER_0_70_469 VGND VGND VPWR VPWR sky130_fd_sc_hd__decap_6
XFILLER_0_140_346 VGND VGND VPWR VPWR sky130_fd_sc_hd__fill_2
X_13379_ _06792_ _06858_ _06860_ _06563_ VGND VGND VPWR VPWR _06861_ sky130_fd_sc_hd__a211o_1
XFILLER_0_3_747 VPWR VGND VPWR VGND sky130_ef_sc_hd__decap_12
X_16167_ clknet_leaf_126_clk _00785_ VGND VGND VPWR VPWR net40 sky130_fd_sc_hd__dfxtp_1
XFILLER_0_62_9 VGND VGND VPWR VPWR sky130_fd_sc_hd__fill_2
XFILLER_0_50_182 VGND VGND VPWR VPWR sky130_fd_sc_hd__fill_1
X_16098_ clknet_leaf_145_clk _00748_ VGND VGND VPWR VPWR count_cycle\[41\] sky130_fd_sc_hd__dfxtp_1
X_15118_ _01941_ VGND VGND VPWR VPWR _01416_ sky130_fd_sc_hd__clkbuf_1
X_07940_ count_instr\[9\] _02236_ count_cycle\[41\] _02204_ VGND VGND VPWR VPWR _02344_
+ sky130_fd_sc_hd__a22o_1
X_15049_ net1095 _05167_ _01901_ VGND VGND VPWR VPWR _01905_ sky130_fd_sc_hd__mux2_1
X_07871_ net197 VGND VGND VPWR VPWR _02280_ sky130_fd_sc_hd__clkbuf_4
X_09610_ _03794_ _03816_ _03843_ _03775_ reg_pc\[2\] VGND VGND VPWR VPWR _03844_ sky130_fd_sc_hd__a32o_1
XFILLER_0_92_32 VGND VGND VPWR VPWR sky130_fd_sc_hd__decap_8
X_09541_ _03775_ VGND VGND VPWR VPWR _03776_ sky130_fd_sc_hd__clkbuf_4
XFILLER_0_116_83 VGND VGND VPWR VPWR sky130_fd_sc_hd__fill_1
XFILLER_0_92_98 VGND VGND VPWR VPWR sky130_fd_sc_hd__decap_4
XFILLER_0_66_709 VGND VGND VPWR VPWR sky130_fd_sc_hd__decap_3
X_09472_ _02242_ _03652_ _03654_ _03707_ VGND VGND VPWR VPWR _03708_ sky130_fd_sc_hd__a31o_1
X_08423_ net174 _02802_ _02803_ net207 VGND VGND VPWR VPWR _02804_ sky130_fd_sc_hd__a2bb2o_1
X_08354_ net192 net224 VGND VGND VPWR VPWR _02735_ sky130_fd_sc_hd__nand2_1
XFILLER_0_74_720 VGND VGND VPWR VPWR sky130_fd_sc_hd__fill_1
XFILLER_0_18_135 VGND VGND VPWR VPWR sky130_fd_sc_hd__decap_4
XFILLER_0_135_118 VGND VGND VPWR VPWR sky130_fd_sc_hd__decap_8
XFILLER_0_132_93 VGND VGND VPWR VPWR sky130_fd_sc_hd__decap_6
X_08285_ net199 _02664_ VGND VGND VPWR VPWR _02666_ sky130_fd_sc_hd__nand2_1
XFILLER_0_61_436 VGND VGND VPWR VPWR sky130_fd_sc_hd__decap_8
XFILLER_0_6_530 VGND VGND VPWR VPWR sky130_fd_sc_hd__fill_2
XFILLER_0_132_825 VGND VGND VPWR VPWR sky130_fd_sc_hd__decap_4
XFILLER_0_116_365 VGND VGND VPWR VPWR sky130_fd_sc_hd__fill_1
XFILLER_0_14_363 VGND VGND VPWR VPWR sky130_fd_sc_hd__fill_1
XFILLER_0_14_374 VGND VGND VPWR VPWR sky130_fd_sc_hd__decap_4
XFILLER_0_10_580 VGND VGND VPWR VPWR sky130_fd_sc_hd__decap_4
X_09808_ cpuregs\[8\]\[7\] cpuregs\[9\]\[7\] cpuregs\[10\]\[7\] cpuregs\[11\]\[7\]
+ _03755_ _03718_ VGND VGND VPWR VPWR _04037_ sky130_fd_sc_hd__mux4_1
XFILLER_0_97_801 VGND VGND VPWR VPWR sky130_fd_sc_hd__fill_1
XFILLER_0_69_503 VGND VGND VPWR VPWR sky130_fd_sc_hd__fill_1
X_09739_ _03929_ _03967_ _03969_ VGND VGND VPWR VPWR _03970_ sky130_fd_sc_hd__a21o_1
X_12750_ _02159_ _03845_ _06256_ _06283_ _03793_ VGND VGND VPWR VPWR _06284_ sky130_fd_sc_hd__a32o_1
XFILLER_0_96_355 VGND VGND VPWR VPWR sky130_fd_sc_hd__fill_1
XTAP_1223 VGND VPWR sky130_fd_sc_hd__tapvpwrvgnd_1
XTAP_1212 VGND VPWR sky130_fd_sc_hd__tapvpwrvgnd_1
XTAP_1201 VGND VPWR sky130_fd_sc_hd__tapvpwrvgnd_1
X_11701_ net719 _05202_ _05469_ VGND VGND VPWR VPWR _05470_ sky130_fd_sc_hd__mux2_1
XFILLER_0_84_539 VGND VGND VPWR VPWR sky130_fd_sc_hd__fill_1
XTAP_1256 VGND VPWR sky130_fd_sc_hd__tapvpwrvgnd_1
XTAP_1245 VGND VPWR sky130_fd_sc_hd__tapvpwrvgnd_1
XTAP_1234 VGND VPWR sky130_fd_sc_hd__tapvpwrvgnd_1
X_12681_ net432 _06222_ _06226_ VGND VGND VPWR VPWR _00759_ sky130_fd_sc_hd__o21a_1
X_14420_ _05043_ net1184 _01562_ VGND VGND VPWR VPWR _01571_ sky130_fd_sc_hd__mux2_1
X_11632_ _05410_ VGND VGND VPWR VPWR _05433_ sky130_fd_sc_hd__buf_4
XTAP_1289 VGND VPWR sky130_fd_sc_hd__tapvpwrvgnd_1
XTAP_1267 VGND VPWR sky130_fd_sc_hd__tapvpwrvgnd_1
XTAP_1278 VGND VPWR sky130_fd_sc_hd__tapvpwrvgnd_1
X_14351_ mem_rdata_q\[23\] _07460_ VGND VGND VPWR VPWR _07609_ sky130_fd_sc_hd__and2_1
X_11563_ _05396_ VGND VGND VPWR VPWR _00471_ sky130_fd_sc_hd__clkbuf_1
X_13302_ _06462_ VGND VGND VPWR VPWR _06786_ sky130_fd_sc_hd__buf_4
X_10514_ _04685_ VGND VGND VPWR VPWR _04724_ sky130_fd_sc_hd__inv_2
X_11494_ _05359_ VGND VGND VPWR VPWR _00439_ sky130_fd_sc_hd__clkbuf_1
X_14282_ _05791_ _06005_ _07567_ mem_rdata_q\[31\] _07324_ VGND VGND VPWR VPWR _07568_
+ sky130_fd_sc_hd__a221o_1
XFILLER_0_24_149 VGND VGND VPWR VPWR sky130_fd_sc_hd__fill_2
XFILLER_0_134_184 VGND VGND VPWR VPWR sky130_fd_sc_hd__fill_1
X_16021_ clknet_leaf_35_clk _00671_ VGND VGND VPWR VPWR reg_pc\[27\] sky130_fd_sc_hd__dfxtp_2
X_10445_ cpuregs\[6\]\[24\] cpuregs\[7\]\[24\] _03881_ VGND VGND VPWR VPWR _04657_
+ sky130_fd_sc_hd__mux2_1
X_13233_ cpuregs\[24\]\[13\] cpuregs\[25\]\[13\] cpuregs\[26\]\[13\] cpuregs\[27\]\[13\]
+ _06525_ _06558_ VGND VGND VPWR VPWR _06719_ sky130_fd_sc_hd__mux4_1
XFILLER_0_60_491 VGND VGND VPWR VPWR sky130_fd_sc_hd__fill_1
X_13164_ cpuregs\[22\]\[11\] cpuregs\[23\]\[11\] _06450_ VGND VGND VPWR VPWR _06652_
+ sky130_fd_sc_hd__mux2_1
X_12115_ _05735_ _05749_ _05750_ _05730_ VGND VGND VPWR VPWR _00669_ sky130_fd_sc_hd__o211a_1
X_10376_ cpuregs\[14\]\[22\] cpuregs\[15\]\[22\] _03756_ VGND VGND VPWR VPWR _04590_
+ sky130_fd_sc_hd__mux2_1
XFILLER_0_20_344 VGND VGND VPWR VPWR sky130_fd_sc_hd__decap_4
XFILLER_0_20_377 VGND VGND VPWR VPWR sky130_fd_sc_hd__fill_1
X_13095_ cpuregs\[16\]\[9\] cpuregs\[17\]\[9\] cpuregs\[18\]\[9\] cpuregs\[19\]\[9\]
+ _06443_ _06444_ VGND VGND VPWR VPWR _06585_ sky130_fd_sc_hd__mux4_1
X_12046_ _03476_ reg_next_pc\[5\] _03221_ VGND VGND VPWR VPWR _05702_ sky130_fd_sc_hd__mux2_2
X_16923_ clknet_leaf_109_clk _01487_ VGND VGND VPWR VPWR cpuregs\[0\]\[10\] sky130_fd_sc_hd__dfxtp_1
X_16854_ clknet_leaf_142_clk _01418_ VGND VGND VPWR VPWR cpuregs\[22\]\[5\] sky130_fd_sc_hd__dfxtp_1
X_15805_ clknet_leaf_127_clk _00455_ VGND VGND VPWR VPWR cpuregs\[16\]\[3\] sky130_fd_sc_hd__dfxtp_1
XFILLER_0_99_160 VGND VGND VPWR VPWR sky130_fd_sc_hd__decap_8
X_13997_ mem_rdata_q\[21\] _07411_ VGND VGND VPWR VPWR _07412_ sky130_fd_sc_hd__nor2_1
X_16785_ clknet_leaf_119_clk _01349_ VGND VGND VPWR VPWR cpuregs\[6\]\[0\] sky130_fd_sc_hd__dfxtp_1
X_15736_ clknet_leaf_57_clk _00386_ VGND VGND VPWR VPWR cpuregs\[21\]\[30\] sky130_fd_sc_hd__dfxtp_1
X_12948_ _06382_ VGND VGND VPWR VPWR _06442_ sky130_fd_sc_hd__buf_4
X_15667_ clknet_leaf_69_clk _00317_ VGND VGND VPWR VPWR cpuregs\[14\]\[25\] sky130_fd_sc_hd__dfxtp_1
X_12879_ _03308_ VGND VGND VPWR VPWR _06377_ sky130_fd_sc_hd__buf_4
XFILLER_0_134_3 VGND VGND VPWR VPWR sky130_fd_sc_hd__decap_4
X_14618_ _05037_ net1573 _01670_ VGND VGND VPWR VPWR _01676_ sky130_fd_sc_hd__mux2_1
XFILLER_0_117_118 VGND VGND VPWR VPWR sky130_fd_sc_hd__fill_1
X_15598_ clknet_leaf_60_clk _00248_ VGND VGND VPWR VPWR cpuregs\[28\]\[20\] sky130_fd_sc_hd__dfxtp_1
XTAP_1790 VGND VPWR sky130_fd_sc_hd__tapvpwrvgnd_1
XFILLER_0_83_561 VGND VGND VPWR VPWR sky130_fd_sc_hd__fill_2
X_14549_ _01639_ VGND VGND VPWR VPWR _01149_ sky130_fd_sc_hd__clkbuf_1
XFILLER_0_43_425 VGND VGND VPWR VPWR sky130_fd_sc_hd__fill_1
XFILLER_0_102_63 VGND VGND VPWR VPWR sky130_fd_sc_hd__decap_4
X_08070_ _02209_ VGND VGND VPWR VPWR _02466_ sky130_fd_sc_hd__buf_2
XFILLER_0_71_767 VGND VGND VPWR VPWR sky130_fd_sc_hd__fill_2
XFILLER_0_15_149 VGND VGND VPWR VPWR sky130_fd_sc_hd__fill_2
XFILLER_0_140_132 VGND VGND VPWR VPWR sky130_fd_sc_hd__decap_8
XFILLER_0_125_184 VGND VGND VPWR VPWR sky130_fd_sc_hd__decap_4
XFILLER_0_113_346 VGND VGND VPWR VPWR sky130_fd_sc_hd__fill_2
XFILLER_0_102_85 VGND VGND VPWR VPWR sky130_fd_sc_hd__fill_1
X_16219_ clknet_leaf_52_clk _00836_ VGND VGND VPWR VPWR net226 sky130_fd_sc_hd__dfxtp_4
XFILLER_0_70_266 VGND VGND VPWR VPWR sky130_fd_sc_hd__fill_1
XFILLER_0_113_357 VGND VGND VPWR VPWR sky130_fd_sc_hd__fill_1
XFILLER_0_3_577 VGND VGND VPWR VPWR sky130_fd_sc_hd__fill_2
XFILLER_0_11_300 VGND VGND VPWR VPWR sky130_fd_sc_hd__decap_6
XFILLER_0_121_390 VGND VGND VPWR VPWR sky130_fd_sc_hd__fill_2
X_08972_ reg_out\[23\] reg_next_pc\[23\] _03270_ VGND VGND VPWR VPWR _03273_ sky130_fd_sc_hd__mux2_1
X_07923_ _02309_ _02325_ _02328_ _02194_ _02199_ VGND VGND VPWR VPWR _02329_ sky130_fd_sc_hd__a221o_1
Xhold29 _00857_ VGND VGND VPWR VPWR net387 sky130_fd_sc_hd__dlygate4sd3_1
X_07854_ count_instr\[35\] instr_rdinstrh count_cycle\[35\] instr_rdcycleh VGND VGND
+ VPWR VPWR _02264_ sky130_fd_sc_hd__a22o_1
XFILLER_0_79_801 VGND VGND VPWR VPWR sky130_fd_sc_hd__fill_2
X_07785_ _02198_ VGND VGND VPWR VPWR _02199_ sky130_fd_sc_hd__clkbuf_4
X_09524_ cpuregs\[10\]\[1\] cpuregs\[11\]\[1\] _03751_ VGND VGND VPWR VPWR _03759_
+ sky130_fd_sc_hd__mux2_1
XFILLER_0_94_826 VGND VGND VPWR VPWR sky130_fd_sc_hd__fill_2
XFILLER_0_66_528 VGND VGND VPWR VPWR sky130_fd_sc_hd__fill_1
X_09455_ cpuregs\[8\]\[0\] cpuregs\[9\]\[0\] cpuregs\[10\]\[0\] cpuregs\[11\]\[0\]
+ _03667_ _03670_ VGND VGND VPWR VPWR _03691_ sky130_fd_sc_hd__mux4_1
X_08406_ _02782_ _02753_ _02786_ VGND VGND VPWR VPWR _02787_ sky130_fd_sc_hd__a21oi_1
XFILLER_0_19_422 VPWR VGND VPWR VGND sky130_ef_sc_hd__decap_12
X_09386_ reg_pc\[28\] reg_pc\[27\] _03612_ VGND VGND VPWR VPWR _03626_ sky130_fd_sc_hd__and3_1
XFILLER_0_108_129 VGND VGND VPWR VPWR sky130_fd_sc_hd__decap_4
XFILLER_0_74_561 VGND VGND VPWR VPWR sky130_fd_sc_hd__fill_1
XFILLER_0_46_241 VGND VGND VPWR VPWR sky130_fd_sc_hd__fill_2
XFILLER_0_19_444 VGND VGND VPWR VPWR sky130_fd_sc_hd__decap_4
X_08337_ _02445_ _02716_ VGND VGND VPWR VPWR _02718_ sky130_fd_sc_hd__nand2_1
X_08268_ reg_pc\[31\] decoded_imm\[31\] VGND VGND VPWR VPWR _02650_ sky130_fd_sc_hd__xnor2_1
XFILLER_0_131_110 VGND VGND VPWR VPWR sky130_fd_sc_hd__fill_2
X_08199_ reg_pc\[26\] decoded_imm\[26\] VGND VGND VPWR VPWR _02586_ sky130_fd_sc_hd__nand2_1
XFILLER_0_104_357 VGND VGND VPWR VPWR sky130_fd_sc_hd__decap_6
X_10230_ _02416_ _02536_ _03650_ VGND VGND VPWR VPWR _04448_ sky130_fd_sc_hd__mux2_1
X_10161_ cpuregs\[14\]\[16\] cpuregs\[15\]\[16\] _03756_ VGND VGND VPWR VPWR _04381_
+ sky130_fd_sc_hd__mux2_1
XFILLER_0_30_686 VGND VGND VPWR VPWR sky130_fd_sc_hd__decap_4
X_10092_ _03744_ _04309_ _04313_ _03885_ VGND VGND VPWR VPWR _04314_ sky130_fd_sc_hd__o211a_1
X_13920_ mem_rdata_q\[12\] mem_rdata_q\[13\] VGND VGND VPWR VPWR _07360_ sky130_fd_sc_hd__or2b_1
X_13851_ _07310_ VGND VGND VPWR VPWR _01096_ sky130_fd_sc_hd__buf_1
X_16570_ clknet_leaf_47_clk _01147_ VGND VGND VPWR VPWR cpuregs\[24\]\[22\] sky130_fd_sc_hd__dfxtp_1
X_10994_ _05035_ net1563 _05074_ VGND VGND VPWR VPWR _05079_ sky130_fd_sc_hd__mux2_1
X_13782_ cpuregs\[24\]\[30\] cpuregs\[25\]\[30\] cpuregs\[26\]\[30\] cpuregs\[27\]\[30\]
+ _06443_ _06444_ VGND VGND VPWR VPWR _07251_ sky130_fd_sc_hd__mux4_1
X_12802_ net547 net77 _06313_ VGND VGND VPWR VPWR _06316_ sky130_fd_sc_hd__mux2_1
XFILLER_0_96_141 VGND VGND VPWR VPWR sky130_fd_sc_hd__fill_2
X_12733_ _03695_ _06264_ _06266_ VGND VGND VPWR VPWR _06267_ sky130_fd_sc_hd__a21o_1
XTAP_1031 VGND VPWR sky130_fd_sc_hd__tapvpwrvgnd_1
XTAP_1020 VGND VPWR sky130_fd_sc_hd__tapvpwrvgnd_1
X_15521_ clknet_leaf_112_clk _00171_ VGND VGND VPWR VPWR cpuregs\[13\]\[7\] sky130_fd_sc_hd__dfxtp_1
XTAP_1064 VGND VPWR sky130_fd_sc_hd__tapvpwrvgnd_1
XTAP_1053 VGND VPWR sky130_fd_sc_hd__tapvpwrvgnd_1
XTAP_1042 VGND VPWR sky130_fd_sc_hd__tapvpwrvgnd_1
XFILLER_0_32_38 VGND VGND VPWR VPWR sky130_fd_sc_hd__fill_2
X_15452_ clknet_leaf_131_clk _00102_ VGND VGND VPWR VPWR cpuregs\[12\]\[2\] sky130_fd_sc_hd__dfxtp_1
X_14403_ _07615_ VGND VGND VPWR VPWR _01562_ sky130_fd_sc_hd__buf_4
XTAP_1097 VGND VPWR sky130_fd_sc_hd__tapvpwrvgnd_1
XTAP_1086 VGND VPWR sky130_fd_sc_hd__tapvpwrvgnd_1
XTAP_1075 VGND VPWR sky130_fd_sc_hd__tapvpwrvgnd_1
X_12664_ net400 _06210_ VGND VGND VPWR VPWR _06214_ sky130_fd_sc_hd__nand2_1
XFILLER_0_37_241 VGND VGND VPWR VPWR sky130_fd_sc_hd__fill_2
X_11615_ _05424_ VGND VGND VPWR VPWR _00495_ sky130_fd_sc_hd__clkbuf_1
XFILLER_0_5_809 VGND VGND VPWR VPWR sky130_fd_sc_hd__fill_2
X_15383_ clknet_leaf_120_clk _00038_ VGND VGND VPWR VPWR cpuregs\[11\]\[1\] sky130_fd_sc_hd__dfxtp_1
X_12595_ _06164_ VGND VGND VPWR VPWR _06165_ sky130_fd_sc_hd__clkbuf_2
XFILLER_0_107_162 VGND VGND VPWR VPWR sky130_fd_sc_hd__decap_6
XFILLER_0_107_140 VGND VGND VPWR VPWR sky130_fd_sc_hd__decap_4
X_11546_ _05008_ net619 _05386_ VGND VGND VPWR VPWR _05388_ sky130_fd_sc_hd__mux2_1
X_14334_ _02149_ net566 net754 _06025_ _07388_ VGND VGND VPWR VPWR _07600_ sky130_fd_sc_hd__a221o_1
XFILLER_0_25_458 VGND VGND VPWR VPWR sky130_fd_sc_hd__fill_2
XFILLER_0_107_173 VGND VGND VPWR VPWR sky130_fd_sc_hd__fill_1
X_14265_ net1176 _06290_ _07555_ _07558_ VGND VGND VPWR VPWR _00990_ sky130_fd_sc_hd__a22o_1
XFILLER_0_52_266 VGND VGND VPWR VPWR sky130_fd_sc_hd__fill_1
X_16004_ clknet_leaf_25_clk _00654_ VGND VGND VPWR VPWR reg_pc\[10\] sky130_fd_sc_hd__dfxtp_2
X_13216_ _06537_ _06698_ _06701_ VGND VGND VPWR VPWR _06702_ sky130_fd_sc_hd__a21o_1
X_11477_ net643 _05184_ _05349_ VGND VGND VPWR VPWR _05351_ sky130_fd_sc_hd__mux2_1
XFILLER_0_40_439 VGND VGND VPWR VPWR sky130_fd_sc_hd__fill_2
X_14196_ _07522_ VGND VGND VPWR VPWR _00957_ sky130_fd_sc_hd__clkbuf_1
X_10428_ _03738_ _04636_ _04640_ _03806_ VGND VGND VPWR VPWR _04641_ sky130_fd_sc_hd__o211a_1
XFILLER_0_20_141 VGND VGND VPWR VPWR sky130_fd_sc_hd__decap_6
X_10359_ _03794_ _04560_ _04573_ _03775_ reg_pc\[21\] VGND VGND VPWR VPWR _04574_
+ sky130_fd_sc_hd__a32o_1
X_13147_ _06351_ _06634_ _03377_ VGND VGND VPWR VPWR _06635_ sky130_fd_sc_hd__a21o_1
XTAP_804 VGND VPWR sky130_fd_sc_hd__tapvpwrvgnd_1
XTAP_815 VGND VPWR sky130_fd_sc_hd__tapvpwrvgnd_1
XTAP_826 VGND VPWR sky130_fd_sc_hd__tapvpwrvgnd_1
X_13078_ _06568_ VGND VGND VPWR VPWR _00814_ sky130_fd_sc_hd__clkbuf_1
XTAP_837 VGND VPWR sky130_fd_sc_hd__tapvpwrvgnd_1
XTAP_848 VGND VPWR sky130_fd_sc_hd__tapvpwrvgnd_1
XTAP_859 VGND VPWR sky130_fd_sc_hd__tapvpwrvgnd_1
X_16906_ clknet_leaf_71_clk _01470_ VGND VGND VPWR VPWR cpuregs\[8\]\[25\] sky130_fd_sc_hd__dfxtp_1
X_12029_ _03448_ reg_next_pc\[1\] _03221_ VGND VGND VPWR VPWR _05689_ sky130_fd_sc_hd__mux2_2
XFILLER_0_73_12 VGND VGND VPWR VPWR sky130_fd_sc_hd__decap_3
X_16837_ clknet_leaf_82_clk _01401_ VGND VGND VPWR VPWR cpuregs\[7\]\[20\] sky130_fd_sc_hd__dfxtp_1
X_16768_ clknet_leaf_87_clk _01332_ VGND VGND VPWR VPWR cpuregs\[5\]\[15\] sky130_fd_sc_hd__dfxtp_1
X_15719_ clknet_leaf_98_clk _00369_ VGND VGND VPWR VPWR cpuregs\[21\]\[13\] sky130_fd_sc_hd__dfxtp_1
X_16699_ clknet_leaf_102_clk _01266_ VGND VGND VPWR VPWR cpuregs\[3\]\[13\] sky130_fd_sc_hd__dfxtp_1
X_09240_ _03499_ VGND VGND VPWR VPWR _00045_ sky130_fd_sc_hd__clkbuf_1
X_09171_ _03434_ _03438_ VGND VGND VPWR VPWR _03439_ sky130_fd_sc_hd__and2_2
XFILLER_0_8_669 VGND VGND VPWR VPWR sky130_fd_sc_hd__fill_1
XFILLER_0_83_391 VGND VGND VPWR VPWR sky130_fd_sc_hd__fill_1
X_08122_ _02204_ count_cycle\[53\] VGND VGND VPWR VPWR _02514_ sky130_fd_sc_hd__and2_1
XFILLER_0_22_93 VGND VGND VPWR VPWR sky130_fd_sc_hd__fill_2
XFILLER_0_126_482 VGND VGND VPWR VPWR sky130_fd_sc_hd__fill_2
XFILLER_0_98_42 VGND VGND VPWR VPWR sky130_fd_sc_hd__fill_1
XFILLER_0_98_20 VGND VGND VPWR VPWR sky130_fd_sc_hd__fill_2
X_08053_ _02207_ _02445_ _02446_ _02449_ VGND VGND VPWR VPWR _02450_ sky130_fd_sc_hd__o2bb2a_1
XFILLER_0_44_778 VGND VGND VPWR VPWR sky130_fd_sc_hd__fill_1
XFILLER_0_3_330 VGND VGND VPWR VPWR sky130_fd_sc_hd__fill_2
XFILLER_0_3_363 VGND VGND VPWR VPWR sky130_fd_sc_hd__fill_2
XFILLER_0_3_352 VGND VGND VPWR VPWR sky130_fd_sc_hd__fill_2
XFILLER_0_24_480 VGND VGND VPWR VPWR sky130_fd_sc_hd__fill_2
XFILLER_0_114_699 VGND VGND VPWR VPWR sky130_fd_sc_hd__fill_1
XFILLER_0_98_97 VPWR VGND VPWR VGND sky130_ef_sc_hd__decap_12
XFILLER_0_11_141 VGND VGND VPWR VPWR sky130_fd_sc_hd__decap_4
XFILLER_0_101_349 VGND VGND VPWR VPWR sky130_fd_sc_hd__decap_4
Xpicorv32_285 VGND VGND VPWR VPWR picorv32_285/HI mem_addr[0] sky130_fd_sc_hd__conb_1
Xpicorv32_263 VGND VGND VPWR VPWR picorv32_263/HI eoi[10] sky130_fd_sc_hd__conb_1
Xpicorv32_296 VGND VGND VPWR VPWR picorv32_296/HI pcpi_insn[7] sky130_fd_sc_hd__conb_1
Xpicorv32_274 VGND VGND VPWR VPWR picorv32_274/HI eoi[21] sky130_fd_sc_hd__conb_1
XFILLER_0_11_174 VGND VGND VPWR VPWR sky130_fd_sc_hd__fill_2
X_08955_ reg_out\[18\] reg_next_pc\[18\] _03248_ VGND VGND VPWR VPWR _03261_ sky130_fd_sc_hd__mux2_1
X_07906_ net29 net130 _02312_ _02219_ VGND VGND VPWR VPWR _02313_ sky130_fd_sc_hd__a22o_1
X_08886_ _03218_ VGND VGND VPWR VPWR net110 sky130_fd_sc_hd__clkbuf_4
XFILLER_0_79_620 VGND VGND VPWR VPWR sky130_fd_sc_hd__fill_2
X_07837_ net10 _02216_ _02247_ _02212_ VGND VGND VPWR VPWR _02248_ sky130_fd_sc_hd__a22o_1
X_07768_ _02185_ _02138_ VGND VGND VPWR VPWR _02186_ sky130_fd_sc_hd__nand2_1
XFILLER_0_78_163 VPWR VGND VPWR VGND sky130_ef_sc_hd__decap_12
XFILLER_0_78_141 VGND VGND VPWR VPWR sky130_fd_sc_hd__fill_2
X_09507_ _03724_ _03741_ VGND VGND VPWR VPWR _03742_ sky130_fd_sc_hd__nor2_1
XFILLER_0_93_122 VGND VGND VPWR VPWR sky130_fd_sc_hd__decap_3
XPHY_125 VGND VGND VPWR VPWR sky130_fd_sc_hd__decap_3
XPHY_114 VGND VGND VPWR VPWR sky130_fd_sc_hd__decap_3
XPHY_103 VGND VGND VPWR VPWR sky130_fd_sc_hd__decap_3
X_07699_ instr_srai instr_slli instr_jalr _02124_ VGND VGND VPWR VPWR _02125_ sky130_fd_sc_hd__or4_1
XFILLER_0_136_202 VPWR VGND VPWR VGND sky130_ef_sc_hd__decap_12
X_09438_ _03673_ VGND VGND VPWR VPWR _03674_ sky130_fd_sc_hd__buf_4
XFILLER_0_93_144 VGND VGND VPWR VPWR sky130_fd_sc_hd__fill_2
XFILLER_0_82_807 VGND VGND VPWR VPWR sky130_fd_sc_hd__fill_1
XPHY_158 VGND VGND VPWR VPWR sky130_fd_sc_hd__decap_3
XPHY_147 VGND VGND VPWR VPWR sky130_fd_sc_hd__decap_3
XPHY_136 VGND VGND VPWR VPWR sky130_fd_sc_hd__decap_3
XFILLER_0_66_358 VGND VGND VPWR VPWR sky130_fd_sc_hd__decap_3
X_09369_ _03611_ VGND VGND VPWR VPWR _00062_ sky130_fd_sc_hd__clkbuf_1
XPHY_169 VGND VGND VPWR VPWR sky130_fd_sc_hd__decap_3
X_12380_ _05981_ _05739_ VGND VGND VPWR VPWR _05989_ sky130_fd_sc_hd__xor2_1
X_11400_ net1256 _05175_ _05302_ VGND VGND VPWR VPWR _05310_ sky130_fd_sc_hd__mux2_1
XANTENNA_92 net127 VGND VGND VPWR VPWR sky130_fd_sc_hd__diode_2
XANTENNA_81 net112 VGND VGND VPWR VPWR sky130_fd_sc_hd__diode_2
XANTENNA_70 net90 VGND VGND VPWR VPWR sky130_fd_sc_hd__diode_2
XFILLER_0_22_417 VGND VGND VPWR VPWR sky130_fd_sc_hd__decap_3
X_11331_ _05273_ VGND VGND VPWR VPWR _00362_ sky130_fd_sc_hd__clkbuf_1
X_11262_ _05236_ VGND VGND VPWR VPWR _00330_ sky130_fd_sc_hd__clkbuf_1
X_14050_ net567 VGND VGND VPWR VPWR _01100_ sky130_fd_sc_hd__clkbuf_1
X_10213_ _03766_ _04429_ _04431_ VGND VGND VPWR VPWR _04432_ sky130_fd_sc_hd__a21o_1
X_11193_ _05191_ VGND VGND VPWR VPWR _00306_ sky130_fd_sc_hd__clkbuf_1
X_13001_ cpuregs\[28\]\[6\] cpuregs\[29\]\[6\] _06349_ VGND VGND VPWR VPWR _06494_
+ sky130_fd_sc_hd__mux2_1
X_10144_ _04226_ _04258_ _04257_ VGND VGND VPWR VPWR _04364_ sky130_fd_sc_hd__o21a_1
XFILLER_0_118_29 VGND VGND VPWR VPWR sky130_fd_sc_hd__decap_6
XFILLER_0_27_27 VGND VGND VPWR VPWR sky130_fd_sc_hd__decap_6
X_14952_ _01853_ VGND VGND VPWR VPWR _01338_ sky130_fd_sc_hd__clkbuf_1
X_10075_ _04226_ _04230_ _04257_ _04258_ VGND VGND VPWR VPWR _04297_ sky130_fd_sc_hd__a31o_1
X_14883_ _03584_ net1164 _01815_ VGND VGND VPWR VPWR _01817_ sky130_fd_sc_hd__mux2_1
X_13903_ _07327_ mem_rdata_q\[13\] mem_rdata_q\[12\] VGND VGND VPWR VPWR _07350_ sky130_fd_sc_hd__and3_1
X_13834_ _02164_ _07298_ VGND VGND VPWR VPWR _00840_ sky130_fd_sc_hd__nor2_1
X_16622_ clknet_leaf_126_clk _01189_ VGND VGND VPWR VPWR cpuregs\[23\]\[0\] sky130_fd_sc_hd__dfxtp_1
XFILLER_0_57_303 VGND VGND VPWR VPWR sky130_fd_sc_hd__fill_1
X_13765_ _03340_ _07233_ _06998_ VGND VGND VPWR VPWR _07234_ sky130_fd_sc_hd__a21o_1
X_10977_ _05018_ net1247 _05063_ VGND VGND VPWR VPWR _05070_ sky130_fd_sc_hd__mux2_1
XFILLER_0_57_325 VGND VGND VPWR VPWR sky130_fd_sc_hd__fill_2
XPHY_5 VGND VGND VPWR VPWR sky130_fd_sc_hd__decap_3
X_16553_ clknet_leaf_130_clk _01130_ VGND VGND VPWR VPWR cpuregs\[24\]\[5\] sky130_fd_sc_hd__dfxtp_1
X_13696_ _06421_ _07165_ _07167_ _06894_ VGND VGND VPWR VPWR _07168_ sky130_fd_sc_hd__a211o_1
X_15504_ clknet_leaf_61_clk _00154_ VGND VGND VPWR VPWR cpuregs\[30\]\[22\] sky130_fd_sc_hd__dfxtp_1
X_12716_ net416 _06247_ _06251_ VGND VGND VPWR VPWR _00769_ sky130_fd_sc_hd__o21a_1
X_16484_ clknet_leaf_142_clk _01066_ VGND VGND VPWR VPWR cpuregs\[19\]\[5\] sky130_fd_sc_hd__dfxtp_1
XFILLER_0_127_257 VGND VGND VPWR VPWR sky130_fd_sc_hd__fill_2
X_15435_ clknet_leaf_52_clk _00085_ VGND VGND VPWR VPWR net178 sky130_fd_sc_hd__dfxtp_4
X_12647_ _06200_ _06179_ _06201_ VGND VGND VPWR VPWR _06202_ sky130_fd_sc_hd__and3b_1
XFILLER_0_26_701 VGND VGND VPWR VPWR sky130_fd_sc_hd__fill_1
X_15366_ _02070_ VGND VGND VPWR VPWR _01535_ sky130_fd_sc_hd__clkbuf_1
XFILLER_0_25_222 VGND VGND VPWR VPWR sky130_fd_sc_hd__fill_2
X_12578_ count_cycle\[23\] _06150_ VGND VGND VPWR VPWR _06153_ sky130_fd_sc_hd__or2_1
XFILLER_0_25_277 VGND VGND VPWR VPWR sky130_fd_sc_hd__decap_3
Xhold307 cpuregs\[22\]\[26\] VGND VGND VPWR VPWR net665 sky130_fd_sc_hd__dlygate4sd3_1
X_15297_ net493 VGND VGND VPWR VPWR _02034_ sky130_fd_sc_hd__clkbuf_1
X_14317_ _07320_ decoded_imm_j\[19\] _07570_ mem_rdata_q\[19\] _07357_ VGND VGND VPWR
+ VPWR _07591_ sky130_fd_sc_hd__a221o_1
X_11529_ _04991_ net1513 _05375_ VGND VGND VPWR VPWR _05379_ sky130_fd_sc_hd__mux2_1
XFILLER_0_25_288 VGND VGND VPWR VPWR sky130_fd_sc_hd__fill_1
XFILLER_0_40_214 VGND VGND VPWR VPWR sky130_fd_sc_hd__fill_1
X_14248_ _07549_ VGND VGND VPWR VPWR _00982_ sky130_fd_sc_hd__clkbuf_1
Xhold329 cpuregs\[26\]\[20\] VGND VGND VPWR VPWR net687 sky130_fd_sc_hd__dlygate4sd3_1
Xhold318 cpuregs\[25\]\[20\] VGND VGND VPWR VPWR net676 sky130_fd_sc_hd__dlygate4sd3_1
X_14179_ _07508_ _07509_ _06290_ VGND VGND VPWR VPWR _07510_ sky130_fd_sc_hd__a21oi_1
XFILLER_0_0_355 VGND VGND VPWR VPWR sky130_fd_sc_hd__fill_1
XTAP_601 VGND VPWR sky130_fd_sc_hd__tapvpwrvgnd_1
XTAP_612 VGND VPWR sky130_fd_sc_hd__tapvpwrvgnd_1
XTAP_623 VGND VPWR sky130_fd_sc_hd__tapvpwrvgnd_1
XTAP_634 VGND VPWR sky130_fd_sc_hd__tapvpwrvgnd_1
XTAP_645 VGND VPWR sky130_fd_sc_hd__tapvpwrvgnd_1
XTAP_656 VGND VPWR sky130_fd_sc_hd__tapvpwrvgnd_1
XTAP_667 VGND VPWR sky130_fd_sc_hd__tapvpwrvgnd_1
X_08740_ _02705_ _02846_ _03098_ VGND VGND VPWR VPWR _03099_ sky130_fd_sc_hd__a21o_1
Xhold1018 cpuregs\[7\]\[20\] VGND VGND VPWR VPWR net1376 sky130_fd_sc_hd__dlygate4sd3_1
Xhold1007 cpuregs\[2\]\[17\] VGND VGND VPWR VPWR net1365 sky130_fd_sc_hd__dlygate4sd3_1
Xhold1029 cpuregs\[11\]\[1\] VGND VGND VPWR VPWR net1387 sky130_fd_sc_hd__dlygate4sd3_1
XTAP_689 VGND VPWR sky130_fd_sc_hd__tapvpwrvgnd_1
XTAP_678 VGND VPWR sky130_fd_sc_hd__tapvpwrvgnd_1
X_08671_ _02765_ _03034_ VGND VGND VPWR VPWR _03035_ sky130_fd_sc_hd__xnor2_1
XFILLER_0_108_62 VGND VGND VPWR VPWR sky130_fd_sc_hd__fill_1
XFILLER_0_124_83 VGND VGND VPWR VPWR sky130_fd_sc_hd__fill_1
XFILLER_0_29_550 VGND VGND VPWR VPWR sky130_fd_sc_hd__fill_1
XFILLER_0_91_615 VGND VGND VPWR VPWR sky130_fd_sc_hd__fill_1
X_09223_ net1270 _03484_ _03446_ VGND VGND VPWR VPWR _03485_ sky130_fd_sc_hd__mux2_1
XFILLER_0_90_147 VGND VGND VPWR VPWR sky130_fd_sc_hd__decap_6
XFILLER_0_44_542 VGND VGND VPWR VPWR sky130_fd_sc_hd__fill_2
XFILLER_0_17_756 VGND VGND VPWR VPWR sky130_fd_sc_hd__decap_4
X_09154_ _03426_ VGND VGND VPWR VPWR _00029_ sky130_fd_sc_hd__clkbuf_1
XFILLER_0_127_791 VGND VGND VPWR VPWR sky130_fd_sc_hd__fill_1
X_08105_ _02496_ _02497_ VGND VGND VPWR VPWR _02498_ sky130_fd_sc_hd__nand2_1
X_09085_ _03365_ _02157_ reg_sh\[2\] VGND VGND VPWR VPWR _03366_ sky130_fd_sc_hd__a21oi_1
Xhold830 cpuregs\[15\]\[28\] VGND VGND VPWR VPWR net1188 sky130_fd_sc_hd__dlygate4sd3_1
X_08036_ _02309_ _02426_ _02199_ _02433_ VGND VGND VPWR VPWR _02434_ sky130_fd_sc_hd__a211o_1
XFILLER_0_31_269 VGND VGND VPWR VPWR sky130_fd_sc_hd__fill_1
Xhold852 cpuregs\[26\]\[25\] VGND VGND VPWR VPWR net1210 sky130_fd_sc_hd__dlygate4sd3_1
Xhold863 cpuregs\[9\]\[18\] VGND VGND VPWR VPWR net1221 sky130_fd_sc_hd__dlygate4sd3_1
Xhold841 decoded_imm\[25\] VGND VGND VPWR VPWR net1199 sky130_fd_sc_hd__dlygate4sd3_1
XFILLER_0_40_770 VGND VGND VPWR VPWR sky130_fd_sc_hd__fill_2
XFILLER_0_40_781 VGND VGND VPWR VPWR sky130_fd_sc_hd__fill_1
Xhold896 cpuregs\[3\]\[29\] VGND VGND VPWR VPWR net1254 sky130_fd_sc_hd__dlygate4sd3_1
Xhold874 cpuregs\[17\]\[26\] VGND VGND VPWR VPWR net1232 sky130_fd_sc_hd__dlygate4sd3_1
Xhold885 cpuregs\[25\]\[10\] VGND VGND VPWR VPWR net1243 sky130_fd_sc_hd__dlygate4sd3_1
X_09987_ _03696_ _04209_ _04211_ VGND VGND VPWR VPWR _04212_ sky130_fd_sc_hd__a21o_1
X_08938_ _02391_ _03249_ _03246_ VGND VGND VPWR VPWR _03250_ sky130_fd_sc_hd__mux2_1
X_08869_ _02143_ net250 net207 _02133_ VGND VGND VPWR VPWR _03210_ sky130_fd_sc_hd__a22o_1
X_10900_ _05022_ net1472 _05006_ VGND VGND VPWR VPWR _05023_ sky130_fd_sc_hd__mux2_1
X_11880_ count_instr\[22\] _05579_ VGND VGND VPWR VPWR _05582_ sky130_fd_sc_hd__or2_1
X_10831_ _04976_ VGND VGND VPWR VPWR _00159_ sky130_fd_sc_hd__clkbuf_1
X_10762_ _04938_ VGND VGND VPWR VPWR _00128_ sky130_fd_sc_hd__clkbuf_1
X_13550_ _07026_ VGND VGND VPWR VPWR _00828_ sky130_fd_sc_hd__clkbuf_1
X_12501_ net442 _05696_ _05526_ _06099_ VGND VGND VPWR VPWR _00706_ sky130_fd_sc_hd__o211a_1
XFILLER_0_109_246 VPWR VGND VPWR VGND sky130_ef_sc_hd__decap_12
X_13481_ _06374_ VGND VGND VPWR VPWR _06960_ sky130_fd_sc_hd__buf_4
XFILLER_0_66_155 VGND VGND VPWR VPWR sky130_fd_sc_hd__decap_4
XFILLER_0_54_328 VGND VGND VPWR VPWR sky130_fd_sc_hd__decap_4
XFILLER_0_137_577 VGND VGND VPWR VPWR sky130_fd_sc_hd__fill_1
X_12432_ _05995_ _06015_ _06036_ _06026_ VGND VGND VPWR VPWR _06037_ sky130_fd_sc_hd__and4b_1
XFILLER_0_109_279 VGND VGND VPWR VPWR sky130_fd_sc_hd__fill_1
X_10693_ _04898_ _02646_ _03714_ VGND VGND VPWR VPWR _04899_ sky130_fd_sc_hd__mux2_1
X_15220_ _01972_ VGND VGND VPWR VPWR _01995_ sky130_fd_sc_hd__buf_4
XFILLER_0_124_249 VGND VGND VPWR VPWR sky130_fd_sc_hd__decap_3
XFILLER_0_105_452 VGND VGND VPWR VPWR sky130_fd_sc_hd__fill_2
X_12363_ _05961_ _05972_ _05971_ VGND VGND VPWR VPWR _05974_ sky130_fd_sc_hd__a21o_1
X_15151_ _01958_ VGND VGND VPWR VPWR _01432_ sky130_fd_sc_hd__clkbuf_1
XFILLER_0_2_609 VGND VGND VPWR VPWR sky130_fd_sc_hd__fill_1
XFILLER_0_133_794 VPWR VGND VPWR VGND sky130_ef_sc_hd__decap_12
XFILLER_0_133_783 VGND VGND VPWR VPWR sky130_fd_sc_hd__fill_1
XFILLER_0_132_271 VGND VGND VPWR VPWR sky130_fd_sc_hd__decap_4
X_12294_ _05791_ _05910_ net383 VGND VGND VPWR VPWR _05911_ sky130_fd_sc_hd__o21ai_1
X_15082_ net1138 _05200_ _01912_ VGND VGND VPWR VPWR _01922_ sky130_fd_sc_hd__mux2_1
X_11314_ _05263_ VGND VGND VPWR VPWR _00355_ sky130_fd_sc_hd__clkbuf_1
X_14102_ _07469_ VGND VGND VPWR VPWR _00916_ sky130_fd_sc_hd__clkbuf_1
XFILLER_0_120_444 VGND VGND VPWR VPWR sky130_fd_sc_hd__decap_4
X_11245_ _05226_ VGND VGND VPWR VPWR _00323_ sky130_fd_sc_hd__clkbuf_1
X_14033_ mem_rdata_q\[30\] net24 _07422_ VGND VGND VPWR VPWR _07433_ sky130_fd_sc_hd__mux2_1
XFILLER_0_120_488 VGND VGND VPWR VPWR sky130_fd_sc_hd__fill_1
XFILLER_0_38_15 VPWR VGND VPWR VGND sky130_ef_sc_hd__decap_12
X_11176_ net680 _05179_ _05161_ VGND VGND VPWR VPWR _05180_ sky130_fd_sc_hd__mux2_1
X_10127_ _03695_ _04345_ _04347_ VGND VGND VPWR VPWR _04348_ sky130_fd_sc_hd__a21o_1
X_15984_ clknet_leaf_152_clk _00634_ VGND VGND VPWR VPWR count_instr\[53\] sky130_fd_sc_hd__dfxtp_1
X_10058_ _03695_ _04278_ _04280_ VGND VGND VPWR VPWR _04281_ sky130_fd_sc_hd__a21o_1
X_14935_ _01844_ VGND VGND VPWR VPWR _01330_ sky130_fd_sc_hd__clkbuf_1
XFILLER_0_89_247 VGND VGND VPWR VPWR sky130_fd_sc_hd__fill_1
X_14866_ _03532_ net771 _01804_ VGND VGND VPWR VPWR _01808_ sky130_fd_sc_hd__mux2_1
X_16605_ clknet_leaf_88_clk _01172_ VGND VGND VPWR VPWR cpuregs\[9\]\[15\] sky130_fd_sc_hd__dfxtp_1
X_13817_ _06442_ _07280_ _07284_ _06428_ VGND VGND VPWR VPWR _07285_ sky130_fd_sc_hd__o211a_1
X_14797_ net1207 _05188_ _01767_ VGND VGND VPWR VPWR _01771_ sky130_fd_sc_hd__mux2_1
X_13748_ cpuregs\[20\]\[29\] cpuregs\[21\]\[29\] _06456_ VGND VGND VPWR VPWR _07218_
+ sky130_fd_sc_hd__mux2_1
XFILLER_0_70_24 VGND VGND VPWR VPWR sky130_fd_sc_hd__fill_1
X_16536_ clknet_leaf_16_clk _01113_ VGND VGND VPWR VPWR mem_rdata_q\[20\] sky130_fd_sc_hd__dfxtp_1
XFILLER_0_57_122 VGND VGND VPWR VPWR sky130_fd_sc_hd__decap_6
XFILLER_0_18_509 VGND VGND VPWR VPWR sky130_fd_sc_hd__fill_1
XFILLER_0_128_533 VGND VGND VPWR VPWR sky130_fd_sc_hd__decap_8
XFILLER_0_73_615 VGND VGND VPWR VPWR sky130_fd_sc_hd__fill_1
X_13679_ _06970_ _07150_ VGND VGND VPWR VPWR _07151_ sky130_fd_sc_hd__and2_1
X_16467_ clknet_leaf_52_clk _01049_ VGND VGND VPWR VPWR cpuregs\[18\]\[20\] sky130_fd_sc_hd__dfxtp_1
XFILLER_0_70_79 VGND VGND VPWR VPWR sky130_fd_sc_hd__decap_4
XFILLER_0_57_188 VGND VGND VPWR VPWR sky130_fd_sc_hd__decap_4
X_16398_ clknet_leaf_33_clk _00980_ VGND VGND VPWR VPWR net152 sky130_fd_sc_hd__dfxtp_1
XFILLER_0_92_9 VGND VGND VPWR VPWR sky130_fd_sc_hd__decap_4
XFILLER_0_60_309 VGND VGND VPWR VPWR sky130_fd_sc_hd__decap_6
XFILLER_0_5_436 VGND VGND VPWR VPWR sky130_fd_sc_hd__fill_1
X_15418_ clknet_leaf_139_clk _00031_ VGND VGND VPWR VPWR _00011_ sky130_fd_sc_hd__dfxtp_4
X_15349_ _02061_ VGND VGND VPWR VPWR _01527_ sky130_fd_sc_hd__clkbuf_1
XFILLER_0_13_225 VGND VGND VPWR VPWR sky130_fd_sc_hd__decap_8
XFILLER_0_124_783 VGND VGND VPWR VPWR sky130_fd_sc_hd__decap_6
XFILLER_0_78_7 VGND VGND VPWR VPWR sky130_fd_sc_hd__fill_1
Xhold104 cpuregs\[0\]\[1\] VGND VGND VPWR VPWR net462 sky130_fd_sc_hd__dlygate4sd3_1
Xhold115 is_alu_reg_imm VGND VGND VPWR VPWR net473 sky130_fd_sc_hd__dlygate4sd3_1
Xhold126 cpuregs\[0\]\[9\] VGND VGND VPWR VPWR net484 sky130_fd_sc_hd__dlygate4sd3_1
Xhold159 net61 VGND VGND VPWR VPWR net517 sky130_fd_sc_hd__dlygate4sd3_1
Xhold148 net65 VGND VGND VPWR VPWR net506 sky130_fd_sc_hd__dlygate4sd3_1
Xhold137 net164 VGND VGND VPWR VPWR net495 sky130_fd_sc_hd__dlygate4sd3_1
X_09910_ _03823_ _04136_ _03826_ VGND VGND VPWR VPWR _04137_ sky130_fd_sc_hd__a21o_1
XFILLER_0_0_141 VPWR VGND VPWR VGND sky130_ef_sc_hd__decap_12
XFILLER_0_22_792 VGND VGND VPWR VPWR sky130_fd_sc_hd__fill_2
X_09841_ _04068_ _04069_ VGND VGND VPWR VPWR _04070_ sky130_fd_sc_hd__nand2_1
XTAP_442 VGND VPWR sky130_fd_sc_hd__tapvpwrvgnd_1
XTAP_431 VGND VPWR sky130_fd_sc_hd__tapvpwrvgnd_1
XTAP_420 VGND VPWR sky130_fd_sc_hd__tapvpwrvgnd_1
X_09772_ decoded_imm\[6\] net199 VGND VGND VPWR VPWR _04002_ sky130_fd_sc_hd__and2_1
XTAP_453 VGND VPWR sky130_fd_sc_hd__tapvpwrvgnd_1
XTAP_464 VGND VPWR sky130_fd_sc_hd__tapvpwrvgnd_1
XTAP_475 VGND VPWR sky130_fd_sc_hd__tapvpwrvgnd_1
X_08723_ _03068_ _03081_ _03082_ VGND VGND VPWR VPWR _03083_ sky130_fd_sc_hd__a21bo_1
XTAP_486 VGND VPWR sky130_fd_sc_hd__tapvpwrvgnd_1
XTAP_497 VGND VPWR sky130_fd_sc_hd__tapvpwrvgnd_1
XFILLER_0_28_70 VGND VGND VPWR VPWR sky130_fd_sc_hd__decap_6
XTAP_2309 VGND VPWR sky130_fd_sc_hd__tapvpwrvgnd_1
X_08654_ net240 VGND VGND VPWR VPWR _03020_ sky130_fd_sc_hd__clkbuf_4
XFILLER_0_139_809 VGND VGND VPWR VPWR sky130_fd_sc_hd__decap_6
XFILLER_0_135_93 VPWR VGND VPWR VGND sky130_ef_sc_hd__decap_12
XTAP_1619 VGND VPWR sky130_fd_sc_hd__tapvpwrvgnd_1
XTAP_1608 VGND VPWR sky130_fd_sc_hd__tapvpwrvgnd_1
X_08585_ _02366_ _02955_ VGND VGND VPWR VPWR _02956_ sky130_fd_sc_hd__nand2_1
XFILLER_0_119_500 VGND VGND VPWR VPWR sky130_fd_sc_hd__decap_4
XFILLER_0_48_133 VGND VGND VPWR VPWR sky130_fd_sc_hd__decap_6
X_09206_ reg_pc\[3\] reg_pc\[2\] reg_pc\[4\] VGND VGND VPWR VPWR _03470_ sky130_fd_sc_hd__a21o_1
XFILLER_0_9_797 VPWR VGND VPWR VGND sky130_ef_sc_hd__decap_12
XFILLER_0_8_285 VPWR VGND VPWR VGND sky130_ef_sc_hd__decap_12
XFILLER_0_17_564 VGND VGND VPWR VPWR sky130_fd_sc_hd__fill_1
XFILLER_0_134_569 VGND VGND VPWR VPWR sky130_fd_sc_hd__fill_2
XFILLER_0_122_709 VGND VGND VPWR VPWR sky130_fd_sc_hd__fill_1
XFILLER_0_44_372 VGND VGND VPWR VPWR sky130_fd_sc_hd__fill_1
X_09137_ _03345_ _03413_ _03415_ VGND VGND VPWR VPWR _03416_ sky130_fd_sc_hd__a21o_1
XFILLER_0_17_586 VGND VGND VPWR VPWR sky130_fd_sc_hd__fill_2
XFILLER_0_115_772 VGND VGND VPWR VPWR sky130_fd_sc_hd__fill_1
XFILLER_0_44_394 VGND VGND VPWR VPWR sky130_fd_sc_hd__fill_2
XFILLER_0_32_556 VGND VGND VPWR VPWR sky130_fd_sc_hd__fill_1
X_09068_ _03346_ _03348_ _03310_ VGND VGND VPWR VPWR _03349_ sky130_fd_sc_hd__a21o_1
X_08019_ count_instr\[14\] _02270_ count_cycle\[14\] _02173_ _02417_ VGND VGND VPWR
+ VPWR _02418_ sky130_fd_sc_hd__a221o_2
Xhold660 cpuregs\[5\]\[2\] VGND VGND VPWR VPWR net1018 sky130_fd_sc_hd__dlygate4sd3_1
Xhold671 cpuregs\[20\]\[8\] VGND VGND VPWR VPWR net1029 sky130_fd_sc_hd__dlygate4sd3_1
Xhold682 cpuregs\[20\]\[12\] VGND VGND VPWR VPWR net1040 sky130_fd_sc_hd__dlygate4sd3_1
Xhold693 net40 VGND VGND VPWR VPWR net1051 sky130_fd_sc_hd__dlygate4sd3_1
X_11030_ net1101 _03504_ _05088_ VGND VGND VPWR VPWR _05098_ sky130_fd_sc_hd__mux2_1
X_12981_ cpuregs\[8\]\[6\] cpuregs\[9\]\[6\] _06422_ VGND VGND VPWR VPWR _06474_ sky130_fd_sc_hd__mux2_1
XFILLER_0_99_556 VGND VGND VPWR VPWR sky130_fd_sc_hd__fill_1
XFILLER_0_87_729 VGND VGND VPWR VPWR sky130_fd_sc_hd__fill_2
X_11932_ count_instr\[35\] count_instr\[34\] _05609_ _05618_ VGND VGND VPWR VPWR _05619_
+ sky130_fd_sc_hd__and4_1
X_14720_ _05003_ net1643 _01720_ VGND VGND VPWR VPWR _01730_ sky130_fd_sc_hd__mux2_1
X_11863_ _05569_ VGND VGND VPWR VPWR _00598_ sky130_fd_sc_hd__clkbuf_1
XFILLER_0_24_39 VGND VGND VPWR VPWR sky130_fd_sc_hd__fill_1
X_14651_ _01693_ VGND VGND VPWR VPWR _01197_ sky130_fd_sc_hd__clkbuf_1
X_13602_ cpuregs\[24\]\[24\] cpuregs\[25\]\[24\] cpuregs\[26\]\[24\] cpuregs\[27\]\[24\]
+ _06856_ _06889_ VGND VGND VPWR VPWR _07077_ sky130_fd_sc_hd__mux4_1
X_10814_ _04967_ VGND VGND VPWR VPWR _00151_ sky130_fd_sc_hd__clkbuf_1
XFILLER_0_67_453 VGND VGND VPWR VPWR sky130_fd_sc_hd__fill_1
XFILLER_0_94_250 VGND VGND VPWR VPWR sky130_fd_sc_hd__fill_2
X_16321_ clknet_leaf_16_clk _00906_ VGND VGND VPWR VPWR decoded_imm_j\[11\] sky130_fd_sc_hd__dfxtp_2
X_14582_ _05001_ net1372 _01648_ VGND VGND VPWR VPWR _01657_ sky130_fd_sc_hd__mux2_1
X_11794_ _05518_ VGND VGND VPWR VPWR _00580_ sky130_fd_sc_hd__clkbuf_1
XFILLER_0_131_29 VPWR VGND VPWR VGND sky130_ef_sc_hd__decap_12
XFILLER_0_125_514 VGND VGND VPWR VPWR sky130_fd_sc_hd__decap_3
X_13533_ cpuregs\[16\]\[22\] cpuregs\[17\]\[22\] cpuregs\[18\]\[22\] cpuregs\[19\]\[22\]
+ _06945_ _06979_ VGND VGND VPWR VPWR _07010_ sky130_fd_sc_hd__mux4_1
X_10745_ net935 _03577_ _04929_ VGND VGND VPWR VPWR _04930_ sky130_fd_sc_hd__mux2_1
XFILLER_0_67_497 VGND VGND VPWR VPWR sky130_fd_sc_hd__decap_6
X_16252_ clknet_leaf_43_clk alu_out\[25\] VGND VGND VPWR VPWR alu_out_q\[25\] sky130_fd_sc_hd__dfxtp_1
X_10676_ _03878_ _04879_ _04881_ VGND VGND VPWR VPWR _04882_ sky130_fd_sc_hd__a21o_1
X_13464_ _06638_ _06938_ _06940_ _06739_ _06942_ VGND VGND VPWR VPWR _06943_ sky130_fd_sc_hd__o311a_1
XFILLER_0_54_169 VGND VGND VPWR VPWR sky130_fd_sc_hd__fill_1
X_16183_ clknet_leaf_36_clk _00801_ VGND VGND VPWR VPWR net57 sky130_fd_sc_hd__dfxtp_1
X_12415_ _05745_ _06009_ VGND VGND VPWR VPWR _06022_ sky130_fd_sc_hd__and2_1
X_13395_ _06639_ _06875_ VGND VGND VPWR VPWR _06876_ sky130_fd_sc_hd__and2_1
XFILLER_0_63_670 VGND VGND VPWR VPWR sky130_fd_sc_hd__fill_2
X_15203_ _01986_ VGND VGND VPWR VPWR _01456_ sky130_fd_sc_hd__clkbuf_1
XFILLER_0_51_821 VGND VGND VPWR VPWR sky130_fd_sc_hd__decap_3
X_12346_ _05944_ _05958_ _05695_ VGND VGND VPWR VPWR _05959_ sky130_fd_sc_hd__o21ai_1
XFILLER_0_62_191 VGND VGND VPWR VPWR sky130_fd_sc_hd__decap_4
X_15134_ net707 _03518_ _01948_ VGND VGND VPWR VPWR _01950_ sky130_fd_sc_hd__mux2_1
Xoutput209 net209 VGND VGND VPWR VPWR pcpi_rs2[15] sky130_fd_sc_hd__clkbuf_4
XFILLER_0_11_718 VGND VGND VPWR VPWR sky130_fd_sc_hd__fill_2
X_12277_ _05811_ _05890_ _05891_ _05892_ _05894_ VGND VGND VPWR VPWR _05895_ sky130_fd_sc_hd__a32o_1
X_15065_ _01913_ VGND VGND VPWR VPWR _01391_ sky130_fd_sc_hd__clkbuf_1
X_11228_ _03615_ VGND VGND VPWR VPWR _05215_ sky130_fd_sc_hd__clkbuf_4
X_14016_ _07424_ VGND VGND VPWR VPWR _00886_ sky130_fd_sc_hd__clkbuf_1
XFILLER_0_4_27 VGND VGND VPWR VPWR sky130_fd_sc_hd__fill_1
X_11159_ _05168_ VGND VGND VPWR VPWR _00295_ sky130_fd_sc_hd__clkbuf_1
X_15967_ clknet_leaf_150_clk _00617_ VGND VGND VPWR VPWR count_instr\[36\] sky130_fd_sc_hd__dfxtp_1
X_15898_ clknet_leaf_127_clk _00548_ VGND VGND VPWR VPWR cpuregs\[17\]\[0\] sky130_fd_sc_hd__dfxtp_1
X_14918_ _01835_ VGND VGND VPWR VPWR _01322_ sky130_fd_sc_hd__clkbuf_1
X_14849_ _03478_ net1521 _01793_ VGND VGND VPWR VPWR _01799_ sky130_fd_sc_hd__mux2_1
X_08370_ net97 VGND VGND VPWR VPWR _02751_ sky130_fd_sc_hd__clkbuf_8
XFILLER_0_18_317 VPWR VGND VPWR VGND sky130_ef_sc_hd__decap_12
XFILLER_0_45_125 VGND VGND VPWR VPWR sky130_fd_sc_hd__fill_2
XFILLER_0_14_83 VGND VGND VPWR VPWR sky130_fd_sc_hd__fill_1
X_16519_ clknet_leaf_6_clk _01096_ VGND VGND VPWR VPWR mem_rdata_q\[3\] sky130_fd_sc_hd__dfxtp_1
XFILLER_0_128_374 VGND VGND VPWR VPWR sky130_fd_sc_hd__fill_1
XFILLER_0_131_517 VGND VGND VPWR VPWR sky130_fd_sc_hd__decap_8
XFILLER_0_6_789 VPWR VGND VPWR VGND sky130_ef_sc_hd__decap_12
XFILLER_0_14_589 VGND VGND VPWR VPWR sky130_fd_sc_hd__decap_3
XFILLER_0_41_353 VGND VGND VPWR VPWR sky130_fd_sc_hd__fill_1
XFILLER_0_111_252 VGND VGND VPWR VPWR sky130_fd_sc_hd__decap_4
XFILLER_0_69_3 VGND VGND VPWR VPWR sky130_fd_sc_hd__fill_1
XFILLER_0_1_494 VGND VGND VPWR VPWR sky130_fd_sc_hd__fill_1
X_09824_ cpuregs\[20\]\[7\] cpuregs\[21\]\[7\] _03664_ VGND VGND VPWR VPWR _04053_
+ sky130_fd_sc_hd__mux2_1
XTAP_283 VGND VPWR sky130_fd_sc_hd__tapvpwrvgnd_1
XTAP_294 VGND VPWR sky130_fd_sc_hd__tapvpwrvgnd_1
X_09755_ cpuregs\[16\]\[5\] cpuregs\[17\]\[5\] _03819_ VGND VGND VPWR VPWR _03986_
+ sky130_fd_sc_hd__mux2_1
XTAP_2117 VGND VPWR sky130_fd_sc_hd__tapvpwrvgnd_1
X_08706_ _03064_ _03065_ _03066_ net215 VGND VGND VPWR VPWR _03067_ sky130_fd_sc_hd__o22ai_4
XTAP_2106 VGND VPWR sky130_fd_sc_hd__tapvpwrvgnd_1
X_09686_ _02081_ _03914_ _03915_ _03917_ _02241_ VGND VGND VPWR VPWR _03918_ sky130_fd_sc_hd__a32o_1
XTAP_2139 VGND VPWR sky130_fd_sc_hd__tapvpwrvgnd_1
XTAP_2128 VGND VPWR sky130_fd_sc_hd__tapvpwrvgnd_1
X_08637_ _03002_ _03003_ VGND VGND VPWR VPWR _03004_ sky130_fd_sc_hd__nor2_1
XTAP_1405 VGND VPWR sky130_fd_sc_hd__tapvpwrvgnd_1
XTAP_1438 VGND VPWR sky130_fd_sc_hd__tapvpwrvgnd_1
XTAP_1427 VGND VPWR sky130_fd_sc_hd__tapvpwrvgnd_1
XTAP_1416 VGND VPWR sky130_fd_sc_hd__tapvpwrvgnd_1
XFILLER_0_92_710 VGND VGND VPWR VPWR sky130_fd_sc_hd__fill_1
X_08568_ _02933_ _02940_ VGND VGND VPWR VPWR _02941_ sky130_fd_sc_hd__xnor2_1
XTAP_1449 VGND VPWR sky130_fd_sc_hd__tapvpwrvgnd_1
XFILLER_0_135_801 VPWR VGND VPWR VGND sky130_ef_sc_hd__decap_12
X_08499_ _02875_ _02876_ VGND VGND VPWR VPWR _02877_ sky130_fd_sc_hd__nand2_1
XFILLER_0_9_561 VGND VGND VPWR VPWR sky130_fd_sc_hd__decap_6
X_10530_ _03744_ _04735_ _04739_ _03885_ VGND VGND VPWR VPWR _04740_ sky130_fd_sc_hd__o211a_1
XFILLER_0_92_776 VGND VGND VPWR VPWR sky130_fd_sc_hd__fill_1
XFILLER_0_92_765 VGND VGND VPWR VPWR sky130_fd_sc_hd__fill_2
X_10461_ _04512_ _04542_ _04541_ VGND VGND VPWR VPWR _04673_ sky130_fd_sc_hd__o21a_1
XFILLER_0_92_798 VGND VGND VPWR VPWR sky130_fd_sc_hd__fill_1
XFILLER_0_17_372 VGND VGND VPWR VPWR sky130_fd_sc_hd__fill_1
X_12200_ _05819_ _05820_ _05821_ _05823_ VGND VGND VPWR VPWR _05824_ sky130_fd_sc_hd__a31o_1
X_10392_ _04602_ _04603_ _04604_ _04605_ _03676_ _04103_ VGND VGND VPWR VPWR _04606_
+ sky130_fd_sc_hd__mux4_1
X_13180_ _03317_ VGND VGND VPWR VPWR _06667_ sky130_fd_sc_hd__buf_4
X_12131_ _03643_ reg_next_pc\[31\] _03224_ VGND VGND VPWR VPWR _05761_ sky130_fd_sc_hd__mux2_1
X_12062_ _05690_ reg_pc\[10\] VGND VGND VPWR VPWR _05713_ sky130_fd_sc_hd__or2_1
Xhold490 cpuregs\[17\]\[9\] VGND VGND VPWR VPWR net848 sky130_fd_sc_hd__dlygate4sd3_1
X_11013_ _05089_ VGND VGND VPWR VPWR _00228_ sky130_fd_sc_hd__clkbuf_1
X_16870_ clknet_leaf_62_clk _01434_ VGND VGND VPWR VPWR cpuregs\[22\]\[21\] sky130_fd_sc_hd__dfxtp_1
X_15821_ clknet_leaf_56_clk _00471_ VGND VGND VPWR VPWR cpuregs\[16\]\[19\] sky130_fd_sc_hd__dfxtp_1
XFILLER_0_99_364 VGND VGND VPWR VPWR sky130_fd_sc_hd__decap_8
X_15752_ clknet_leaf_104_clk _00402_ VGND VGND VPWR VPWR cpuregs\[15\]\[14\] sky130_fd_sc_hd__dfxtp_1
X_12964_ cpuregs\[24\]\[5\] cpuregs\[25\]\[5\] cpuregs\[26\]\[5\] cpuregs\[27\]\[5\]
+ _06456_ _06457_ VGND VGND VPWR VPWR _06458_ sky130_fd_sc_hd__mux4_1
X_14703_ _01721_ VGND VGND VPWR VPWR _01221_ sky130_fd_sc_hd__clkbuf_1
X_11915_ count_instr\[31\] _05602_ count_instr\[32\] VGND VGND VPWR VPWR _05607_ sky130_fd_sc_hd__a21o_1
Xhold1190 cpuregs\[29\]\[5\] VGND VGND VPWR VPWR net1548 sky130_fd_sc_hd__dlygate4sd3_1
X_12895_ cpuregs\[30\]\[1\] cpuregs\[31\]\[1\] _03336_ VGND VGND VPWR VPWR _06393_
+ sky130_fd_sc_hd__mux2_1
X_15683_ clknet_leaf_138_clk _00333_ VGND VGND VPWR VPWR cpuregs\[27\]\[9\] sky130_fd_sc_hd__dfxtp_1
XTAP_1961 VGND VPWR sky130_fd_sc_hd__tapvpwrvgnd_1
XTAP_1950 VGND VPWR sky130_fd_sc_hd__tapvpwrvgnd_1
XFILLER_0_83_710 VGND VGND VPWR VPWR sky130_fd_sc_hd__fill_1
X_11846_ count_instr\[11\] count_instr\[10\] _05547_ _05556_ VGND VGND VPWR VPWR _05557_
+ sky130_fd_sc_hd__and4_1
X_14634_ net1517 _05159_ _01684_ VGND VGND VPWR VPWR _01685_ sky130_fd_sc_hd__mux2_1
XTAP_1994 VGND VPWR sky130_fd_sc_hd__tapvpwrvgnd_1
XTAP_1983 VGND VPWR sky130_fd_sc_hd__tapvpwrvgnd_1
XTAP_1972 VGND VPWR sky130_fd_sc_hd__tapvpwrvgnd_1
X_11777_ _05035_ net809 _05505_ VGND VGND VPWR VPWR _05510_ sky130_fd_sc_hd__mux2_1
XFILLER_0_95_581 VGND VGND VPWR VPWR sky130_fd_sc_hd__fill_2
XFILLER_0_51_48 VGND VGND VPWR VPWR sky130_fd_sc_hd__decap_8
X_14565_ _01647_ VGND VGND VPWR VPWR _01648_ sky130_fd_sc_hd__clkbuf_8
X_13516_ _06993_ net216 _06960_ VGND VGND VPWR VPWR _06994_ sky130_fd_sc_hd__mux2_1
XFILLER_0_82_253 VGND VGND VPWR VPWR sky130_fd_sc_hd__fill_2
X_16304_ clknet_leaf_9_clk _00889_ VGND VGND VPWR VPWR decoded_imm_j\[8\] sky130_fd_sc_hd__dfxtp_1
X_10728_ net573 _03525_ _04918_ VGND VGND VPWR VPWR _04921_ sky130_fd_sc_hd__mux2_1
XFILLER_0_27_169 VGND VGND VPWR VPWR sky130_fd_sc_hd__decap_8
X_16235_ clknet_leaf_23_clk alu_out\[8\] VGND VGND VPWR VPWR alu_out_q\[8\] sky130_fd_sc_hd__dfxtp_1
X_14496_ _04905_ _05227_ VGND VGND VPWR VPWR _01611_ sky130_fd_sc_hd__nor2_4
X_10659_ _03780_ _04838_ _04865_ _03793_ VGND VGND VPWR VPWR _04866_ sky130_fd_sc_hd__a22o_1
X_13447_ _06751_ _06922_ _06926_ _06798_ VGND VGND VPWR VPWR _06927_ sky130_fd_sc_hd__o211a_1
XFILLER_0_3_726 VGND VGND VPWR VPWR sky130_fd_sc_hd__fill_2
X_16166_ clknet_leaf_43_clk _00784_ VGND VGND VPWR VPWR net39 sky130_fd_sc_hd__dfxtp_2
X_13378_ _06794_ _06859_ VGND VGND VPWR VPWR _06860_ sky130_fd_sc_hd__and2_1
XFILLER_0_51_673 VGND VGND VPWR VPWR sky130_fd_sc_hd__fill_2
XFILLER_0_3_759 VPWR VGND VPWR VGND sky130_ef_sc_hd__decap_12
X_12329_ _05790_ _05727_ _05942_ _05802_ VGND VGND VPWR VPWR _05943_ sky130_fd_sc_hd__a22o_1
X_16097_ clknet_leaf_145_clk _00747_ VGND VGND VPWR VPWR count_cycle\[40\] sky130_fd_sc_hd__dfxtp_1
X_15117_ net1446 _03463_ _01937_ VGND VGND VPWR VPWR _01941_ sky130_fd_sc_hd__mux2_1
XFILLER_0_55_9 VGND VGND VPWR VPWR sky130_fd_sc_hd__decap_3
X_15048_ _01904_ VGND VGND VPWR VPWR _01383_ sky130_fd_sc_hd__clkbuf_1
X_07870_ _02274_ _02277_ _02278_ VGND VGND VPWR VPWR _02279_ sky130_fd_sc_hd__a21oi_1
X_09540_ _03774_ VGND VGND VPWR VPWR _03775_ sky130_fd_sc_hd__clkbuf_4
X_09471_ _03657_ _03689_ _03703_ _03706_ VGND VGND VPWR VPWR _03707_ sky130_fd_sc_hd__a31o_1
X_08422_ _02403_ VGND VGND VPWR VPWR _02803_ sky130_fd_sc_hd__inv_2
XFILLER_0_58_261 VGND VGND VPWR VPWR sky130_fd_sc_hd__fill_2
X_08353_ _02732_ _02733_ VGND VGND VPWR VPWR _02734_ sky130_fd_sc_hd__nand2_1
XFILLER_0_132_50 VPWR VGND VPWR VGND sky130_ef_sc_hd__decap_12
XFILLER_0_74_765 VGND VGND VPWR VPWR sky130_fd_sc_hd__fill_2
XFILLER_0_73_253 VGND VGND VPWR VPWR sky130_fd_sc_hd__decap_6
X_08284_ net199 _02664_ VGND VGND VPWR VPWR _02665_ sky130_fd_sc_hd__or2_1
XFILLER_0_61_426 VGND VGND VPWR VPWR sky130_fd_sc_hd__decap_3
XFILLER_0_27_681 VGND VGND VPWR VPWR sky130_fd_sc_hd__decap_6
XFILLER_0_33_117 VGND VGND VPWR VPWR sky130_fd_sc_hd__decap_6
XFILLER_0_6_564 VGND VGND VPWR VPWR sky130_fd_sc_hd__fill_1
XFILLER_0_30_802 VGND VGND VPWR VPWR sky130_fd_sc_hd__fill_1
XFILLER_0_100_701 VGND VGND VPWR VPWR sky130_fd_sc_hd__fill_2
XFILLER_0_2_781 VPWR VGND VPWR VGND sky130_ef_sc_hd__decap_12
X_07999_ reg_pc\[13\] decoded_imm\[13\] VGND VGND VPWR VPWR _02399_ sky130_fd_sc_hd__nand2_1
X_09807_ _02263_ _02310_ _02378_ _02340_ _03365_ _03652_ VGND VGND VPWR VPWR _04036_
+ sky130_fd_sc_hd__mux4_1
X_09738_ _03900_ _03968_ _03730_ VGND VGND VPWR VPWR _03969_ sky130_fd_sc_hd__a21o_1
XFILLER_0_69_537 VGND VGND VPWR VPWR sky130_fd_sc_hd__decap_4
XFILLER_0_69_526 VGND VGND VPWR VPWR sky130_fd_sc_hd__fill_2
XFILLER_0_69_559 VGND VGND VPWR VPWR sky130_fd_sc_hd__fill_1
XTAP_1213 VGND VPWR sky130_fd_sc_hd__tapvpwrvgnd_1
XTAP_1202 VGND VPWR sky130_fd_sc_hd__tapvpwrvgnd_1
X_09669_ _03797_ VGND VGND VPWR VPWR _03902_ sky130_fd_sc_hd__buf_6
XFILLER_0_139_425 VGND VGND VPWR VPWR sky130_fd_sc_hd__fill_2
X_11700_ _05446_ VGND VGND VPWR VPWR _05469_ sky130_fd_sc_hd__buf_4
XTAP_1257 VGND VPWR sky130_fd_sc_hd__tapvpwrvgnd_1
XTAP_1246 VGND VPWR sky130_fd_sc_hd__tapvpwrvgnd_1
XTAP_1235 VGND VPWR sky130_fd_sc_hd__tapvpwrvgnd_1
XTAP_1224 VGND VPWR sky130_fd_sc_hd__tapvpwrvgnd_1
X_12680_ _05631_ _06225_ VGND VGND VPWR VPWR _06226_ sky130_fd_sc_hd__nor2_1
X_11631_ _05432_ VGND VGND VPWR VPWR _00503_ sky130_fd_sc_hd__clkbuf_1
XTAP_1279 VGND VPWR sky130_fd_sc_hd__tapvpwrvgnd_1
XTAP_1268 VGND VPWR sky130_fd_sc_hd__tapvpwrvgnd_1
X_11562_ _05024_ net1255 _05386_ VGND VGND VPWR VPWR _05396_ sky130_fd_sc_hd__mux2_1
XFILLER_0_64_253 VGND VGND VPWR VPWR sky130_fd_sc_hd__decap_6
X_14350_ decoded_imm\[4\] _07587_ _07607_ _07608_ VGND VGND VPWR VPWR _01025_ sky130_fd_sc_hd__o22a_1
XFILLER_0_25_607 VGND VGND VPWR VPWR sky130_fd_sc_hd__fill_1
X_10513_ _04721_ _04722_ VGND VGND VPWR VPWR _04723_ sky130_fd_sc_hd__nand2_1
X_13301_ cpuregs\[20\]\[15\] cpuregs\[21\]\[15\] _06784_ VGND VGND VPWR VPWR _06785_
+ sky130_fd_sc_hd__mux2_1
XFILLER_0_64_275 VGND VGND VPWR VPWR sky130_fd_sc_hd__fill_2
XFILLER_0_134_141 VGND VGND VPWR VPWR sky130_fd_sc_hd__fill_2
XFILLER_0_107_388 VGND VGND VPWR VPWR sky130_fd_sc_hd__decap_4
X_11493_ net733 _05200_ _05349_ VGND VGND VPWR VPWR _05359_ sky130_fd_sc_hd__mux2_1
X_14281_ is_beq_bne_blt_bge_bltu_bgeu _02189_ VGND VGND VPWR VPWR _07567_ sky130_fd_sc_hd__or2_2
XFILLER_0_24_139 VGND VGND VPWR VPWR sky130_fd_sc_hd__fill_1
X_16020_ clknet_leaf_38_clk _00670_ VGND VGND VPWR VPWR reg_pc\[26\] sky130_fd_sc_hd__dfxtp_2
X_10444_ _04654_ _03751_ _03820_ _04655_ VGND VGND VPWR VPWR _04656_ sky130_fd_sc_hd__a211o_1
X_13232_ _06447_ _06715_ _06717_ _06453_ VGND VGND VPWR VPWR _06718_ sky130_fd_sc_hd__a211o_1
X_10375_ cpuregs\[8\]\[22\] cpuregs\[9\]\[22\] cpuregs\[10\]\[22\] cpuregs\[11\]\[22\]
+ _03876_ _03895_ VGND VGND VPWR VPWR _04589_ sky130_fd_sc_hd__mux4_1
X_13163_ cpuregs\[20\]\[11\] cpuregs\[21\]\[11\] _06448_ VGND VGND VPWR VPWR _06651_
+ sky130_fd_sc_hd__mux2_1
XFILLER_0_0_707 VGND VGND VPWR VPWR sky130_fd_sc_hd__fill_2
X_12114_ _05737_ reg_pc\[25\] VGND VGND VPWR VPWR _05750_ sky130_fd_sc_hd__or2_1
X_13094_ _03307_ _06574_ _06583_ VGND VGND VPWR VPWR _06584_ sky130_fd_sc_hd__or3_2
X_12045_ _05696_ net569 _05697_ _05701_ VGND VGND VPWR VPWR _00648_ sky130_fd_sc_hd__o211a_1
X_16922_ clknet_leaf_110_clk _01486_ VGND VGND VPWR VPWR cpuregs\[0\]\[9\] sky130_fd_sc_hd__dfxtp_1
X_16853_ clknet_leaf_126_clk _01417_ VGND VGND VPWR VPWR cpuregs\[22\]\[4\] sky130_fd_sc_hd__dfxtp_1
X_15804_ clknet_leaf_132_clk _00454_ VGND VGND VPWR VPWR cpuregs\[16\]\[2\] sky130_fd_sc_hd__dfxtp_1
XFILLER_0_87_301 VGND VGND VPWR VPWR sky130_fd_sc_hd__fill_1
X_13996_ _07360_ _07408_ _07409_ _07410_ VGND VGND VPWR VPWR _07411_ sky130_fd_sc_hd__or4_2
X_16784_ clknet_leaf_103_clk _01348_ VGND VGND VPWR VPWR cpuregs\[5\]\[31\] sky130_fd_sc_hd__dfxtp_1
X_15735_ clknet_leaf_63_clk _00385_ VGND VGND VPWR VPWR cpuregs\[21\]\[29\] sky130_fd_sc_hd__dfxtp_1
X_12947_ _06377_ VGND VGND VPWR VPWR _06441_ sky130_fd_sc_hd__clkbuf_4
X_15666_ clknet_leaf_60_clk _00316_ VGND VGND VPWR VPWR cpuregs\[14\]\[24\] sky130_fd_sc_hd__dfxtp_1
XANTENNA_160 net120 VGND VGND VPWR VPWR sky130_fd_sc_hd__diode_2
X_12878_ _06376_ VGND VGND VPWR VPWR _00806_ sky130_fd_sc_hd__clkbuf_1
X_14617_ _01675_ VGND VGND VPWR VPWR _01181_ sky130_fd_sc_hd__clkbuf_1
X_11829_ net449 _05542_ _05533_ VGND VGND VPWR VPWR _05545_ sky130_fd_sc_hd__o21ai_1
XFILLER_0_28_434 VGND VGND VPWR VPWR sky130_fd_sc_hd__fill_2
XFILLER_0_138_480 VGND VGND VPWR VPWR sky130_fd_sc_hd__fill_1
XTAP_1791 VGND VPWR sky130_fd_sc_hd__tapvpwrvgnd_1
XTAP_1780 VGND VPWR sky130_fd_sc_hd__tapvpwrvgnd_1
X_15597_ clknet_leaf_93_clk _00247_ VGND VGND VPWR VPWR cpuregs\[28\]\[19\] sky130_fd_sc_hd__dfxtp_1
XFILLER_0_83_551 VGND VGND VPWR VPWR sky130_fd_sc_hd__fill_2
X_14548_ net639 _05211_ _01634_ VGND VGND VPWR VPWR _01639_ sky130_fd_sc_hd__mux2_1
X_14479_ _01602_ VGND VGND VPWR VPWR _01084_ sky130_fd_sc_hd__clkbuf_1
XFILLER_0_140_111 VGND VGND VPWR VPWR sky130_fd_sc_hd__fill_1
XFILLER_0_140_100 VGND VGND VPWR VPWR sky130_fd_sc_hd__fill_1
XFILLER_0_113_314 VGND VGND VPWR VPWR sky130_fd_sc_hd__fill_2
X_16218_ clknet_leaf_61_clk _00835_ VGND VGND VPWR VPWR net224 sky130_fd_sc_hd__dfxtp_4
XFILLER_0_11_73 VGND VGND VPWR VPWR sky130_fd_sc_hd__fill_1
XFILLER_0_12_813 VGND VGND VPWR VPWR sky130_fd_sc_hd__fill_2
X_16149_ clknet_leaf_40_clk _07637_ VGND VGND VPWR VPWR reg_out\[27\] sky130_fd_sc_hd__dfxtp_1
XFILLER_0_87_22 VGND VGND VPWR VPWR sky130_fd_sc_hd__fill_2
XFILLER_0_11_95 VGND VGND VPWR VPWR sky130_fd_sc_hd__fill_1
XFILLER_0_11_323 VGND VGND VPWR VPWR sky130_fd_sc_hd__decap_6
XFILLER_0_140_177 VGND VGND VPWR VPWR sky130_fd_sc_hd__fill_1
X_08971_ _03272_ VGND VGND VPWR VPWR net78 sky130_fd_sc_hd__clkbuf_4
X_07922_ net30 net130 _02327_ _02219_ VGND VGND VPWR VPWR _02328_ sky130_fd_sc_hd__a22o_1
X_07853_ net196 VGND VGND VPWR VPWR _02263_ sky130_fd_sc_hd__clkbuf_4
XFILLER_0_127_50 VGND VGND VPWR VPWR sky130_fd_sc_hd__decap_6
X_07784_ cpu_state\[3\] cpu_state\[6\] _02159_ VGND VGND VPWR VPWR _02198_ sky130_fd_sc_hd__nor3_1
X_09523_ _03724_ _03757_ _03662_ VGND VGND VPWR VPWR _03758_ sky130_fd_sc_hd__o21a_1
XFILLER_0_94_816 VGND VGND VPWR VPWR sky130_fd_sc_hd__fill_1
XFILLER_0_66_518 VGND VGND VPWR VPWR sky130_fd_sc_hd__fill_1
X_09454_ _03688_ VGND VGND VPWR VPWR _03690_ sky130_fd_sc_hd__clkbuf_4
XFILLER_0_38_209 VGND VGND VPWR VPWR sky130_fd_sc_hd__decap_6
X_09385_ reg_pc\[27\] reg_pc\[26\] _03607_ reg_pc\[28\] VGND VGND VPWR VPWR _03625_
+ sky130_fd_sc_hd__a31o_1
X_08405_ _02783_ _02785_ _02754_ VGND VGND VPWR VPWR _02786_ sky130_fd_sc_hd__o21a_1
X_08336_ net178 _02716_ VGND VGND VPWR VPWR _02717_ sky130_fd_sc_hd__or2_1
XFILLER_0_19_434 VGND VGND VPWR VPWR sky130_fd_sc_hd__decap_4
XFILLER_0_62_724 VGND VGND VPWR VPWR sky130_fd_sc_hd__fill_2
XFILLER_0_116_141 VGND VGND VPWR VPWR sky130_fd_sc_hd__decap_6
X_08267_ _02268_ _02638_ _02649_ VGND VGND VPWR VPWR _07641_ sky130_fd_sc_hd__o21a_1
XFILLER_0_62_757 VGND VGND VPWR VPWR sky130_fd_sc_hd__fill_1
XFILLER_0_62_746 VGND VGND VPWR VPWR sky130_fd_sc_hd__fill_1
XFILLER_0_61_234 VGND VGND VPWR VPWR sky130_fd_sc_hd__decap_4
XFILLER_0_15_640 VGND VGND VPWR VPWR sky130_fd_sc_hd__decap_3
Xclkbuf_leaf_140_clk clknet_4_3_0_clk VGND VGND VPWR VPWR clknet_leaf_140_clk sky130_fd_sc_hd__clkbuf_16
X_08198_ reg_pc\[26\] decoded_imm\[26\] VGND VGND VPWR VPWR _02585_ sky130_fd_sc_hd__or2_1
XFILLER_0_61_267 VGND VGND VPWR VPWR sky130_fd_sc_hd__decap_6
XFILLER_0_132_689 VGND VGND VPWR VPWR sky130_fd_sc_hd__fill_2
XFILLER_0_104_369 VGND VGND VPWR VPWR sky130_fd_sc_hd__fill_1
XFILLER_0_30_632 VGND VGND VPWR VPWR sky130_fd_sc_hd__fill_1
XFILLER_0_100_531 VGND VGND VPWR VPWR sky130_fd_sc_hd__fill_1
X_10160_ cpuregs\[8\]\[16\] cpuregs\[9\]\[16\] cpuregs\[10\]\[16\] cpuregs\[11\]\[16\]
+ _03876_ _03895_ VGND VGND VPWR VPWR _04380_ sky130_fd_sc_hd__mux4_1
XFILLER_0_30_676 VGND VGND VPWR VPWR sky130_fd_sc_hd__fill_1
X_10091_ _03720_ _04310_ _04312_ VGND VGND VPWR VPWR _04313_ sky130_fd_sc_hd__a21o_1
XFILLER_0_16_29 VGND VGND VPWR VPWR sky130_fd_sc_hd__decap_3
X_13850_ mem_rdata_q\[3\] net26 _02089_ VGND VGND VPWR VPWR _07310_ sky130_fd_sc_hd__mux2_1
X_10993_ _05078_ VGND VGND VPWR VPWR _00219_ sky130_fd_sc_hd__clkbuf_1
X_13781_ _06348_ _07247_ _07249_ _06417_ VGND VGND VPWR VPWR _07250_ sky130_fd_sc_hd__a211o_1
X_12801_ _06315_ VGND VGND VPWR VPWR _00790_ sky130_fd_sc_hd__clkbuf_1
X_12732_ _04119_ _06265_ _00014_ VGND VGND VPWR VPWR _06266_ sky130_fd_sc_hd__a21o_1
XTAP_1021 VGND VPWR sky130_fd_sc_hd__tapvpwrvgnd_1
XTAP_1010 VGND VPWR sky130_fd_sc_hd__tapvpwrvgnd_1
X_15520_ clknet_leaf_118_clk _00170_ VGND VGND VPWR VPWR cpuregs\[13\]\[6\] sky130_fd_sc_hd__dfxtp_1
XFILLER_0_96_197 VGND VGND VPWR VPWR sky130_fd_sc_hd__decap_3
XTAP_1054 VGND VPWR sky130_fd_sc_hd__tapvpwrvgnd_1
XTAP_1065 VGND VPWR sky130_fd_sc_hd__tapvpwrvgnd_1
XTAP_1043 VGND VPWR sky130_fd_sc_hd__tapvpwrvgnd_1
XTAP_1032 VGND VPWR sky130_fd_sc_hd__tapvpwrvgnd_1
X_15451_ clknet_leaf_124_clk _00101_ VGND VGND VPWR VPWR cpuregs\[12\]\[1\] sky130_fd_sc_hd__dfxtp_1
X_14402_ _01561_ VGND VGND VPWR VPWR _01048_ sky130_fd_sc_hd__clkbuf_1
XTAP_1098 VGND VPWR sky130_fd_sc_hd__tapvpwrvgnd_1
XTAP_1087 VGND VPWR sky130_fd_sc_hd__tapvpwrvgnd_1
XTAP_1076 VGND VPWR sky130_fd_sc_hd__tapvpwrvgnd_1
X_12663_ count_cycle\[48\] _06210_ VGND VGND VPWR VPWR _06213_ sky130_fd_sc_hd__or2_1
XFILLER_0_108_653 VPWR VGND VPWR VGND sky130_ef_sc_hd__decap_12
X_11614_ _05008_ net982 _05422_ VGND VGND VPWR VPWR _05424_ sky130_fd_sc_hd__mux2_1
X_15382_ clknet_leaf_118_clk _00037_ VGND VGND VPWR VPWR cpuregs\[11\]\[0\] sky130_fd_sc_hd__dfxtp_1
X_12594_ count_cycle\[26\] count_cycle\[27\] count_cycle\[28\] _06156_ VGND VGND VPWR
+ VPWR _06164_ sky130_fd_sc_hd__and4_1
XFILLER_0_92_381 VGND VGND VPWR VPWR sky130_fd_sc_hd__fill_1
X_11545_ _05387_ VGND VGND VPWR VPWR _00462_ sky130_fd_sc_hd__clkbuf_1
XFILLER_0_52_223 VGND VGND VPWR VPWR sky130_fd_sc_hd__decap_6
X_14333_ _02189_ _07460_ mem_rdata_q\[31\] VGND VGND VPWR VPWR _07599_ sky130_fd_sc_hd__o21a_1
XFILLER_0_25_437 VGND VGND VPWR VPWR sky130_fd_sc_hd__fill_2
Xclkbuf_leaf_131_clk clknet_4_8_0_clk VGND VGND VPWR VPWR clknet_leaf_131_clk sky130_fd_sc_hd__clkbuf_16
X_14264_ net170 net133 _06291_ VGND VGND VPWR VPWR _07558_ sky130_fd_sc_hd__mux2_1
X_11476_ _05350_ VGND VGND VPWR VPWR _00430_ sky130_fd_sc_hd__clkbuf_1
X_10427_ _04127_ _04637_ _04639_ VGND VGND VPWR VPWR _04640_ sky130_fd_sc_hd__a21o_1
XFILLER_0_122_144 VGND VGND VPWR VPWR sky130_fd_sc_hd__decap_3
XFILLER_0_80_598 VGND VGND VPWR VPWR sky130_fd_sc_hd__decap_6
X_16003_ clknet_leaf_11_clk _00653_ VGND VGND VPWR VPWR reg_pc\[9\] sky130_fd_sc_hd__dfxtp_2
X_13215_ _06699_ _06700_ _06667_ VGND VGND VPWR VPWR _06701_ sky130_fd_sc_hd__a21o_1
X_14195_ net496 net119 _07519_ VGND VGND VPWR VPWR _07522_ sky130_fd_sc_hd__mux2_1
XFILLER_0_110_328 VGND VGND VPWR VPWR sky130_fd_sc_hd__decap_4
X_10358_ _03817_ _04566_ _04572_ VGND VGND VPWR VPWR _04573_ sky130_fd_sc_hd__or3_1
X_13146_ cpuregs\[10\]\[11\] cpuregs\[11\]\[11\] _06424_ VGND VGND VPWR VPWR _06634_
+ sky130_fd_sc_hd__mux2_1
XTAP_805 VGND VPWR sky130_fd_sc_hd__tapvpwrvgnd_1
XTAP_816 VGND VPWR sky130_fd_sc_hd__tapvpwrvgnd_1
X_10289_ _03657_ _04492_ _04505_ _03776_ reg_pc\[19\] VGND VGND VPWR VPWR _04506_
+ sky130_fd_sc_hd__a32o_1
XFILLER_0_20_197 VGND VGND VPWR VPWR sky130_fd_sc_hd__decap_4
X_13077_ _06567_ _02671_ _06375_ VGND VGND VPWR VPWR _06568_ sky130_fd_sc_hd__mux2_1
XTAP_827 VGND VPWR sky130_fd_sc_hd__tapvpwrvgnd_1
XTAP_838 VGND VPWR sky130_fd_sc_hd__tapvpwrvgnd_1
XTAP_849 VGND VPWR sky130_fd_sc_hd__tapvpwrvgnd_1
X_16905_ clknet_leaf_81_clk _01469_ VGND VGND VPWR VPWR cpuregs\[8\]\[24\] sky130_fd_sc_hd__dfxtp_1
X_12028_ _05687_ VGND VGND VPWR VPWR _05688_ sky130_fd_sc_hd__clkbuf_4
X_16836_ clknet_leaf_90_clk _01400_ VGND VGND VPWR VPWR cpuregs\[7\]\[19\] sky130_fd_sc_hd__dfxtp_1
XFILLER_0_73_35 VGND VGND VPWR VPWR sky130_fd_sc_hd__fill_1
XFILLER_0_73_57 VGND VGND VPWR VPWR sky130_fd_sc_hd__fill_2
X_16767_ clknet_leaf_105_clk _01331_ VGND VGND VPWR VPWR cpuregs\[5\]\[14\] sky130_fd_sc_hd__dfxtp_1
X_13979_ instr_srl _07324_ _07342_ _07384_ VGND VGND VPWR VPWR _07399_ sky130_fd_sc_hd__a22o_1
X_15718_ clknet_leaf_137_clk _00368_ VGND VGND VPWR VPWR cpuregs\[21\]\[12\] sky130_fd_sc_hd__dfxtp_1
X_16698_ clknet_leaf_108_clk _01265_ VGND VGND VPWR VPWR cpuregs\[3\]\[12\] sky130_fd_sc_hd__dfxtp_1
X_15649_ clknet_leaf_112_clk _00299_ VGND VGND VPWR VPWR cpuregs\[14\]\[7\] sky130_fd_sc_hd__dfxtp_1
X_09170_ reg_out\[0\] alu_out_q\[0\] _03437_ VGND VGND VPWR VPWR _03438_ sky130_fd_sc_hd__mux2_1
XFILLER_0_7_136 VGND VGND VPWR VPWR sky130_fd_sc_hd__decap_4
XFILLER_0_28_253 VGND VGND VPWR VPWR sky130_fd_sc_hd__decap_6
X_08121_ _02200_ _02506_ _02510_ _02513_ VGND VGND VPWR VPWR _07630_ sky130_fd_sc_hd__o31a_1
XFILLER_0_7_169 VGND VGND VPWR VPWR sky130_fd_sc_hd__fill_2
Xclkbuf_leaf_122_clk clknet_4_8_0_clk VGND VGND VPWR VPWR clknet_leaf_122_clk sky130_fd_sc_hd__clkbuf_16
XFILLER_0_114_645 VGND VGND VPWR VPWR sky130_fd_sc_hd__fill_1
XFILLER_0_114_623 VGND VGND VPWR VPWR sky130_fd_sc_hd__fill_1
X_08052_ net8 _02448_ _02429_ VGND VGND VPWR VPWR _02449_ sky130_fd_sc_hd__a21oi_1
Xpicorv32_253 VGND VGND VPWR VPWR picorv32_253/HI eoi[0] sky130_fd_sc_hd__conb_1
XFILLER_0_11_120 VGND VGND VPWR VPWR sky130_fd_sc_hd__decap_8
XFILLER_0_12_665 VGND VGND VPWR VPWR sky130_fd_sc_hd__decap_8
Xpicorv32_275 VGND VGND VPWR VPWR picorv32_275/HI eoi[22] sky130_fd_sc_hd__conb_1
Xpicorv32_264 VGND VGND VPWR VPWR picorv32_264/HI eoi[11] sky130_fd_sc_hd__conb_1
Xpicorv32_286 VGND VGND VPWR VPWR picorv32_286/HI mem_addr[1] sky130_fd_sc_hd__conb_1
Xpicorv32_297 VGND VGND VPWR VPWR picorv32_297/HI pcpi_insn[8] sky130_fd_sc_hd__conb_1
X_08954_ _03260_ VGND VGND VPWR VPWR net73 sky130_fd_sc_hd__dlymetal6s2s_1
XFILLER_0_11_186 VGND VGND VPWR VPWR sky130_fd_sc_hd__decap_6
X_07905_ net15 _02216_ _02311_ _02212_ VGND VGND VPWR VPWR _02312_ sky130_fd_sc_hd__a22o_1
X_08885_ net250 net216 _02209_ VGND VGND VPWR VPWR _03218_ sky130_fd_sc_hd__mux2_1
X_07836_ net2 net19 _02213_ VGND VGND VPWR VPWR _02247_ sky130_fd_sc_hd__mux2_1
X_07767_ _02140_ VGND VGND VPWR VPWR _02185_ sky130_fd_sc_hd__buf_4
X_09506_ cpuregs\[18\]\[1\] cpuregs\[19\]\[1\] _03680_ VGND VGND VPWR VPWR _03741_
+ sky130_fd_sc_hd__mux2_1
XFILLER_0_78_197 VGND VGND VPWR VPWR sky130_fd_sc_hd__fill_1
XFILLER_0_78_175 VGND VGND VPWR VPWR sky130_fd_sc_hd__decap_8
XPHY_115 VGND VGND VPWR VPWR sky130_fd_sc_hd__decap_3
XPHY_104 VGND VGND VPWR VPWR sky130_fd_sc_hd__decap_3
X_07698_ instr_bne instr_beq instr_lw instr_srli VGND VGND VPWR VPWR _02124_ sky130_fd_sc_hd__or4_1
XFILLER_0_136_214 VGND VGND VPWR VPWR sky130_fd_sc_hd__fill_1
X_09437_ _00014_ VGND VGND VPWR VPWR _03673_ sky130_fd_sc_hd__inv_2
XPHY_148 VGND VGND VPWR VPWR sky130_fd_sc_hd__decap_3
XPHY_137 VGND VGND VPWR VPWR sky130_fd_sc_hd__decap_3
XPHY_126 VGND VGND VPWR VPWR sky130_fd_sc_hd__decap_3
XFILLER_0_136_225 VGND VGND VPWR VPWR sky130_fd_sc_hd__decap_4
X_09368_ net1211 _03610_ _03578_ VGND VGND VPWR VPWR _03611_ sky130_fd_sc_hd__mux2_1
XFILLER_0_93_167 VGND VGND VPWR VPWR sky130_fd_sc_hd__fill_1
XPHY_159 VGND VGND VPWR VPWR sky130_fd_sc_hd__decap_3
XFILLER_0_47_573 VGND VGND VPWR VPWR sky130_fd_sc_hd__decap_3
X_08319_ net186 net218 VGND VGND VPWR VPWR _02700_ sky130_fd_sc_hd__or2_1
X_09299_ _03546_ _03547_ _03548_ _03550_ VGND VGND VPWR VPWR _03551_ sky130_fd_sc_hd__a22o_2
XFILLER_0_47_595 VGND VGND VPWR VPWR sky130_fd_sc_hd__fill_2
Xclkbuf_leaf_113_clk clknet_4_10_0_clk VGND VGND VPWR VPWR clknet_leaf_113_clk sky130_fd_sc_hd__clkbuf_16
XANTENNA_71 net90 VGND VGND VPWR VPWR sky130_fd_sc_hd__diode_2
XANTENNA_60 net72 VGND VGND VPWR VPWR sky130_fd_sc_hd__diode_2
XANTENNA_82 net115 VGND VGND VPWR VPWR sky130_fd_sc_hd__diode_2
XFILLER_0_7_681 VGND VGND VPWR VPWR sky130_fd_sc_hd__decap_4
XANTENNA_93 net128 VGND VGND VPWR VPWR sky130_fd_sc_hd__diode_2
X_11330_ _04997_ net1589 _05266_ VGND VGND VPWR VPWR _05273_ sky130_fd_sc_hd__mux2_1
XFILLER_0_132_453 VGND VGND VPWR VPWR sky130_fd_sc_hd__fill_1
XFILLER_0_50_727 VGND VGND VPWR VPWR sky130_fd_sc_hd__fill_1
XFILLER_0_132_475 VGND VGND VPWR VPWR sky130_fd_sc_hd__fill_1
XFILLER_0_120_637 VGND VGND VPWR VPWR sky130_fd_sc_hd__decap_6
X_11261_ net1598 _05173_ _05229_ VGND VGND VPWR VPWR _05236_ sky130_fd_sc_hd__mux2_1
X_10212_ _04045_ _04430_ _03674_ VGND VGND VPWR VPWR _04431_ sky130_fd_sc_hd__a21o_1
X_11192_ net762 _05190_ _05182_ VGND VGND VPWR VPWR _05191_ sky130_fd_sc_hd__mux2_1
X_13000_ cpuregs\[24\]\[6\] cpuregs\[25\]\[6\] cpuregs\[26\]\[6\] cpuregs\[27\]\[6\]
+ _06456_ _06457_ VGND VGND VPWR VPWR _06493_ sky130_fd_sc_hd__mux4_1
X_10143_ _04227_ _04260_ _04296_ _04327_ VGND VGND VPWR VPWR _04363_ sky130_fd_sc_hd__or4_1
XFILLER_0_100_394 VGND VGND VPWR VPWR sky130_fd_sc_hd__decap_4
X_14951_ _03584_ net1478 _01851_ VGND VGND VPWR VPWR _01853_ sky130_fd_sc_hd__mux2_1
X_10074_ _04294_ _04295_ VGND VGND VPWR VPWR _04296_ sky130_fd_sc_hd__nand2_1
X_14882_ _01816_ VGND VGND VPWR VPWR _01305_ sky130_fd_sc_hd__clkbuf_1
X_13902_ _07349_ VGND VGND VPWR VPWR _00851_ sky130_fd_sc_hd__clkbuf_1
X_16621_ clknet_leaf_99_clk _01188_ VGND VGND VPWR VPWR cpuregs\[9\]\[31\] sky130_fd_sc_hd__dfxtp_1
X_13833_ _02147_ _05686_ _05832_ _07296_ _07297_ VGND VGND VPWR VPWR _07298_ sky130_fd_sc_hd__o311a_1
XFILLER_0_134_29 VPWR VGND VPWR VGND sky130_ef_sc_hd__decap_12
X_16552_ clknet_leaf_125_clk _01129_ VGND VGND VPWR VPWR cpuregs\[24\]\[4\] sky130_fd_sc_hd__dfxtp_1
X_15503_ clknet_leaf_61_clk _00153_ VGND VGND VPWR VPWR cpuregs\[30\]\[21\] sky130_fd_sc_hd__dfxtp_1
X_13764_ cpuregs\[10\]\[30\] cpuregs\[11\]\[30\] _03347_ VGND VGND VPWR VPWR _07233_
+ sky130_fd_sc_hd__mux2_1
X_10976_ _05069_ VGND VGND VPWR VPWR _00211_ sky130_fd_sc_hd__clkbuf_1
XFILLER_0_69_164 VGND VGND VPWR VPWR sky130_fd_sc_hd__decap_4
XPHY_6 VGND VGND VPWR VPWR sky130_fd_sc_hd__decap_3
X_13695_ _06387_ _07166_ VGND VGND VPWR VPWR _07167_ sky130_fd_sc_hd__and2_1
X_16483_ clknet_leaf_126_clk _01065_ VGND VGND VPWR VPWR cpuregs\[19\]\[4\] sky130_fd_sc_hd__dfxtp_1
X_12715_ _05631_ _06250_ VGND VGND VPWR VPWR _06251_ sky130_fd_sc_hd__nor2_1
X_15434_ clknet_leaf_21_clk _00084_ VGND VGND VPWR VPWR net177 sky130_fd_sc_hd__dfxtp_4
X_12646_ count_cycle\[43\] _06197_ VGND VGND VPWR VPWR _06201_ sky130_fd_sc_hd__or2_1
X_15365_ _03616_ net999 _02063_ VGND VGND VPWR VPWR _02070_ sky130_fd_sc_hd__mux2_1
Xclkbuf_leaf_104_clk clknet_4_11_0_clk VGND VGND VPWR VPWR clknet_leaf_104_clk sky130_fd_sc_hd__clkbuf_16
XFILLER_0_26_746 VGND VGND VPWR VPWR sky130_fd_sc_hd__fill_1
X_14316_ _07589_ VGND VGND VPWR VPWR _07590_ sky130_fd_sc_hd__buf_2
XFILLER_0_53_554 VGND VGND VPWR VPWR sky130_fd_sc_hd__decap_6
X_12577_ count_cycle\[23\] net362 VGND VGND VPWR VPWR _06152_ sky130_fd_sc_hd__and2_1
XFILLER_0_41_705 VGND VGND VPWR VPWR sky130_fd_sc_hd__fill_1
X_15296_ _02033_ VGND VGND VPWR VPWR _01502_ sky130_fd_sc_hd__clkbuf_1
X_11528_ _05378_ VGND VGND VPWR VPWR _00454_ sky130_fd_sc_hd__clkbuf_1
Xhold308 cpuregs\[15\]\[2\] VGND VGND VPWR VPWR net666 sky130_fd_sc_hd__dlygate4sd3_1
X_14247_ net594 net116 _07541_ VGND VGND VPWR VPWR _07549_ sky130_fd_sc_hd__mux2_1
Xhold319 cpuregs\[27\]\[13\] VGND VGND VPWR VPWR net677 sky130_fd_sc_hd__dlygate4sd3_1
XFILLER_0_1_813 VGND VGND VPWR VPWR sky130_fd_sc_hd__fill_1
X_11459_ _05341_ VGND VGND VPWR VPWR _00422_ sky130_fd_sc_hd__clkbuf_1
X_14178_ mem_do_rdata mem_do_rinst mem_state\[1\] mem_state\[0\] VGND VGND VPWR VPWR
+ _07509_ sky130_fd_sc_hd__or4b_1
X_13129_ cpuregs\[22\]\[10\] cpuregs\[23\]\[10\] _06450_ VGND VGND VPWR VPWR _06618_
+ sky130_fd_sc_hd__mux2_1
XTAP_602 VGND VPWR sky130_fd_sc_hd__tapvpwrvgnd_1
XTAP_613 VGND VPWR sky130_fd_sc_hd__tapvpwrvgnd_1
XTAP_624 VGND VPWR sky130_fd_sc_hd__tapvpwrvgnd_1
XTAP_635 VGND VPWR sky130_fd_sc_hd__tapvpwrvgnd_1
XTAP_646 VGND VPWR sky130_fd_sc_hd__tapvpwrvgnd_1
XTAP_657 VGND VPWR sky130_fd_sc_hd__tapvpwrvgnd_1
XTAP_668 VGND VPWR sky130_fd_sc_hd__tapvpwrvgnd_1
Xhold1008 cpuregs\[25\]\[22\] VGND VGND VPWR VPWR net1366 sky130_fd_sc_hd__dlygate4sd3_1
Xhold1019 cpuregs\[31\]\[15\] VGND VGND VPWR VPWR net1377 sky130_fd_sc_hd__dlygate4sd3_1
XFILLER_0_84_45 VGND VGND VPWR VPWR sky130_fd_sc_hd__fill_2
XTAP_679 VGND VPWR sky130_fd_sc_hd__tapvpwrvgnd_1
X_08670_ _02716_ _03022_ _02922_ VGND VGND VPWR VPWR _03034_ sky130_fd_sc_hd__o21a_1
XFILLER_0_84_78 VGND VGND VPWR VPWR sky130_fd_sc_hd__decap_6
X_16819_ clknet_leaf_132_clk _01383_ VGND VGND VPWR VPWR cpuregs\[7\]\[2\] sky130_fd_sc_hd__dfxtp_1
XFILLER_0_88_440 VGND VGND VPWR VPWR sky130_fd_sc_hd__decap_8
XFILLER_0_49_827 VGND VGND VPWR VPWR sky130_fd_sc_hd__fill_1
XFILLER_0_48_315 VGND VGND VPWR VPWR sky130_fd_sc_hd__fill_2
XFILLER_0_75_134 VGND VGND VPWR VPWR sky130_fd_sc_hd__fill_1
XFILLER_0_64_819 VGND VGND VPWR VPWR sky130_fd_sc_hd__decap_3
XFILLER_0_48_337 VGND VGND VPWR VPWR sky130_fd_sc_hd__fill_1
XFILLER_0_75_167 VGND VGND VPWR VPWR sky130_fd_sc_hd__fill_1
X_09222_ _03483_ VGND VGND VPWR VPWR _03484_ sky130_fd_sc_hd__clkbuf_4
XFILLER_0_75_189 VGND VGND VPWR VPWR sky130_fd_sc_hd__fill_2
XFILLER_0_16_201 VGND VGND VPWR VPWR sky130_fd_sc_hd__fill_1
XFILLER_0_17_724 VGND VGND VPWR VPWR sky130_fd_sc_hd__fill_1
X_09153_ decoded_imm_j\[2\] _01115_ _03296_ VGND VGND VPWR VPWR _03426_ sky130_fd_sc_hd__mux2_1
X_08104_ reg_pc\[20\] decoded_imm\[20\] VGND VGND VPWR VPWR _02497_ sky130_fd_sc_hd__nand2_1
X_09084_ _03364_ VGND VGND VPWR VPWR _03365_ sky130_fd_sc_hd__buf_4
XFILLER_0_16_289 VGND VGND VPWR VPWR sky130_fd_sc_hd__fill_2
XFILLER_0_32_738 VGND VGND VPWR VPWR sky130_fd_sc_hd__fill_2
Xhold820 cpuregs\[12\]\[21\] VGND VGND VPWR VPWR net1178 sky130_fd_sc_hd__dlygate4sd3_1
XFILLER_0_114_475 VGND VGND VPWR VPWR sky130_fd_sc_hd__fill_1
X_08035_ _02429_ _02430_ _02432_ _02221_ VGND VGND VPWR VPWR _02433_ sky130_fd_sc_hd__o211a_1
Xhold853 cpuregs\[11\]\[25\] VGND VGND VPWR VPWR net1211 sky130_fd_sc_hd__dlygate4sd3_1
XFILLER_0_101_136 VGND VGND VPWR VPWR sky130_fd_sc_hd__decap_8
Xhold842 cpuregs\[6\]\[20\] VGND VGND VPWR VPWR net1200 sky130_fd_sc_hd__dlygate4sd3_1
Xhold864 cpuregs\[21\]\[31\] VGND VGND VPWR VPWR net1222 sky130_fd_sc_hd__dlygate4sd3_1
Xhold831 cpuregs\[23\]\[5\] VGND VGND VPWR VPWR net1189 sky130_fd_sc_hd__dlygate4sd3_1
Xhold897 cpuregs\[16\]\[19\] VGND VGND VPWR VPWR net1255 sky130_fd_sc_hd__dlygate4sd3_1
Xhold886 cpuregs\[22\]\[6\] VGND VGND VPWR VPWR net1244 sky130_fd_sc_hd__dlygate4sd3_1
Xhold875 cpuregs\[8\]\[9\] VGND VGND VPWR VPWR net1233 sky130_fd_sc_hd__dlygate4sd3_1
X_09986_ _03723_ _04210_ _03675_ VGND VGND VPWR VPWR _04211_ sky130_fd_sc_hd__a21o_1
X_08937_ reg_out\[12\] reg_next_pc\[12\] _03248_ VGND VGND VPWR VPWR _03249_ sky130_fd_sc_hd__mux2_1
XFILLER_0_99_727 VGND VGND VPWR VPWR sky130_fd_sc_hd__fill_1
X_08868_ _02685_ _03204_ _03209_ VGND VGND VPWR VPWR net100 sky130_fd_sc_hd__a21o_1
XFILLER_0_98_237 VGND VGND VPWR VPWR sky130_fd_sc_hd__fill_2
X_07819_ _02224_ _02207_ _02227_ _02222_ _02230_ VGND VGND VPWR VPWR _02231_ sky130_fd_sc_hd__a221o_1
X_08799_ _03148_ _03153_ VGND VGND VPWR VPWR _03154_ sky130_fd_sc_hd__xnor2_1
X_10830_ net895 _03622_ _04968_ VGND VGND VPWR VPWR _04976_ sky130_fd_sc_hd__mux2_1
X_10761_ net1190 _03629_ _04929_ VGND VGND VPWR VPWR _04938_ sky130_fd_sc_hd__mux2_1
XFILLER_0_109_203 VGND VGND VPWR VPWR sky130_fd_sc_hd__decap_6
X_12500_ _05790_ _05762_ _06098_ _05802_ VGND VGND VPWR VPWR _06099_ sky130_fd_sc_hd__a22o_1
XFILLER_0_109_225 VGND VGND VPWR VPWR sky130_fd_sc_hd__decap_8
XFILLER_0_109_214 VGND VGND VPWR VPWR sky130_fd_sc_hd__fill_2
X_10692_ _03717_ _04877_ _04897_ VGND VGND VPWR VPWR _04898_ sky130_fd_sc_hd__o21a_1
X_13480_ _06762_ _06944_ _06958_ _06802_ decoded_imm\[20\] VGND VGND VPWR VPWR _06959_
+ sky130_fd_sc_hd__a32o_1
XFILLER_0_66_178 VGND VGND VPWR VPWR sky130_fd_sc_hd__decap_4
X_12431_ _05989_ _06003_ VGND VGND VPWR VPWR _06036_ sky130_fd_sc_hd__and2_1
XFILLER_0_109_258 VGND VGND VPWR VPWR sky130_fd_sc_hd__fill_1
XFILLER_0_118_781 VGND VGND VPWR VPWR sky130_fd_sc_hd__fill_1
X_12362_ _05961_ _05971_ _05972_ VGND VGND VPWR VPWR _05973_ sky130_fd_sc_hd__and3_1
XFILLER_0_90_682 VGND VGND VPWR VPWR sky130_fd_sc_hd__fill_2
X_15150_ net972 _03570_ _01948_ VGND VGND VPWR VPWR _01958_ sky130_fd_sc_hd__mux2_1
X_12293_ _05718_ _05893_ VGND VGND VPWR VPWR _05910_ sky130_fd_sc_hd__and2_1
X_15081_ _01921_ VGND VGND VPWR VPWR _01399_ sky130_fd_sc_hd__clkbuf_1
X_11313_ net1286 _05225_ _05228_ VGND VGND VPWR VPWR _05263_ sky130_fd_sc_hd__mux2_1
X_14101_ _02141_ _07468_ VGND VGND VPWR VPWR _07469_ sky130_fd_sc_hd__and2_1
X_14032_ _07432_ VGND VGND VPWR VPWR _00890_ sky130_fd_sc_hd__clkbuf_1
X_11244_ net808 _05225_ _05160_ VGND VGND VPWR VPWR _05226_ sky130_fd_sc_hd__mux2_1
XFILLER_0_38_27 VGND VGND VPWR VPWR sky130_fd_sc_hd__fill_1
XFILLER_0_38_38 VPWR VGND VPWR VGND sky130_ef_sc_hd__decap_12
X_11175_ _03503_ VGND VGND VPWR VPWR _05179_ sky130_fd_sc_hd__clkbuf_4
X_10126_ _04119_ _04346_ _03826_ VGND VGND VPWR VPWR _04347_ sky130_fd_sc_hd__a21o_1
X_15983_ clknet_leaf_152_clk _00633_ VGND VGND VPWR VPWR count_instr\[52\] sky130_fd_sc_hd__dfxtp_1
X_10057_ _04119_ _04279_ _03826_ VGND VGND VPWR VPWR _04280_ sky130_fd_sc_hd__a21o_1
X_14934_ _03532_ net1557 _01840_ VGND VGND VPWR VPWR _01844_ sky130_fd_sc_hd__mux2_1
X_16604_ clknet_leaf_106_clk _01171_ VGND VGND VPWR VPWR cpuregs\[9\]\[14\] sky130_fd_sc_hd__dfxtp_1
X_14865_ _01807_ VGND VGND VPWR VPWR _01297_ sky130_fd_sc_hd__clkbuf_1
X_13816_ _06421_ _07281_ _07283_ _06343_ VGND VGND VPWR VPWR _07284_ sky130_fd_sc_hd__a211o_1
XFILLER_0_57_101 VGND VGND VPWR VPWR sky130_fd_sc_hd__decap_3
X_14796_ _01770_ VGND VGND VPWR VPWR _01265_ sky130_fd_sc_hd__clkbuf_1
X_13747_ _06382_ _07216_ VGND VGND VPWR VPWR _07217_ sky130_fd_sc_hd__or2_1
X_16535_ clknet_leaf_25_clk _01112_ VGND VGND VPWR VPWR mem_rdata_q\[19\] sky130_fd_sc_hd__dfxtp_1
XFILLER_0_46_808 VGND VGND VPWR VPWR sky130_fd_sc_hd__fill_1
X_10959_ _05060_ VGND VGND VPWR VPWR _00203_ sky130_fd_sc_hd__clkbuf_1
X_16466_ clknet_leaf_56_clk _01048_ VGND VGND VPWR VPWR cpuregs\[18\]\[19\] sky130_fd_sc_hd__dfxtp_1
XFILLER_0_70_36 VGND VGND VPWR VPWR sky130_fd_sc_hd__decap_3
X_13678_ cpuregs\[4\]\[27\] cpuregs\[5\]\[27\] _06906_ VGND VGND VPWR VPWR _07150_
+ sky130_fd_sc_hd__mux2_1
X_15417_ clknet_leaf_141_clk _00030_ VGND VGND VPWR VPWR _00010_ sky130_fd_sc_hd__dfxtp_2
X_16397_ clknet_leaf_9_clk _00979_ VGND VGND VPWR VPWR net151 sky130_fd_sc_hd__dfxtp_1
X_12629_ net1661 _06186_ VGND VGND VPWR VPWR _06189_ sky130_fd_sc_hd__nand2_1
XFILLER_0_124_751 VGND VGND VPWR VPWR sky130_fd_sc_hd__decap_4
X_15348_ _03564_ net990 _02052_ VGND VGND VPWR VPWR _02061_ sky130_fd_sc_hd__mux2_1
XFILLER_0_79_23 VGND VGND VPWR VPWR sky130_fd_sc_hd__decap_4
XFILLER_0_26_587 VGND VGND VPWR VPWR sky130_fd_sc_hd__fill_1
XFILLER_0_26_598 VGND VGND VPWR VPWR sky130_fd_sc_hd__fill_1
XFILLER_0_130_209 VGND VGND VPWR VPWR sky130_fd_sc_hd__fill_2
Xhold105 reg_next_pc\[16\] VGND VGND VPWR VPWR net463 sky130_fd_sc_hd__dlygate4sd3_1
X_15279_ net456 VGND VGND VPWR VPWR _02025_ sky130_fd_sc_hd__clkbuf_1
Xhold116 count_cycle\[37\] VGND VGND VPWR VPWR net474 sky130_fd_sc_hd__dlygate4sd3_1
Xhold138 net157 VGND VGND VPWR VPWR net496 sky130_fd_sc_hd__dlygate4sd3_1
Xhold127 net158 VGND VGND VPWR VPWR net485 sky130_fd_sc_hd__dlygate4sd3_1
Xhold149 net50 VGND VGND VPWR VPWR net507 sky130_fd_sc_hd__dlygate4sd3_1
XFILLER_0_0_153 VGND VGND VPWR VPWR sky130_fd_sc_hd__decap_4
X_09840_ decoded_imm\[7\] net200 VGND VGND VPWR VPWR _04069_ sky130_fd_sc_hd__nand2_1
XTAP_432 VGND VPWR sky130_fd_sc_hd__tapvpwrvgnd_1
XTAP_421 VGND VPWR sky130_fd_sc_hd__tapvpwrvgnd_1
XTAP_410 VGND VPWR sky130_fd_sc_hd__tapvpwrvgnd_1
XFILLER_0_0_175 VGND VGND VPWR VPWR sky130_fd_sc_hd__decap_3
XFILLER_0_0_197 VGND VGND VPWR VPWR sky130_fd_sc_hd__fill_2
XFILLER_0_1_698 VGND VGND VPWR VPWR sky130_fd_sc_hd__fill_2
XFILLER_0_21_292 VGND VGND VPWR VPWR sky130_fd_sc_hd__decap_6
X_09771_ decoded_imm\[6\] net199 VGND VGND VPWR VPWR _04001_ sky130_fd_sc_hd__nor2_1
XTAP_443 VGND VPWR sky130_fd_sc_hd__tapvpwrvgnd_1
XTAP_454 VGND VPWR sky130_fd_sc_hd__tapvpwrvgnd_1
XTAP_465 VGND VPWR sky130_fd_sc_hd__tapvpwrvgnd_1
XTAP_476 VGND VPWR sky130_fd_sc_hd__tapvpwrvgnd_1
X_08722_ _02509_ _03067_ VGND VGND VPWR VPWR _03082_ sky130_fd_sc_hd__nand2_1
XTAP_487 VGND VPWR sky130_fd_sc_hd__tapvpwrvgnd_1
XTAP_498 VGND VPWR sky130_fd_sc_hd__tapvpwrvgnd_1
X_08653_ _03017_ _03018_ VGND VGND VPWR VPWR _03019_ sky130_fd_sc_hd__xor2_1
XFILLER_0_14_3 VGND VGND VPWR VPWR sky130_fd_sc_hd__fill_2
XTAP_1609 VGND VPWR sky130_fd_sc_hd__tapvpwrvgnd_1
X_08584_ net247 _02954_ VGND VGND VPWR VPWR _02955_ sky130_fd_sc_hd__xnor2_1
XFILLER_0_36_318 VGND VGND VPWR VPWR sky130_fd_sc_hd__decap_4
XFILLER_0_107_729 VGND VGND VPWR VPWR sky130_fd_sc_hd__fill_2
X_09205_ _03467_ _03468_ VGND VGND VPWR VPWR _03469_ sky130_fd_sc_hd__nor2_1
XFILLER_0_8_253 VGND VGND VPWR VPWR sky130_fd_sc_hd__decap_3
XFILLER_0_8_297 VGND VGND VPWR VPWR sky130_fd_sc_hd__decap_6
XFILLER_0_115_751 VGND VGND VPWR VPWR sky130_fd_sc_hd__fill_1
X_09136_ _03324_ _03414_ _00009_ VGND VGND VPWR VPWR _03415_ sky130_fd_sc_hd__a21o_1
XFILLER_0_114_261 VGND VGND VPWR VPWR sky130_fd_sc_hd__decap_3
XFILLER_0_114_250 VGND VGND VPWR VPWR sky130_fd_sc_hd__fill_2
X_09067_ cpuregs\[28\]\[2\] cpuregs\[29\]\[2\] _03347_ VGND VGND VPWR VPWR _03348_
+ sky130_fd_sc_hd__mux2_1
XFILLER_0_114_283 VGND VGND VPWR VPWR sky130_fd_sc_hd__fill_1
X_08018_ count_instr\[46\] instr_rdinstrh count_cycle\[46\] instr_rdcycleh VGND VGND
+ VPWR VPWR _02417_ sky130_fd_sc_hd__a22o_1
Xhold650 cpuregs\[21\]\[30\] VGND VGND VPWR VPWR net1008 sky130_fd_sc_hd__dlygate4sd3_1
Xhold672 cpuregs\[5\]\[30\] VGND VGND VPWR VPWR net1030 sky130_fd_sc_hd__dlygate4sd3_1
Xhold661 cpuregs\[23\]\[18\] VGND VGND VPWR VPWR net1019 sky130_fd_sc_hd__dlygate4sd3_1
XFILLER_0_13_782 VGND VGND VPWR VPWR sky130_fd_sc_hd__fill_2
Xhold683 cpuregs\[7\]\[30\] VGND VGND VPWR VPWR net1041 sky130_fd_sc_hd__dlygate4sd3_1
Xhold694 cpuregs\[12\]\[4\] VGND VGND VPWR VPWR net1052 sky130_fd_sc_hd__dlygate4sd3_1
X_09969_ _03665_ VGND VGND VPWR VPWR _04194_ sky130_fd_sc_hd__clkbuf_8
X_12980_ cpuregs\[12\]\[6\] cpuregs\[13\]\[6\] cpuregs\[14\]\[6\] cpuregs\[15\]\[6\]
+ _06418_ _06419_ VGND VGND VPWR VPWR _06473_ sky130_fd_sc_hd__mux4_1
X_11931_ count_instr\[37\] count_instr\[36\] VGND VGND VPWR VPWR _05618_ sky130_fd_sc_hd__and2_1
X_11862_ _05567_ _05530_ _05568_ VGND VGND VPWR VPWR _05569_ sky130_fd_sc_hd__and3b_1
X_14650_ net1404 _05177_ _01684_ VGND VGND VPWR VPWR _01693_ sky130_fd_sc_hd__mux2_1
XFILLER_0_138_810 VGND VGND VPWR VPWR sky130_fd_sc_hd__fill_2
X_13601_ _06783_ _07073_ _07075_ _06789_ VGND VGND VPWR VPWR _07076_ sky130_fd_sc_hd__a211o_1
X_10813_ net1057 _03571_ _04957_ VGND VGND VPWR VPWR _04967_ sky130_fd_sc_hd__mux2_1
XFILLER_0_79_281 VGND VGND VPWR VPWR sky130_fd_sc_hd__decap_4
X_14581_ _01656_ VGND VGND VPWR VPWR _01164_ sky130_fd_sc_hd__clkbuf_1
X_13532_ _06962_ _07001_ _07008_ VGND VGND VPWR VPWR _07009_ sky130_fd_sc_hd__or3_2
X_16320_ clknet_leaf_28_clk _00905_ VGND VGND VPWR VPWR decoded_imm_j\[18\] sky130_fd_sc_hd__dfxtp_2
X_11793_ _02185_ net414 VGND VGND VPWR VPWR _05518_ sky130_fd_sc_hd__and2_1
XFILLER_0_39_167 VGND VGND VPWR VPWR sky130_fd_sc_hd__fill_1
X_10744_ _04906_ VGND VGND VPWR VPWR _04929_ sky130_fd_sc_hd__buf_4
X_16251_ clknet_leaf_43_clk alu_out\[24\] VGND VGND VPWR VPWR alu_out_q\[24\] sky130_fd_sc_hd__dfxtp_1
X_10675_ _03868_ _04880_ _03870_ VGND VGND VPWR VPWR _04881_ sky130_fd_sc_hd__a21o_1
X_13463_ _06911_ _06941_ VGND VGND VPWR VPWR _06942_ sky130_fd_sc_hd__or2_1
XFILLER_0_125_559 VGND VGND VPWR VPWR sky130_fd_sc_hd__fill_1
X_12414_ _05745_ _06009_ VGND VGND VPWR VPWR _06021_ sky130_fd_sc_hd__or2_1
X_16182_ clknet_leaf_28_clk _00800_ VGND VGND VPWR VPWR net56 sky130_fd_sc_hd__dfxtp_4
X_13394_ cpuregs\[4\]\[18\] cpuregs\[5\]\[18\] _06575_ VGND VGND VPWR VPWR _06875_
+ sky130_fd_sc_hd__mux2_1
X_15202_ _03519_ net1438 _01984_ VGND VGND VPWR VPWR _01986_ sky130_fd_sc_hd__mux2_1
X_12345_ _02153_ _05953_ _05954_ _05957_ VGND VGND VPWR VPWR _05958_ sky130_fd_sc_hd__o31a_1
X_15133_ _01949_ VGND VGND VPWR VPWR _01423_ sky130_fd_sc_hd__clkbuf_1
XFILLER_0_120_253 VGND VGND VPWR VPWR sky130_fd_sc_hd__decap_8
XFILLER_0_120_242 VGND VGND VPWR VPWR sky130_fd_sc_hd__decap_8
XFILLER_0_120_231 VGND VGND VPWR VPWR sky130_fd_sc_hd__decap_3
X_12276_ _05791_ _05893_ VGND VGND VPWR VPWR _05894_ sky130_fd_sc_hd__nor2_1
X_15064_ net752 _05181_ _01912_ VGND VGND VPWR VPWR _01913_ sky130_fd_sc_hd__mux2_1
XFILLER_0_120_286 VGND VGND VPWR VPWR sky130_fd_sc_hd__fill_1
X_11227_ _05214_ VGND VGND VPWR VPWR _00317_ sky130_fd_sc_hd__clkbuf_1
X_14015_ decoded_imm_j\[5\] _01118_ _03430_ VGND VGND VPWR VPWR _07424_ sky130_fd_sc_hd__mux2_1
X_11158_ net1301 _05167_ _05161_ VGND VGND VPWR VPWR _05168_ sky130_fd_sc_hd__mux2_1
X_10109_ _02378_ _02416_ _02493_ _02445_ _03847_ _03916_ VGND VGND VPWR VPWR _04330_
+ sky130_fd_sc_hd__mux4_1
X_11089_ _05129_ VGND VGND VPWR VPWR _00264_ sky130_fd_sc_hd__clkbuf_1
X_15966_ clknet_leaf_150_clk _00616_ VGND VGND VPWR VPWR count_instr\[35\] sky130_fd_sc_hd__dfxtp_1
X_15897_ clknet_leaf_97_clk _00547_ VGND VGND VPWR VPWR cpuregs\[20\]\[31\] sky130_fd_sc_hd__dfxtp_1
X_14917_ _03478_ net1356 _01829_ VGND VGND VPWR VPWR _01835_ sky130_fd_sc_hd__mux2_1
X_14848_ _01798_ VGND VGND VPWR VPWR _01289_ sky130_fd_sc_hd__clkbuf_1
XFILLER_0_86_752 VGND VGND VPWR VPWR sky130_fd_sc_hd__fill_1
XFILLER_0_85_251 VGND VGND VPWR VPWR sky130_fd_sc_hd__fill_1
X_14779_ _01761_ VGND VGND VPWR VPWR _01257_ sky130_fd_sc_hd__clkbuf_1
XFILLER_0_14_40 VGND VGND VPWR VPWR sky130_fd_sc_hd__fill_1
X_16518_ clknet_leaf_6_clk _01095_ VGND VGND VPWR VPWR mem_rdata_q\[2\] sky130_fd_sc_hd__dfxtp_1
XFILLER_0_18_329 VGND VGND VPWR VPWR sky130_fd_sc_hd__decap_4
XFILLER_0_73_457 VGND VGND VPWR VPWR sky130_fd_sc_hd__fill_2
X_16449_ clknet_leaf_133_clk _01031_ VGND VGND VPWR VPWR cpuregs\[18\]\[2\] sky130_fd_sc_hd__dfxtp_1
XFILLER_0_121_30 VGND VGND VPWR VPWR sky130_fd_sc_hd__decap_4
XFILLER_0_6_757 VGND VGND VPWR VPWR sky130_fd_sc_hd__decap_4
XFILLER_0_5_223 VGND VGND VPWR VPWR sky130_fd_sc_hd__fill_1
XFILLER_0_42_811 VGND VGND VPWR VPWR sky130_fd_sc_hd__fill_1
XFILLER_0_53_192 VGND VGND VPWR VPWR sky130_fd_sc_hd__fill_1
XFILLER_0_53_181 VGND VGND VPWR VPWR sky130_fd_sc_hd__decap_4
XFILLER_0_14_579 VGND VGND VPWR VPWR sky130_fd_sc_hd__fill_1
XFILLER_0_112_754 VGND VGND VPWR VPWR sky130_fd_sc_hd__fill_2
XFILLER_0_10_730 VGND VGND VPWR VPWR sky130_fd_sc_hd__decap_3
XFILLER_0_112_798 VGND VGND VPWR VPWR sky130_fd_sc_hd__fill_2
XFILLER_0_10_752 VGND VGND VPWR VPWR sky130_fd_sc_hd__decap_4
X_09823_ cpuregs\[22\]\[7\] cpuregs\[23\]\[7\] _03665_ VGND VGND VPWR VPWR _04052_
+ sky130_fd_sc_hd__mux2_1
XTAP_284 VGND VPWR sky130_fd_sc_hd__tapvpwrvgnd_1
XTAP_295 VGND VPWR sky130_fd_sc_hd__tapvpwrvgnd_1
X_09754_ cpuregs\[20\]\[5\] cpuregs\[21\]\[5\] cpuregs\[22\]\[5\] cpuregs\[23\]\[5\]
+ _03666_ _03984_ VGND VGND VPWR VPWR _03985_ sky130_fd_sc_hd__mux4_1
X_08705_ _02122_ _03064_ VGND VGND VPWR VPWR _03066_ sky130_fd_sc_hd__nor2_1
XTAP_2107 VGND VPWR sky130_fd_sc_hd__tapvpwrvgnd_1
X_09685_ _02132_ _02263_ _02340_ _02294_ _03847_ _03916_ VGND VGND VPWR VPWR _03917_
+ sky130_fd_sc_hd__mux4_1
XTAP_2118 VGND VPWR sky130_fd_sc_hd__tapvpwrvgnd_1
XTAP_2129 VGND VPWR sky130_fd_sc_hd__tapvpwrvgnd_1
X_08636_ net176 _03000_ VGND VGND VPWR VPWR _03003_ sky130_fd_sc_hd__nor2_1
Xclkbuf_leaf_93_clk clknet_4_12_0_clk VGND VGND VPWR VPWR clknet_leaf_93_clk sky130_fd_sc_hd__clkbuf_16
XTAP_1406 VGND VPWR sky130_fd_sc_hd__tapvpwrvgnd_1
XTAP_1439 VGND VPWR sky130_fd_sc_hd__tapvpwrvgnd_1
XTAP_1428 VGND VPWR sky130_fd_sc_hd__tapvpwrvgnd_1
XTAP_1417 VGND VPWR sky130_fd_sc_hd__tapvpwrvgnd_1
XFILLER_0_49_443 VGND VGND VPWR VPWR sky130_fd_sc_hd__fill_2
XFILLER_0_49_421 VGND VGND VPWR VPWR sky130_fd_sc_hd__decap_6
XFILLER_0_49_410 VGND VGND VPWR VPWR sky130_fd_sc_hd__decap_3
X_08567_ _02938_ _02939_ VGND VGND VPWR VPWR _02940_ sky130_fd_sc_hd__nand2_1
XFILLER_0_49_465 VGND VGND VPWR VPWR sky130_fd_sc_hd__fill_2
XFILLER_0_135_813 VPWR VGND VPWR VGND sky130_ef_sc_hd__decap_12
XFILLER_0_91_221 VGND VGND VPWR VPWR sky130_fd_sc_hd__decap_3
XFILLER_0_71_90 VGND VGND VPWR VPWR sky130_fd_sc_hd__fill_1
X_08498_ _02864_ _02865_ _02862_ VGND VGND VPWR VPWR _02876_ sky130_fd_sc_hd__a21o_1
XFILLER_0_119_386 VGND VGND VPWR VPWR sky130_fd_sc_hd__decap_6
X_10460_ _04580_ _04613_ VGND VGND VPWR VPWR _04672_ sky130_fd_sc_hd__or2_1
XFILLER_0_134_378 VGND VGND VPWR VPWR sky130_fd_sc_hd__fill_2
X_09119_ cpuregs\[0\]\[4\] cpuregs\[1\]\[4\] cpuregs\[2\]\[4\] cpuregs\[3\]\[4\] _03313_
+ _03314_ VGND VGND VPWR VPWR _03398_ sky130_fd_sc_hd__mux4_1
XFILLER_0_32_332 VGND VGND VPWR VPWR sky130_fd_sc_hd__fill_1
X_10391_ cpuregs\[16\]\[22\] cpuregs\[17\]\[22\] cpuregs\[18\]\[22\] cpuregs\[19\]\[22\]
+ _03938_ _04028_ VGND VGND VPWR VPWR _04605_ sky130_fd_sc_hd__mux4_1
X_12130_ _05741_ net1640 _05725_ _05760_ VGND VGND VPWR VPWR _00674_ sky130_fd_sc_hd__o211a_1
XFILLER_0_102_242 VGND VGND VPWR VPWR sky130_fd_sc_hd__decap_3
XFILLER_0_60_696 VGND VGND VPWR VPWR sky130_fd_sc_hd__decap_4
Xhold480 cpuregs\[22\]\[28\] VGND VGND VPWR VPWR net838 sky130_fd_sc_hd__dlygate4sd3_1
X_12061_ _03506_ reg_next_pc\[10\] _03222_ VGND VGND VPWR VPWR _05712_ sky130_fd_sc_hd__mux2_2
XFILLER_0_3_3 VPWR VGND VPWR VGND sky130_ef_sc_hd__decap_12
X_11012_ net801 _03440_ _05088_ VGND VGND VPWR VPWR _05089_ sky130_fd_sc_hd__mux2_1
Xhold491 cpuregs\[26\]\[8\] VGND VGND VPWR VPWR net849 sky130_fd_sc_hd__dlygate4sd3_1
X_15820_ clknet_leaf_58_clk _00470_ VGND VGND VPWR VPWR cpuregs\[16\]\[18\] sky130_fd_sc_hd__dfxtp_1
X_15751_ clknet_leaf_103_clk _00401_ VGND VGND VPWR VPWR cpuregs\[15\]\[13\] sky130_fd_sc_hd__dfxtp_1
X_12963_ _03337_ VGND VGND VPWR VPWR _06457_ sky130_fd_sc_hd__clkbuf_8
XFILLER_0_35_28 VGND VGND VPWR VPWR sky130_fd_sc_hd__decap_6
Xhold1180 cpuregs\[27\]\[23\] VGND VGND VPWR VPWR net1538 sky130_fd_sc_hd__dlygate4sd3_1
Xclkbuf_leaf_84_clk clknet_4_14_0_clk VGND VGND VPWR VPWR clknet_leaf_84_clk sky130_fd_sc_hd__clkbuf_16
Xhold1191 cpuregs\[5\]\[0\] VGND VGND VPWR VPWR net1549 sky130_fd_sc_hd__dlygate4sd3_1
X_14702_ _04981_ net1411 _01720_ VGND VGND VPWR VPWR _01721_ sky130_fd_sc_hd__mux2_1
X_11914_ count_instr\[32\] count_instr\[31\] _05602_ VGND VGND VPWR VPWR _05606_ sky130_fd_sc_hd__and3_1
X_15682_ clknet_leaf_143_clk _00332_ VGND VGND VPWR VPWR cpuregs\[27\]\[8\] sky130_fd_sc_hd__dfxtp_1
X_14633_ _01683_ VGND VGND VPWR VPWR _01684_ sky130_fd_sc_hd__buf_4
X_12894_ _03337_ VGND VGND VPWR VPWR _06392_ sky130_fd_sc_hd__clkbuf_8
XTAP_1951 VGND VPWR sky130_fd_sc_hd__tapvpwrvgnd_1
XTAP_1940 VGND VPWR sky130_fd_sc_hd__tapvpwrvgnd_1
X_11845_ count_instr\[13\] count_instr\[12\] VGND VGND VPWR VPWR _05556_ sky130_fd_sc_hd__and2_1
X_11776_ _05509_ VGND VGND VPWR VPWR _00571_ sky130_fd_sc_hd__clkbuf_1
XTAP_1995 VGND VPWR sky130_fd_sc_hd__tapvpwrvgnd_1
XTAP_1984 VGND VPWR sky130_fd_sc_hd__tapvpwrvgnd_1
XTAP_1973 VGND VPWR sky130_fd_sc_hd__tapvpwrvgnd_1
XTAP_1962 VGND VPWR sky130_fd_sc_hd__tapvpwrvgnd_1
XFILLER_0_82_221 VGND VGND VPWR VPWR sky130_fd_sc_hd__fill_2
X_14564_ _03441_ _04983_ VGND VGND VPWR VPWR _01647_ sky130_fd_sc_hd__or2_4
X_13515_ _06762_ _06978_ _06992_ _06802_ decoded_imm\[21\] VGND VGND VPWR VPWR _06993_
+ sky130_fd_sc_hd__a32o_1
XFILLER_0_83_755 VGND VGND VPWR VPWR sky130_fd_sc_hd__fill_2
X_14495_ _01610_ VGND VGND VPWR VPWR _01092_ sky130_fd_sc_hd__clkbuf_1
X_16303_ clknet_leaf_9_clk _00888_ VGND VGND VPWR VPWR decoded_imm_j\[7\] sky130_fd_sc_hd__dfxtp_1
X_10727_ _04920_ VGND VGND VPWR VPWR _00111_ sky130_fd_sc_hd__clkbuf_1
XFILLER_0_125_334 VGND VGND VPWR VPWR sky130_fd_sc_hd__fill_2
XFILLER_0_83_799 VGND VGND VPWR VPWR sky130_fd_sc_hd__fill_2
X_13446_ _06792_ _06923_ _06925_ _06894_ VGND VGND VPWR VPWR _06926_ sky130_fd_sc_hd__a211o_1
X_16234_ clknet_leaf_20_clk alu_out\[7\] VGND VGND VPWR VPWR alu_out_q\[7\] sky130_fd_sc_hd__dfxtp_1
XFILLER_0_42_118 VGND VGND VPWR VPWR sky130_fd_sc_hd__fill_2
XFILLER_0_113_529 VGND VGND VPWR VPWR sky130_fd_sc_hd__fill_1
X_10658_ _03794_ _04851_ _04864_ _03775_ reg_pc\[29\] VGND VGND VPWR VPWR _04865_
+ sky130_fd_sc_hd__a32o_1
XFILLER_0_23_332 VGND VGND VPWR VPWR sky130_fd_sc_hd__fill_1
X_16165_ clknet_leaf_45_clk _00783_ VGND VGND VPWR VPWR net38 sky130_fd_sc_hd__dfxtp_1
X_10589_ decoded_imm\[28\] _02621_ VGND VGND VPWR VPWR _04797_ sky130_fd_sc_hd__nand2_1
XFILLER_0_106_581 VGND VGND VPWR VPWR sky130_fd_sc_hd__decap_6
X_13377_ cpuregs\[30\]\[17\] cpuregs\[31\]\[17\] _06754_ VGND VGND VPWR VPWR _06859_
+ sky130_fd_sc_hd__mux2_1
X_12328_ _05934_ _05935_ _05941_ _05792_ VGND VGND VPWR VPWR _05942_ sky130_fd_sc_hd__a2bb2o_1
XFILLER_0_50_162 VGND VGND VPWR VPWR sky130_fd_sc_hd__decap_4
X_15116_ _01940_ VGND VGND VPWR VPWR _01415_ sky130_fd_sc_hd__clkbuf_1
XFILLER_0_2_259 VGND VGND VPWR VPWR sky130_fd_sc_hd__fill_2
X_16096_ clknet_leaf_148_clk _00746_ VGND VGND VPWR VPWR count_cycle\[39\] sky130_fd_sc_hd__dfxtp_1
X_12259_ decoded_imm_j\[11\] _05714_ VGND VGND VPWR VPWR _05878_ sky130_fd_sc_hd__and2_1
X_15047_ net729 _05165_ _01901_ VGND VGND VPWR VPWR _01904_ sky130_fd_sc_hd__mux2_1
X_15949_ clknet_leaf_152_clk _00599_ VGND VGND VPWR VPWR count_instr\[18\] sky130_fd_sc_hd__dfxtp_1
Xclkbuf_leaf_75_clk clknet_4_15_0_clk VGND VGND VPWR VPWR clknet_leaf_75_clk sky130_fd_sc_hd__clkbuf_16
X_09470_ _02080_ _03704_ _03705_ VGND VGND VPWR VPWR _03706_ sky130_fd_sc_hd__and3_1
X_08421_ _02685_ _02692_ VGND VGND VPWR VPWR _02802_ sky130_fd_sc_hd__nand2_1
X_08352_ net190 net222 VGND VGND VPWR VPWR _02733_ sky130_fd_sc_hd__or2_1
XFILLER_0_132_62 VGND VGND VPWR VPWR sky130_fd_sc_hd__decap_8
X_08283_ net125 VGND VGND VPWR VPWR _02664_ sky130_fd_sc_hd__clkbuf_8
XFILLER_0_131_315 VGND VGND VPWR VPWR sky130_fd_sc_hd__fill_1
XFILLER_0_2_793 VPWR VGND VPWR VGND sky130_ef_sc_hd__decap_12
X_07998_ reg_pc\[13\] decoded_imm\[13\] VGND VGND VPWR VPWR _02398_ sky130_fd_sc_hd__or2_1
X_09806_ _04035_ VGND VGND VPWR VPWR _00075_ sky130_fd_sc_hd__clkbuf_1
X_09737_ cpuregs\[0\]\[5\] cpuregs\[1\]\[5\] _03880_ VGND VGND VPWR VPWR _03968_ sky130_fd_sc_hd__mux2_1
Xclkbuf_leaf_66_clk clknet_4_13_0_clk VGND VGND VPWR VPWR clknet_leaf_66_clk sky130_fd_sc_hd__clkbuf_16
XTAP_1214 VGND VPWR sky130_fd_sc_hd__tapvpwrvgnd_1
XTAP_1203 VGND VPWR sky130_fd_sc_hd__tapvpwrvgnd_1
X_09668_ _03900_ VGND VGND VPWR VPWR _03901_ sky130_fd_sc_hd__clkbuf_8
X_08619_ _02687_ _02986_ _02987_ VGND VGND VPWR VPWR _02988_ sky130_fd_sc_hd__a21o_1
XTAP_1247 VGND VPWR sky130_fd_sc_hd__tapvpwrvgnd_1
XTAP_1236 VGND VPWR sky130_fd_sc_hd__tapvpwrvgnd_1
XTAP_1225 VGND VPWR sky130_fd_sc_hd__tapvpwrvgnd_1
XFILLER_0_49_251 VGND VGND VPWR VPWR sky130_fd_sc_hd__decap_4
X_09599_ cpuregs\[24\]\[2\] cpuregs\[25\]\[2\] cpuregs\[26\]\[2\] cpuregs\[27\]\[2\]
+ _03831_ _03832_ VGND VGND VPWR VPWR _03833_ sky130_fd_sc_hd__mux4_1
X_11630_ _05024_ net1248 _05422_ VGND VGND VPWR VPWR _05432_ sky130_fd_sc_hd__mux2_1
XTAP_1258 VGND VPWR sky130_fd_sc_hd__tapvpwrvgnd_1
XTAP_1269 VGND VPWR sky130_fd_sc_hd__tapvpwrvgnd_1
XFILLER_0_37_413 VGND VGND VPWR VPWR sky130_fd_sc_hd__fill_1
XFILLER_0_119_161 VGND VGND VPWR VPWR sky130_fd_sc_hd__fill_1
XFILLER_0_108_813 VGND VGND VPWR VPWR sky130_fd_sc_hd__fill_1
X_11561_ _05395_ VGND VGND VPWR VPWR _00470_ sky130_fd_sc_hd__clkbuf_1
XFILLER_0_134_131 VGND VGND VPWR VPWR sky130_fd_sc_hd__decap_8
X_10512_ decoded_imm\[26\] net189 VGND VGND VPWR VPWR _04722_ sky130_fd_sc_hd__nand2_1
X_13300_ _06349_ VGND VGND VPWR VPWR _06784_ sky130_fd_sc_hd__buf_4
X_11492_ _05358_ VGND VGND VPWR VPWR _00438_ sky130_fd_sc_hd__clkbuf_1
XFILLER_0_80_769 VGND VGND VPWR VPWR sky130_fd_sc_hd__fill_2
X_14280_ _02179_ _07565_ _07566_ _02508_ VGND VGND VPWR VPWR _00997_ sky130_fd_sc_hd__o22a_1
X_10443_ cpuregs\[4\]\[24\] _03666_ VGND VGND VPWR VPWR _04655_ sky130_fd_sc_hd__nor2_1
X_13231_ _06682_ _06716_ VGND VGND VPWR VPWR _06717_ sky130_fd_sc_hd__and2_1
XFILLER_0_21_803 VGND VGND VPWR VPWR sky130_fd_sc_hd__fill_1
X_10374_ _02082_ _04582_ _04583_ _04587_ VGND VGND VPWR VPWR _04588_ sky130_fd_sc_hd__a31o_1
X_13162_ _06518_ _06649_ VGND VGND VPWR VPWR _06650_ sky130_fd_sc_hd__or2_1
XFILLER_0_21_825 VGND VGND VPWR VPWR sky130_fd_sc_hd__fill_1
X_12113_ _03605_ reg_next_pc\[25\] _03223_ VGND VGND VPWR VPWR _05749_ sky130_fd_sc_hd__mux2_2
X_13093_ _06430_ _06577_ _06579_ _06342_ _06582_ VGND VGND VPWR VPWR _06583_ sky130_fd_sc_hd__o311a_1
X_12044_ _05686_ _05700_ VGND VGND VPWR VPWR _05701_ sky130_fd_sc_hd__or2_1
X_16921_ clknet_leaf_114_clk _01485_ VGND VGND VPWR VPWR cpuregs\[0\]\[8\] sky130_fd_sc_hd__dfxtp_1
XFILLER_0_46_27 VGND VGND VPWR VPWR sky130_fd_sc_hd__fill_1
X_16852_ clknet_leaf_128_clk _01416_ VGND VGND VPWR VPWR cpuregs\[22\]\[3\] sky130_fd_sc_hd__dfxtp_1
X_16783_ clknet_leaf_91_clk _01347_ VGND VGND VPWR VPWR cpuregs\[5\]\[30\] sky130_fd_sc_hd__dfxtp_1
X_15803_ clknet_leaf_143_clk _00453_ VGND VGND VPWR VPWR cpuregs\[16\]\[1\] sky130_fd_sc_hd__dfxtp_1
X_15734_ clknet_leaf_69_clk _00384_ VGND VGND VPWR VPWR cpuregs\[21\]\[28\] sky130_fd_sc_hd__dfxtp_1
Xclkbuf_leaf_57_clk clknet_4_12_0_clk VGND VGND VPWR VPWR clknet_leaf_57_clk sky130_fd_sc_hd__clkbuf_16
X_13995_ mem_rdata_q\[31\] mem_rdata_q\[30\] VGND VGND VPWR VPWR _07410_ sky130_fd_sc_hd__nand2_1
XFILLER_0_1_18 VGND VGND VPWR VPWR sky130_fd_sc_hd__decap_8
XFILLER_0_87_346 VGND VGND VPWR VPWR sky130_fd_sc_hd__decap_8
XFILLER_0_62_37 VGND VGND VPWR VPWR sky130_fd_sc_hd__fill_2
X_12946_ _03307_ _06429_ _06439_ VGND VGND VPWR VPWR _06440_ sky130_fd_sc_hd__or3_2
X_15665_ clknet_leaf_79_clk _00315_ VGND VGND VPWR VPWR cpuregs\[14\]\[23\] sky130_fd_sc_hd__dfxtp_1
XANTENNA_161 net120 VGND VGND VPWR VPWR sky130_fd_sc_hd__diode_2
XANTENNA_150 net181 VGND VGND VPWR VPWR sky130_fd_sc_hd__diode_2
X_12877_ _06373_ _02751_ _06375_ VGND VGND VPWR VPWR _06376_ sky130_fd_sc_hd__mux2_1
X_14616_ _05035_ net1610 _01670_ VGND VGND VPWR VPWR _01675_ sky130_fd_sc_hd__mux2_1
XTAP_1770 VGND VPWR sky130_fd_sc_hd__tapvpwrvgnd_1
X_15596_ clknet_leaf_93_clk _00246_ VGND VGND VPWR VPWR cpuregs\[28\]\[18\] sky130_fd_sc_hd__dfxtp_1
X_11828_ _05544_ VGND VGND VPWR VPWR _00588_ sky130_fd_sc_hd__clkbuf_1
X_14547_ _01638_ VGND VGND VPWR VPWR _01148_ sky130_fd_sc_hd__clkbuf_1
XTAP_1792 VGND VPWR sky130_fd_sc_hd__tapvpwrvgnd_1
XTAP_1781 VGND VPWR sky130_fd_sc_hd__tapvpwrvgnd_1
XFILLER_0_7_307 VGND VGND VPWR VPWR sky130_fd_sc_hd__fill_1
XFILLER_0_126_632 VGND VGND VPWR VPWR sky130_fd_sc_hd__decap_4
X_11759_ _05500_ VGND VGND VPWR VPWR _00563_ sky130_fd_sc_hd__clkbuf_1
XFILLER_0_55_265 VPWR VGND VPWR VGND sky130_ef_sc_hd__decap_12
X_14478_ net792 _05209_ _01598_ VGND VGND VPWR VPWR _01602_ sky130_fd_sc_hd__mux2_1
XFILLER_0_114_805 VGND VGND VPWR VPWR sky130_fd_sc_hd__fill_1
XFILLER_0_55_298 VGND VGND VPWR VPWR sky130_fd_sc_hd__fill_1
XFILLER_0_3_502 VGND VGND VPWR VPWR sky130_fd_sc_hd__fill_2
XFILLER_0_43_449 VGND VGND VPWR VPWR sky130_fd_sc_hd__fill_1
XFILLER_0_126_698 VGND VGND VPWR VPWR sky130_fd_sc_hd__fill_2
X_16217_ clknet_leaf_63_clk _00834_ VGND VGND VPWR VPWR net223 sky130_fd_sc_hd__dfxtp_4
X_13429_ cpuregs\[6\]\[19\] cpuregs\[7\]\[19\] _06842_ VGND VGND VPWR VPWR _06909_
+ sky130_fd_sc_hd__mux2_1
XFILLER_0_11_52 VGND VGND VPWR VPWR sky130_fd_sc_hd__fill_1
X_16148_ clknet_leaf_38_clk _07636_ VGND VGND VPWR VPWR reg_out\[26\] sky130_fd_sc_hd__dfxtp_1
XFILLER_0_87_34 VGND VGND VPWR VPWR sky130_fd_sc_hd__fill_2
XFILLER_0_23_173 VGND VGND VPWR VPWR sky130_fd_sc_hd__fill_1
XFILLER_0_24_696 VGND VGND VPWR VPWR sky130_fd_sc_hd__decap_4
XFILLER_0_140_167 VGND VGND VPWR VPWR sky130_fd_sc_hd__fill_1
X_08970_ _02536_ _03271_ _03268_ VGND VGND VPWR VPWR _03272_ sky130_fd_sc_hd__mux2_1
X_16079_ clknet_leaf_153_clk _00729_ VGND VGND VPWR VPWR count_cycle\[22\] sky130_fd_sc_hd__dfxtp_1
X_07921_ net16 _02216_ _02326_ _02212_ VGND VGND VPWR VPWR _02327_ sky130_fd_sc_hd__a22o_1
X_07852_ net26 net130 _02261_ _02219_ VGND VGND VPWR VPWR _02262_ sky130_fd_sc_hd__a22o_1
Xinput1 mem_rdata[0] VGND VGND VPWR VPWR net1 sky130_fd_sc_hd__clkbuf_2
Xclkbuf_leaf_48_clk clknet_4_7_0_clk VGND VGND VPWR VPWR clknet_leaf_48_clk sky130_fd_sc_hd__clkbuf_16
X_07783_ _02147_ VGND VGND VPWR VPWR _02197_ sky130_fd_sc_hd__clkbuf_4
X_09522_ cpuregs\[14\]\[1\] cpuregs\[15\]\[1\] _03756_ VGND VGND VPWR VPWR _03757_
+ sky130_fd_sc_hd__mux2_1
XFILLER_0_36_71 VGND VGND VPWR VPWR sky130_fd_sc_hd__decap_6
XFILLER_0_36_82 VGND VGND VPWR VPWR sky130_fd_sc_hd__fill_2
XFILLER_0_78_346 VGND VGND VPWR VPWR sky130_fd_sc_hd__fill_2
XFILLER_0_94_806 VGND VGND VPWR VPWR sky130_fd_sc_hd__fill_2
X_09453_ _03660_ _03672_ _03679_ _03686_ _03688_ VGND VGND VPWR VPWR _03689_ sky130_fd_sc_hd__a311o_2
X_09384_ reg_out\[28\] alu_out_q\[28\] _03437_ VGND VGND VPWR VPWR _03624_ sky130_fd_sc_hd__mux2_1
XFILLER_0_59_593 VGND VGND VPWR VPWR sky130_fd_sc_hd__decap_3
X_08404_ _02752_ _02784_ _02758_ VGND VGND VPWR VPWR _02785_ sky130_fd_sc_hd__o21a_1
X_08335_ net210 VGND VGND VPWR VPWR _02716_ sky130_fd_sc_hd__clkbuf_4
XFILLER_0_7_830 VGND VGND VPWR VPWR sky130_fd_sc_hd__fill_2
XFILLER_0_117_665 VGND VGND VPWR VPWR sky130_fd_sc_hd__fill_1
X_08266_ _02643_ _02645_ _02648_ _02268_ VGND VGND VPWR VPWR _02649_ sky130_fd_sc_hd__o211ai_1
XFILLER_0_104_304 VGND VGND VPWR VPWR sky130_fd_sc_hd__fill_1
XFILLER_0_6_362 VGND VGND VPWR VPWR sky130_fd_sc_hd__fill_2
XFILLER_0_104_326 VGND VGND VPWR VPWR sky130_fd_sc_hd__decap_3
XFILLER_0_61_246 VGND VGND VPWR VPWR sky130_fd_sc_hd__decap_8
XFILLER_0_15_663 VGND VGND VPWR VPWR sky130_fd_sc_hd__fill_1
X_08197_ count_cycle\[26\] _02454_ _02582_ _02583_ VGND VGND VPWR VPWR _02584_ sky130_fd_sc_hd__a211o_2
X_10090_ _03979_ _04311_ _03731_ VGND VGND VPWR VPWR _04312_ sky130_fd_sc_hd__a21o_1
Xclkbuf_leaf_39_clk clknet_4_5_0_clk VGND VGND VPWR VPWR clknet_leaf_39_clk sky130_fd_sc_hd__clkbuf_16
X_12800_ net533 net76 _06313_ VGND VGND VPWR VPWR _06315_ sky130_fd_sc_hd__mux2_1
X_10992_ _05033_ net1346 _05074_ VGND VGND VPWR VPWR _05078_ sky130_fd_sc_hd__mux2_1
XFILLER_0_97_644 VGND VGND VPWR VPWR sky130_fd_sc_hd__fill_2
X_13780_ _07013_ _07248_ VGND VGND VPWR VPWR _07249_ sky130_fd_sc_hd__and2_1
XFILLER_0_139_223 VGND VGND VPWR VPWR sky130_fd_sc_hd__fill_1
XFILLER_0_69_346 VGND VGND VPWR VPWR sky130_fd_sc_hd__decap_4
X_12731_ cpuregs\[0\]\[31\] cpuregs\[1\]\[31\] _03767_ VGND VGND VPWR VPWR _06265_
+ sky130_fd_sc_hd__mux2_1
XTAP_1022 VGND VPWR sky130_fd_sc_hd__tapvpwrvgnd_1
XTAP_1011 VGND VPWR sky130_fd_sc_hd__tapvpwrvgnd_1
XTAP_1000 VGND VPWR sky130_fd_sc_hd__tapvpwrvgnd_1
XTAP_1055 VGND VPWR sky130_fd_sc_hd__tapvpwrvgnd_1
XTAP_1044 VGND VPWR sky130_fd_sc_hd__tapvpwrvgnd_1
XTAP_1033 VGND VPWR sky130_fd_sc_hd__tapvpwrvgnd_1
X_15450_ clknet_leaf_118_clk _00100_ VGND VGND VPWR VPWR cpuregs\[12\]\[0\] sky130_fd_sc_hd__dfxtp_1
X_12662_ _06212_ VGND VGND VPWR VPWR _00754_ sky130_fd_sc_hd__clkbuf_1
X_14401_ _05024_ net875 _01551_ VGND VGND VPWR VPWR _01561_ sky130_fd_sc_hd__mux2_1
XTAP_1099 VGND VPWR sky130_fd_sc_hd__tapvpwrvgnd_1
XTAP_1088 VGND VPWR sky130_fd_sc_hd__tapvpwrvgnd_1
XTAP_1077 VGND VPWR sky130_fd_sc_hd__tapvpwrvgnd_1
XTAP_1066 VGND VPWR sky130_fd_sc_hd__tapvpwrvgnd_1
X_11613_ _05423_ VGND VGND VPWR VPWR _00494_ sky130_fd_sc_hd__clkbuf_1
XFILLER_0_108_643 VGND VGND VPWR VPWR sky130_fd_sc_hd__fill_1
XFILLER_0_65_574 VGND VGND VPWR VPWR sky130_fd_sc_hd__fill_2
X_15381_ net1647 _02079_ _06294_ VGND VGND VPWR VPWR _01541_ sky130_fd_sc_hd__a21o_1
X_12593_ _06162_ _06160_ _06163_ VGND VGND VPWR VPWR _00734_ sky130_fd_sc_hd__a21oi_1
XFILLER_0_108_665 VGND VGND VPWR VPWR sky130_fd_sc_hd__decap_3
XFILLER_0_107_131 VGND VGND VPWR VPWR sky130_fd_sc_hd__fill_2
X_14332_ net1657 _07587_ _07590_ _07598_ VGND VGND VPWR VPWR _01017_ sky130_fd_sc_hd__o22a_1
X_11544_ _05005_ net1157 _05386_ VGND VGND VPWR VPWR _05387_ sky130_fd_sc_hd__mux2_1
XFILLER_0_52_235 VGND VGND VPWR VPWR sky130_fd_sc_hd__decap_8
XFILLER_0_52_213 VGND VGND VPWR VPWR sky130_fd_sc_hd__decap_4
X_14263_ net1600 _06294_ _07557_ _06290_ VGND VGND VPWR VPWR _00989_ sky130_fd_sc_hd__o22a_1
X_11475_ net1058 _05181_ _05349_ VGND VGND VPWR VPWR _05350_ sky130_fd_sc_hd__mux2_1
X_10426_ _03837_ _04638_ _03826_ VGND VGND VPWR VPWR _04639_ sky130_fd_sc_hd__a21o_1
X_16002_ clknet_leaf_10_clk _00652_ VGND VGND VPWR VPWR reg_pc\[8\] sky130_fd_sc_hd__dfxtp_2
X_13214_ cpuregs\[10\]\[13\] cpuregs\[11\]\[13\] _06424_ VGND VGND VPWR VPWR _06700_
+ sky130_fd_sc_hd__mux2_1
XFILLER_0_21_611 VGND VGND VPWR VPWR sky130_fd_sc_hd__decap_4
X_14194_ _07521_ VGND VGND VPWR VPWR _00956_ sky130_fd_sc_hd__clkbuf_1
XFILLER_0_122_167 VGND VGND VPWR VPWR sky130_fd_sc_hd__fill_1
X_10357_ _03738_ _04567_ _04571_ _03806_ VGND VGND VPWR VPWR _04572_ sky130_fd_sc_hd__o211a_1
X_13145_ cpuregs\[8\]\[11\] cpuregs\[9\]\[11\] _06422_ VGND VGND VPWR VPWR _06633_
+ sky130_fd_sc_hd__mux2_1
XTAP_806 VGND VPWR sky130_fd_sc_hd__tapvpwrvgnd_1
XTAP_817 VGND VPWR sky130_fd_sc_hd__tapvpwrvgnd_1
X_10288_ _03688_ _04498_ _04504_ VGND VGND VPWR VPWR _04505_ sky130_fd_sc_hd__or3_1
X_13076_ _06416_ _06551_ _06566_ _06470_ decoded_imm\[8\] VGND VGND VPWR VPWR _06567_
+ sky130_fd_sc_hd__a32o_1
XTAP_828 VGND VPWR sky130_fd_sc_hd__tapvpwrvgnd_1
XTAP_839 VGND VPWR sky130_fd_sc_hd__tapvpwrvgnd_1
X_16904_ clknet_leaf_77_clk _01468_ VGND VGND VPWR VPWR cpuregs\[8\]\[23\] sky130_fd_sc_hd__dfxtp_1
X_12027_ _05686_ VGND VGND VPWR VPWR _05687_ sky130_fd_sc_hd__buf_4
X_16835_ clknet_leaf_85_clk _01399_ VGND VGND VPWR VPWR cpuregs\[7\]\[18\] sky130_fd_sc_hd__dfxtp_1
X_16766_ clknet_leaf_102_clk _01330_ VGND VGND VPWR VPWR cpuregs\[5\]\[13\] sky130_fd_sc_hd__dfxtp_1
X_13978_ _07398_ VGND VGND VPWR VPWR _00875_ sky130_fd_sc_hd__clkbuf_1
X_16697_ clknet_leaf_100_clk _01264_ VGND VGND VPWR VPWR cpuregs\[3\]\[11\] sky130_fd_sc_hd__dfxtp_1
X_15717_ clknet_leaf_135_clk _00367_ VGND VGND VPWR VPWR cpuregs\[21\]\[11\] sky130_fd_sc_hd__dfxtp_1
X_12929_ cpuregs\[8\]\[5\] cpuregs\[9\]\[5\] _06422_ VGND VGND VPWR VPWR _06423_ sky130_fd_sc_hd__mux2_1
XFILLER_0_75_327 VGND VGND VPWR VPWR sky130_fd_sc_hd__decap_3
XTAP_2290 VGND VPWR sky130_fd_sc_hd__tapvpwrvgnd_1
XFILLER_0_118_429 VGND VGND VPWR VPWR sky130_fd_sc_hd__decap_4
X_15648_ clknet_leaf_118_clk _00298_ VGND VGND VPWR VPWR cpuregs\[14\]\[6\] sky130_fd_sc_hd__dfxtp_1
XFILLER_0_113_42 VGND VGND VPWR VPWR sky130_fd_sc_hd__decap_8
X_15579_ clknet_leaf_127_clk _00229_ VGND VGND VPWR VPWR cpuregs\[28\]\[1\] sky130_fd_sc_hd__dfxtp_1
XFILLER_0_16_416 VGND VGND VPWR VPWR sky130_fd_sc_hd__fill_1
XFILLER_0_83_393 VPWR VGND VPWR VGND sky130_ef_sc_hd__decap_12
XFILLER_0_4_811 VGND VGND VPWR VPWR sky130_fd_sc_hd__fill_1
X_08120_ count_cycle\[20\] _02232_ _02512_ VGND VGND VPWR VPWR _02513_ sky130_fd_sc_hd__a21o_2
X_08051_ _02447_ VGND VGND VPWR VPWR _02448_ sky130_fd_sc_hd__buf_4
XFILLER_0_52_791 VGND VGND VPWR VPWR sky130_fd_sc_hd__fill_1
Xpicorv32_265 VGND VGND VPWR VPWR picorv32_265/HI eoi[12] sky130_fd_sc_hd__conb_1
Xpicorv32_254 VGND VGND VPWR VPWR picorv32_254/HI eoi[1] sky130_fd_sc_hd__conb_1
XFILLER_0_12_699 VGND VGND VPWR VPWR sky130_fd_sc_hd__fill_1
Xpicorv32_276 VGND VGND VPWR VPWR picorv32_276/HI eoi[23] sky130_fd_sc_hd__conb_1
Xpicorv32_287 VGND VGND VPWR VPWR picorv32_287/HI mem_la_addr[0] sky130_fd_sc_hd__conb_1
X_08953_ _02468_ _03259_ _03246_ VGND VGND VPWR VPWR _03260_ sky130_fd_sc_hd__mux2_1
Xpicorv32_298 VGND VGND VPWR VPWR picorv32_298/HI pcpi_insn[9] sky130_fd_sc_hd__conb_1
X_07904_ net6 net24 _02213_ VGND VGND VPWR VPWR _02311_ sky130_fd_sc_hd__mux2_1
XFILLER_0_138_83 VGND VGND VPWR VPWR sky130_fd_sc_hd__fill_1
X_08884_ _03217_ VGND VGND VPWR VPWR net109 sky130_fd_sc_hd__buf_2
X_07835_ _02242_ _02243_ _02245_ _02147_ VGND VGND VPWR VPWR _02246_ sky130_fd_sc_hd__a22o_1
X_07766_ net1663 _02183_ net1496 VGND VGND VPWR VPWR _02184_ sky130_fd_sc_hd__o21ai_1
X_09505_ _03724_ _03737_ _03739_ VGND VGND VPWR VPWR _03740_ sky130_fd_sc_hd__o21ai_1
XPHY_116 VGND VGND VPWR VPWR sky130_fd_sc_hd__decap_3
XPHY_105 VGND VGND VPWR VPWR sky130_fd_sc_hd__decap_3
X_09436_ _03663_ _03671_ VGND VGND VPWR VPWR _03672_ sky130_fd_sc_hd__or2_1
X_07697_ _02122_ instr_add instr_andi instr_ori VGND VGND VPWR VPWR _02123_ sky130_fd_sc_hd__or4_1
XPHY_149 VGND VGND VPWR VPWR sky130_fd_sc_hd__decap_3
XPHY_138 VGND VGND VPWR VPWR sky130_fd_sc_hd__decap_3
XPHY_127 VGND VGND VPWR VPWR sky130_fd_sc_hd__decap_3
X_09367_ _03609_ VGND VGND VPWR VPWR _03610_ sky130_fd_sc_hd__buf_2
X_08318_ net186 net218 VGND VGND VPWR VPWR _02699_ sky130_fd_sc_hd__nand2_1
X_09298_ _03467_ _03549_ VGND VGND VPWR VPWR _03550_ sky130_fd_sc_hd__nor2_1
XANTENNA_50 net56 VGND VGND VPWR VPWR sky130_fd_sc_hd__diode_2
XFILLER_0_132_421 VGND VGND VPWR VPWR sky130_fd_sc_hd__decap_4
X_08249_ net22 _02466_ _02429_ VGND VGND VPWR VPWR _02633_ sky130_fd_sc_hd__a21oi_1
XANTENNA_61 net72 VGND VGND VPWR VPWR sky130_fd_sc_hd__diode_2
XANTENNA_83 net115 VGND VGND VPWR VPWR sky130_fd_sc_hd__diode_2
XFILLER_0_7_671 VGND VGND VPWR VPWR sky130_fd_sc_hd__fill_1
XANTENNA_72 net91 VGND VGND VPWR VPWR sky130_fd_sc_hd__diode_2
XFILLER_0_105_646 VGND VGND VPWR VPWR sky130_fd_sc_hd__fill_2
XFILLER_0_104_123 VPWR VGND VPWR VGND sky130_ef_sc_hd__decap_12
XANTENNA_94 net128 VGND VGND VPWR VPWR sky130_fd_sc_hd__diode_2
X_11260_ _05235_ VGND VGND VPWR VPWR _00329_ sky130_fd_sc_hd__clkbuf_1
X_10211_ cpuregs\[28\]\[17\] cpuregs\[29\]\[17\] _03749_ VGND VGND VPWR VPWR _04430_
+ sky130_fd_sc_hd__mux2_1
X_11191_ _03537_ VGND VGND VPWR VPWR _05190_ sky130_fd_sc_hd__clkbuf_4
X_10142_ _04080_ _04111_ _04361_ VGND VGND VPWR VPWR _04362_ sky130_fd_sc_hd__or3_1
Xoutput190 net190 VGND VGND VPWR VPWR pcpi_rs1[27] sky130_fd_sc_hd__clkbuf_4
X_14950_ _01852_ VGND VGND VPWR VPWR _01337_ sky130_fd_sc_hd__clkbuf_1
XFILLER_0_100_373 VGND VGND VPWR VPWR sky130_fd_sc_hd__decap_4
XFILLER_0_100_362 VGND VGND VPWR VPWR sky130_fd_sc_hd__fill_2
X_10073_ decoded_imm\[14\] net176 VGND VGND VPWR VPWR _04295_ sky130_fd_sc_hd__nand2_1
X_14881_ _03577_ net1529 _01815_ VGND VGND VPWR VPWR _01816_ sky130_fd_sc_hd__mux2_1
X_13901_ _07332_ _07348_ VGND VGND VPWR VPWR _07349_ sky130_fd_sc_hd__and2_1
X_16620_ clknet_leaf_91_clk _01187_ VGND VGND VPWR VPWR cpuregs\[9\]\[30\] sky130_fd_sc_hd__dfxtp_1
X_13832_ latched_branch _07292_ VGND VGND VPWR VPWR _07297_ sky130_fd_sc_hd__nand2_1
X_13763_ cpuregs\[8\]\[30\] cpuregs\[9\]\[30\] _03343_ VGND VGND VPWR VPWR _07232_
+ sky130_fd_sc_hd__mux2_1
X_16551_ clknet_leaf_130_clk _01128_ VGND VGND VPWR VPWR cpuregs\[24\]\[3\] sky130_fd_sc_hd__dfxtp_1
X_15502_ clknet_leaf_59_clk _00152_ VGND VGND VPWR VPWR cpuregs\[30\]\[20\] sky130_fd_sc_hd__dfxtp_1
X_10975_ _05016_ net915 _05063_ VGND VGND VPWR VPWR _05069_ sky130_fd_sc_hd__mux2_1
XFILLER_0_84_102 VGND VGND VPWR VPWR sky130_fd_sc_hd__decap_8
XFILLER_0_69_187 VGND VGND VPWR VPWR sky130_fd_sc_hd__fill_2
XPHY_7 VGND VGND VPWR VPWR sky130_fd_sc_hd__decap_3
X_12714_ count_cycle\[61\] count_cycle\[62\] _06245_ VGND VGND VPWR VPWR _06250_ sky130_fd_sc_hd__and3_1
X_13694_ cpuregs\[30\]\[27\] cpuregs\[31\]\[27\] _06510_ VGND VGND VPWR VPWR _07166_
+ sky130_fd_sc_hd__mux2_1
X_16482_ clknet_leaf_128_clk _01064_ VGND VGND VPWR VPWR cpuregs\[19\]\[3\] sky130_fd_sc_hd__dfxtp_1
X_15433_ clknet_leaf_21_clk _00083_ VGND VGND VPWR VPWR net176 sky130_fd_sc_hd__dfxtp_4
XFILLER_0_65_360 VGND VGND VPWR VPWR sky130_fd_sc_hd__fill_1
X_12645_ count_cycle\[41\] count_cycle\[42\] count_cycle\[43\] _06193_ VGND VGND VPWR
+ VPWR _06200_ sky130_fd_sc_hd__and4_2
X_15364_ _02069_ VGND VGND VPWR VPWR _01534_ sky130_fd_sc_hd__clkbuf_1
XFILLER_0_65_393 VGND VGND VPWR VPWR sky130_fd_sc_hd__fill_1
X_12576_ _06150_ _06151_ VGND VGND VPWR VPWR _00729_ sky130_fd_sc_hd__nor2_1
Xwire240 _02847_ VGND VGND VPWR VPWR net240 sky130_fd_sc_hd__clkbuf_2
X_14315_ mem_rdata_q\[31\] _07588_ VGND VGND VPWR VPWR _07589_ sky130_fd_sc_hd__and2_1
X_11527_ _04989_ net724 _05375_ VGND VGND VPWR VPWR _05378_ sky130_fd_sc_hd__mux2_1
X_15295_ net483 VGND VGND VPWR VPWR _02033_ sky130_fd_sc_hd__clkbuf_1
XFILLER_0_135_281 VGND VGND VPWR VPWR sky130_fd_sc_hd__fill_2
X_14246_ _07548_ VGND VGND VPWR VPWR _00981_ sky130_fd_sc_hd__clkbuf_1
Xhold309 cpuregs\[28\]\[8\] VGND VGND VPWR VPWR net667 sky130_fd_sc_hd__dlygate4sd3_1
X_11458_ net1061 _05165_ _05338_ VGND VGND VPWR VPWR _05341_ sky130_fd_sc_hd__mux2_1
X_10409_ _04116_ _04617_ _04621_ _04063_ VGND VGND VPWR VPWR _04622_ sky130_fd_sc_hd__o211a_1
X_14177_ mem_do_wdata _02087_ VGND VGND VPWR VPWR _07508_ sky130_fd_sc_hd__or2_1
X_11389_ _05304_ VGND VGND VPWR VPWR _00389_ sky130_fd_sc_hd__clkbuf_1
XFILLER_0_110_148 VGND VGND VPWR VPWR sky130_fd_sc_hd__fill_2
X_13128_ cpuregs\[20\]\[10\] cpuregs\[21\]\[10\] _06448_ VGND VGND VPWR VPWR _06617_
+ sky130_fd_sc_hd__mux2_1
XTAP_603 VGND VPWR sky130_fd_sc_hd__tapvpwrvgnd_1
XTAP_614 VGND VPWR sky130_fd_sc_hd__tapvpwrvgnd_1
XTAP_625 VGND VPWR sky130_fd_sc_hd__tapvpwrvgnd_1
XTAP_636 VGND VPWR sky130_fd_sc_hd__tapvpwrvgnd_1
XTAP_647 VGND VPWR sky130_fd_sc_hd__tapvpwrvgnd_1
XTAP_658 VGND VPWR sky130_fd_sc_hd__tapvpwrvgnd_1
Xhold1009 cpuregs\[1\]\[26\] VGND VGND VPWR VPWR net1367 sky130_fd_sc_hd__dlygate4sd3_1
XTAP_669 VGND VPWR sky130_fd_sc_hd__tapvpwrvgnd_1
X_13059_ _06430_ _06545_ _06547_ _06342_ _06549_ VGND VGND VPWR VPWR _06550_ sky130_fd_sc_hd__o311a_1
X_16818_ clknet_leaf_119_clk _01382_ VGND VGND VPWR VPWR cpuregs\[7\]\[1\] sky130_fd_sc_hd__dfxtp_1
X_16749_ clknet_leaf_68_clk _01313_ VGND VGND VPWR VPWR cpuregs\[4\]\[28\] sky130_fd_sc_hd__dfxtp_1
XFILLER_0_48_327 VGND VGND VPWR VPWR sky130_fd_sc_hd__fill_2
XFILLER_0_124_85 VGND VGND VPWR VPWR sky130_fd_sc_hd__decap_4
XFILLER_0_91_617 VGND VGND VPWR VPWR sky130_fd_sc_hd__decap_3
X_09221_ _03434_ _03480_ _03481_ _03482_ VGND VGND VPWR VPWR _03483_ sky130_fd_sc_hd__a22o_2
X_09152_ _03425_ VGND VGND VPWR VPWR _01115_ sky130_fd_sc_hd__buf_1
X_08103_ reg_pc\[20\] decoded_imm\[20\] VGND VGND VPWR VPWR _02496_ sky130_fd_sc_hd__or2_1
XFILLER_0_16_257 VGND VGND VPWR VPWR sky130_fd_sc_hd__fill_1
XFILLER_0_114_432 VGND VGND VPWR VPWR sky130_fd_sc_hd__decap_4
X_09083_ net245 VGND VGND VPWR VPWR _03364_ sky130_fd_sc_hd__clkbuf_4
XFILLER_0_71_363 VGND VGND VPWR VPWR sky130_fd_sc_hd__decap_4
XFILLER_0_32_717 VGND VGND VPWR VPWR sky130_fd_sc_hd__fill_1
Xhold810 cpuregs\[13\]\[23\] VGND VGND VPWR VPWR net1168 sky130_fd_sc_hd__dlygate4sd3_1
Xhold821 cpuregs\[11\]\[24\] VGND VGND VPWR VPWR net1179 sky130_fd_sc_hd__dlygate4sd3_1
X_08034_ _02428_ _02431_ VGND VGND VPWR VPWR _02432_ sky130_fd_sc_hd__nand2_1
Xhold832 cpuregs\[12\]\[28\] VGND VGND VPWR VPWR net1190 sky130_fd_sc_hd__dlygate4sd3_1
Xhold854 cpuregs\[14\]\[24\] VGND VGND VPWR VPWR net1212 sky130_fd_sc_hd__dlygate4sd3_1
Xhold843 cpuregs\[1\]\[20\] VGND VGND VPWR VPWR net1201 sky130_fd_sc_hd__dlygate4sd3_1
Xhold865 cpuregs\[13\]\[30\] VGND VGND VPWR VPWR net1223 sky130_fd_sc_hd__dlygate4sd3_1
Xhold887 cpuregs\[10\]\[15\] VGND VGND VPWR VPWR net1245 sky130_fd_sc_hd__dlygate4sd3_1
XFILLER_0_12_474 VGND VGND VPWR VPWR sky130_fd_sc_hd__fill_2
Xhold876 cpuregs\[11\]\[0\] VGND VGND VPWR VPWR net1234 sky130_fd_sc_hd__dlygate4sd3_1
Xhold898 cpuregs\[15\]\[7\] VGND VGND VPWR VPWR net1256 sky130_fd_sc_hd__dlygate4sd3_1
X_09985_ cpuregs\[20\]\[11\] cpuregs\[21\]\[11\] _03801_ VGND VGND VPWR VPWR _04210_
+ sky130_fd_sc_hd__mux2_1
X_08936_ _03224_ VGND VGND VPWR VPWR _03248_ sky130_fd_sc_hd__buf_4
XFILLER_0_98_205 VGND VGND VPWR VPWR sky130_fd_sc_hd__fill_1
X_08867_ _02143_ net123 _02685_ _02187_ VGND VGND VPWR VPWR _03209_ sky130_fd_sc_hd__a22o_1
X_07818_ _02147_ _02228_ _02229_ VGND VGND VPWR VPWR _02230_ sky130_fd_sc_hd__and3_1
X_08798_ _03126_ _03149_ _03152_ VGND VGND VPWR VPWR _03153_ sky130_fd_sc_hd__o21ai_1
XFILLER_0_79_441 VGND VGND VPWR VPWR sky130_fd_sc_hd__fill_1
XFILLER_0_67_614 VGND VGND VPWR VPWR sky130_fd_sc_hd__fill_2
XFILLER_0_66_102 VGND VGND VPWR VPWR sky130_fd_sc_hd__fill_2
X_07749_ _02168_ VGND VGND VPWR VPWR _00019_ sky130_fd_sc_hd__clkbuf_1
XFILLER_0_137_502 VGND VGND VPWR VPWR sky130_fd_sc_hd__fill_2
X_10760_ _04937_ VGND VGND VPWR VPWR _00127_ sky130_fd_sc_hd__clkbuf_1
XFILLER_0_66_124 VGND VGND VPWR VPWR sky130_fd_sc_hd__fill_2
X_10691_ reg_pc\[30\] _03992_ _04890_ _04896_ _03702_ VGND VGND VPWR VPWR _04897_
+ sky130_fd_sc_hd__a221o_1
X_09419_ decoded_imm_j\[18\] decoded_imm_j\[17\] decoded_imm_j\[16\] decoded_imm_j\[15\]
+ VGND VGND VPWR VPWR _03655_ sky130_fd_sc_hd__or4_1
X_12430_ _06004_ _05747_ _06013_ _06017_ VGND VGND VPWR VPWR _06035_ sky130_fd_sc_hd__a211o_1
XFILLER_0_63_831 VGND VGND VPWR VPWR sky130_fd_sc_hd__fill_1
XFILLER_0_47_393 VGND VGND VPWR VPWR sky130_fd_sc_hd__fill_2
XFILLER_0_35_533 VGND VGND VPWR VPWR sky130_fd_sc_hd__decap_4
XFILLER_0_117_270 VGND VGND VPWR VPWR sky130_fd_sc_hd__decap_3
X_12361_ _05960_ _05963_ VGND VGND VPWR VPWR _05972_ sky130_fd_sc_hd__nand2_1
XFILLER_0_50_514 VGND VGND VPWR VPWR sky130_fd_sc_hd__fill_2
XFILLER_0_16_780 VGND VGND VPWR VPWR sky130_fd_sc_hd__decap_4
X_14100_ _02149_ _07306_ _07321_ _07462_ VGND VGND VPWR VPWR _07468_ sky130_fd_sc_hd__a22o_1
XFILLER_0_132_251 VGND VGND VPWR VPWR sky130_fd_sc_hd__fill_1
X_11312_ _05262_ VGND VGND VPWR VPWR _00354_ sky130_fd_sc_hd__clkbuf_1
X_12292_ _05906_ _05908_ _05900_ VGND VGND VPWR VPWR _05909_ sky130_fd_sc_hd__a21bo_1
X_15080_ net857 _05198_ _01912_ VGND VGND VPWR VPWR _01921_ sky130_fd_sc_hd__mux2_1
X_14031_ decoded_imm_j\[9\] _01122_ _03430_ VGND VGND VPWR VPWR _07432_ sky130_fd_sc_hd__mux2_1
X_11243_ _03645_ VGND VGND VPWR VPWR _05225_ sky130_fd_sc_hd__clkbuf_4
X_11174_ _05178_ VGND VGND VPWR VPWR _00300_ sky130_fd_sc_hd__clkbuf_1
X_10125_ cpuregs\[20\]\[15\] cpuregs\[21\]\[15\] _03767_ VGND VGND VPWR VPWR _04346_
+ sky130_fd_sc_hd__mux2_1
X_15982_ clknet_leaf_152_clk _00632_ VGND VGND VPWR VPWR count_instr\[51\] sky130_fd_sc_hd__dfxtp_1
XFILLER_0_89_205 VPWR VGND VPWR VGND sky130_ef_sc_hd__decap_12
X_10056_ cpuregs\[20\]\[13\] cpuregs\[21\]\[13\] _03824_ VGND VGND VPWR VPWR _04279_
+ sky130_fd_sc_hd__mux2_1
X_14933_ _01843_ VGND VGND VPWR VPWR _01329_ sky130_fd_sc_hd__clkbuf_1
X_16603_ clknet_leaf_102_clk _01170_ VGND VGND VPWR VPWR cpuregs\[9\]\[13\] sky130_fd_sc_hd__dfxtp_1
X_14864_ _03525_ net918 _01804_ VGND VGND VPWR VPWR _01807_ sky130_fd_sc_hd__mux2_1
X_13815_ _06387_ _07282_ VGND VGND VPWR VPWR _07283_ sky130_fd_sc_hd__and2_1
X_14795_ net748 _05186_ _01767_ VGND VGND VPWR VPWR _01770_ sky130_fd_sc_hd__mux2_1
X_13746_ cpuregs\[16\]\[29\] cpuregs\[17\]\[29\] cpuregs\[18\]\[29\] cpuregs\[19\]\[29\]
+ _06945_ _06979_ VGND VGND VPWR VPWR _07216_ sky130_fd_sc_hd__mux4_1
X_16534_ clknet_leaf_28_clk _01111_ VGND VGND VPWR VPWR mem_rdata_q\[18\] sky130_fd_sc_hd__dfxtp_1
X_10958_ _04999_ net1479 _05052_ VGND VGND VPWR VPWR _05060_ sky130_fd_sc_hd__mux2_1
X_13677_ _06866_ _07144_ _07148_ _06873_ VGND VGND VPWR VPWR _07149_ sky130_fd_sc_hd__o211a_1
X_16465_ clknet_leaf_56_clk _01047_ VGND VGND VPWR VPWR cpuregs\[18\]\[18\] sky130_fd_sc_hd__dfxtp_1
X_10889_ _05015_ VGND VGND VPWR VPWR _00178_ sky130_fd_sc_hd__clkbuf_1
X_12628_ count_cycle\[38\] _06186_ VGND VGND VPWR VPWR _06188_ sky130_fd_sc_hd__or2_1
X_15416_ clknet_leaf_141_clk _00029_ VGND VGND VPWR VPWR _00009_ sky130_fd_sc_hd__dfxtp_2
XFILLER_0_115_207 VGND VGND VPWR VPWR sky130_fd_sc_hd__fill_2
X_16396_ clknet_leaf_8_clk _00978_ VGND VGND VPWR VPWR net150 sky130_fd_sc_hd__dfxtp_1
X_15347_ _02060_ VGND VGND VPWR VPWR _01526_ sky130_fd_sc_hd__clkbuf_1
X_12559_ count_cycle\[17\] count_cycle\[18\] _06135_ VGND VGND VPWR VPWR _06139_ sky130_fd_sc_hd__and3_1
XFILLER_0_80_193 VGND VGND VPWR VPWR sky130_fd_sc_hd__decap_3
X_15278_ _02024_ VGND VGND VPWR VPWR _01493_ sky130_fd_sc_hd__clkbuf_1
Xhold117 mem_rdata_q\[11\] VGND VGND VPWR VPWR net475 sky130_fd_sc_hd__dlygate4sd3_1
Xhold106 reg_sh\[0\] VGND VGND VPWR VPWR net464 sky130_fd_sc_hd__dlygate4sd3_1
XFILLER_0_110_65 VPWR VGND VPWR VGND sky130_ef_sc_hd__decap_12
Xhold139 cpuregs\[0\]\[30\] VGND VGND VPWR VPWR net497 sky130_fd_sc_hd__dlygate4sd3_1
Xhold128 net150 VGND VGND VPWR VPWR net486 sky130_fd_sc_hd__dlygate4sd3_1
X_14229_ _07539_ VGND VGND VPWR VPWR _00973_ sky130_fd_sc_hd__clkbuf_1
XFILLER_0_0_110 VGND VGND VPWR VPWR sky130_fd_sc_hd__fill_2
XTAP_400 VGND VPWR sky130_fd_sc_hd__tapvpwrvgnd_1
XFILLER_0_95_45 VGND VGND VPWR VPWR sky130_fd_sc_hd__decap_4
XTAP_433 VGND VPWR sky130_fd_sc_hd__tapvpwrvgnd_1
XTAP_422 VGND VPWR sky130_fd_sc_hd__tapvpwrvgnd_1
XTAP_411 VGND VPWR sky130_fd_sc_hd__tapvpwrvgnd_1
X_09770_ _03998_ _03999_ _02156_ VGND VGND VPWR VPWR _04000_ sky130_fd_sc_hd__mux2_1
XTAP_444 VGND VPWR sky130_fd_sc_hd__tapvpwrvgnd_1
XTAP_455 VGND VPWR sky130_fd_sc_hd__tapvpwrvgnd_1
XTAP_466 VGND VPWR sky130_fd_sc_hd__tapvpwrvgnd_1
X_08721_ _03074_ VGND VGND VPWR VPWR _03081_ sky130_fd_sc_hd__inv_2
XFILLER_0_119_85 VGND VGND VPWR VPWR sky130_fd_sc_hd__decap_3
XTAP_477 VGND VPWR sky130_fd_sc_hd__tapvpwrvgnd_1
XTAP_499 VGND VPWR sky130_fd_sc_hd__tapvpwrvgnd_1
XTAP_488 VGND VPWR sky130_fd_sc_hd__tapvpwrvgnd_1
X_08652_ _03003_ _03006_ _03001_ VGND VGND VPWR VPWR _03018_ sky130_fd_sc_hd__o21ai_1
X_08583_ net248 _02671_ _02935_ _02850_ VGND VGND VPWR VPWR _02954_ sky130_fd_sc_hd__o31a_1
X_09204_ reg_pc\[4\] reg_pc\[3\] reg_pc\[2\] VGND VGND VPWR VPWR _03468_ sky130_fd_sc_hd__and3_1
XFILLER_0_48_179 VGND VGND VPWR VPWR sky130_fd_sc_hd__decap_4
XFILLER_0_91_447 VGND VGND VPWR VPWR sky130_fd_sc_hd__fill_1
X_09135_ cpuregs\[18\]\[4\] cpuregs\[19\]\[4\] _03312_ VGND VGND VPWR VPWR _03414_
+ sky130_fd_sc_hd__mux2_1
XFILLER_0_32_503 VGND VGND VPWR VPWR sky130_fd_sc_hd__fill_1
X_09066_ _03312_ VGND VGND VPWR VPWR _03347_ sky130_fd_sc_hd__clkbuf_8
X_08017_ net176 VGND VGND VPWR VPWR _02416_ sky130_fd_sc_hd__buf_2
XFILLER_0_8_82 VGND VGND VPWR VPWR sky130_fd_sc_hd__fill_2
Xhold662 cpuregs\[26\]\[21\] VGND VGND VPWR VPWR net1020 sky130_fd_sc_hd__dlygate4sd3_1
Xhold640 cpuregs\[27\]\[14\] VGND VGND VPWR VPWR net998 sky130_fd_sc_hd__dlygate4sd3_1
Xhold651 decoded_imm\[3\] VGND VGND VPWR VPWR net1009 sky130_fd_sc_hd__dlygate4sd3_1
XFILLER_0_12_271 VGND VGND VPWR VPWR sky130_fd_sc_hd__decap_8
Xhold684 cpuregs\[25\]\[29\] VGND VGND VPWR VPWR net1042 sky130_fd_sc_hd__dlygate4sd3_1
Xhold695 cpuregs\[5\]\[14\] VGND VGND VPWR VPWR net1053 sky130_fd_sc_hd__dlygate4sd3_1
Xhold673 cpuregs\[7\]\[7\] VGND VGND VPWR VPWR net1031 sky130_fd_sc_hd__dlygate4sd3_1
X_09968_ cpuregs\[8\]\[11\] cpuregs\[9\]\[11\] cpuregs\[10\]\[11\] cpuregs\[11\]\[11\]
+ _04192_ _03719_ VGND VGND VPWR VPWR _04193_ sky130_fd_sc_hd__mux4_1
X_08919_ _03236_ VGND VGND VPWR VPWR net92 sky130_fd_sc_hd__clkbuf_4
X_11930_ net429 _05614_ _05617_ VGND VGND VPWR VPWR _00617_ sky130_fd_sc_hd__a21oi_1
X_09899_ cpuregs\[4\]\[9\] cpuregs\[5\]\[9\] cpuregs\[6\]\[9\] cpuregs\[7\]\[9\] _03864_
+ _03820_ VGND VGND VPWR VPWR _04126_ sky130_fd_sc_hd__mux4_1
XFILLER_0_87_709 VGND VGND VPWR VPWR sky130_fd_sc_hd__fill_2
X_11861_ count_instr\[16\] _05562_ count_instr\[17\] VGND VGND VPWR VPWR _05568_ sky130_fd_sc_hd__a21o_1
X_13600_ _07013_ _07074_ VGND VGND VPWR VPWR _07075_ sky130_fd_sc_hd__and2_1
X_10812_ _04966_ VGND VGND VPWR VPWR _00150_ sky130_fd_sc_hd__clkbuf_1
X_11792_ _05517_ VGND VGND VPWR VPWR _00579_ sky130_fd_sc_hd__clkbuf_1
X_14580_ _04999_ net1216 _01648_ VGND VGND VPWR VPWR _01656_ sky130_fd_sc_hd__mux2_1
XFILLER_0_138_822 VGND VGND VPWR VPWR sky130_fd_sc_hd__fill_2
X_13531_ _06969_ _07003_ _07005_ _06739_ _07007_ VGND VGND VPWR VPWR _07008_ sky130_fd_sc_hd__o311a_1
XFILLER_0_94_230 VGND VGND VPWR VPWR sky130_fd_sc_hd__decap_6
X_10743_ _04928_ VGND VGND VPWR VPWR _00119_ sky130_fd_sc_hd__clkbuf_1
X_16250_ clknet_leaf_40_clk alu_out\[23\] VGND VGND VPWR VPWR alu_out_q\[23\] sky130_fd_sc_hd__dfxtp_1
X_13462_ cpuregs\[0\]\[20\] cpuregs\[1\]\[20\] cpuregs\[2\]\[20\] cpuregs\[3\]\[20\]
+ _06740_ _06708_ VGND VGND VPWR VPWR _06941_ sky130_fd_sc_hd__mux4_1
X_10674_ cpuregs\[12\]\[30\] cpuregs\[13\]\[30\] _03881_ VGND VGND VPWR VPWR _04880_
+ sky130_fd_sc_hd__mux2_1
XFILLER_0_35_330 VGND VGND VPWR VPWR sky130_fd_sc_hd__decap_6
X_15201_ _01985_ VGND VGND VPWR VPWR _01455_ sky130_fd_sc_hd__clkbuf_1
X_16181_ clknet_leaf_39_clk _00799_ VGND VGND VPWR VPWR net54 sky130_fd_sc_hd__dfxtp_1
X_12413_ _05832_ _06019_ VGND VGND VPWR VPWR _06020_ sky130_fd_sc_hd__nor2_1
XFILLER_0_106_741 VGND VGND VPWR VPWR sky130_fd_sc_hd__fill_1
X_13393_ _06866_ _06867_ _06872_ _06873_ VGND VGND VPWR VPWR _06874_ sky130_fd_sc_hd__o211a_1
XFILLER_0_23_503 VGND VGND VPWR VPWR sky130_fd_sc_hd__fill_1
X_12344_ instr_jal _05956_ net383 VGND VGND VPWR VPWR _05957_ sky130_fd_sc_hd__o21a_1
X_15132_ net1218 _03510_ _01948_ VGND VGND VPWR VPWR _01949_ sky130_fd_sc_hd__mux2_1
X_15063_ _01900_ VGND VGND VPWR VPWR _01912_ sky130_fd_sc_hd__buf_4
XFILLER_0_121_766 VGND VGND VPWR VPWR sky130_fd_sc_hd__fill_1
X_12275_ _05714_ _05716_ _05868_ VGND VGND VPWR VPWR _05893_ sky130_fd_sc_hd__and3_1
X_14014_ _07423_ VGND VGND VPWR VPWR _01118_ sky130_fd_sc_hd__clkbuf_1
XFILLER_0_50_399 VGND VGND VPWR VPWR sky130_fd_sc_hd__decap_6
X_11226_ net727 _05213_ _05203_ VGND VGND VPWR VPWR _05214_ sky130_fd_sc_hd__mux2_1
XFILLER_0_4_29 VGND VGND VPWR VPWR sky130_fd_sc_hd__decap_8
X_11157_ _03463_ VGND VGND VPWR VPWR _05167_ sky130_fd_sc_hd__buf_2
X_10108_ _04295_ _04299_ _04327_ VGND VGND VPWR VPWR _04329_ sky130_fd_sc_hd__a21o_1
X_15965_ clknet_leaf_150_clk _00615_ VGND VGND VPWR VPWR count_instr\[34\] sky130_fd_sc_hd__dfxtp_1
X_11088_ net708 _03472_ _05124_ VGND VGND VPWR VPWR _05129_ sky130_fd_sc_hd__mux2_1
X_15896_ clknet_leaf_58_clk _00546_ VGND VGND VPWR VPWR cpuregs\[20\]\[30\] sky130_fd_sc_hd__dfxtp_1
X_10039_ _04226_ _04230_ _04260_ VGND VGND VPWR VPWR _04262_ sky130_fd_sc_hd__a21o_1
X_14916_ _01834_ VGND VGND VPWR VPWR _01321_ sky130_fd_sc_hd__clkbuf_1
X_14847_ _03472_ net1467 _01793_ VGND VGND VPWR VPWR _01798_ sky130_fd_sc_hd__mux2_1
XFILLER_0_58_411 VGND VGND VPWR VPWR sky130_fd_sc_hd__fill_1
XFILLER_0_58_477 VGND VGND VPWR VPWR sky130_fd_sc_hd__fill_2
X_14778_ net787 _05169_ _01756_ VGND VGND VPWR VPWR _01761_ sky130_fd_sc_hd__mux2_1
X_16517_ clknet_leaf_6_clk _01094_ VGND VGND VPWR VPWR mem_rdata_q\[1\] sky130_fd_sc_hd__dfxtp_1
X_13729_ _06415_ _07186_ _07199_ _02181_ decoded_imm\[28\] VGND VGND VPWR VPWR _07200_
+ sky130_fd_sc_hd__a32o_1
XFILLER_0_58_488 VGND VGND VPWR VPWR sky130_fd_sc_hd__decap_4
XFILLER_0_45_105 VGND VGND VPWR VPWR sky130_fd_sc_hd__decap_4
XFILLER_0_14_85 VGND VGND VPWR VPWR sky130_fd_sc_hd__decap_4
XFILLER_0_27_831 VGND VGND VPWR VPWR sky130_fd_sc_hd__fill_1
X_16448_ clknet_leaf_143_clk _01030_ VGND VGND VPWR VPWR cpuregs\[18\]\[1\] sky130_fd_sc_hd__dfxtp_1
X_16379_ clknet_leaf_117_clk _00961_ VGND VGND VPWR VPWR net163 sky130_fd_sc_hd__dfxtp_1
XFILLER_0_83_7 VGND VGND VPWR VPWR sky130_fd_sc_hd__fill_1
XFILLER_0_111_243 VGND VGND VPWR VPWR sky130_fd_sc_hd__decap_6
XFILLER_0_1_430 VGND VGND VPWR VPWR sky130_fd_sc_hd__fill_2
XFILLER_0_1_452 VGND VGND VPWR VPWR sky130_fd_sc_hd__fill_2
XFILLER_0_111_276 VGND VGND VPWR VPWR sky130_fd_sc_hd__decap_4
X_09822_ cpuregs\[16\]\[7\] cpuregs\[17\]\[7\] cpuregs\[18\]\[7\] cpuregs\[19\]\[7\]
+ _03881_ _03718_ VGND VGND VPWR VPWR _04051_ sky130_fd_sc_hd__mux4_1
X_09753_ _03668_ VGND VGND VPWR VPWR _03984_ sky130_fd_sc_hd__clkbuf_8
X_08704_ _02934_ net215 VGND VGND VPWR VPWR _03065_ sky130_fd_sc_hd__nand2_1
XTAP_285 VGND VPWR sky130_fd_sc_hd__tapvpwrvgnd_1
XTAP_296 VGND VPWR sky130_fd_sc_hd__tapvpwrvgnd_1
XTAP_2108 VGND VPWR sky130_fd_sc_hd__tapvpwrvgnd_1
X_09684_ _03651_ VGND VGND VPWR VPWR _03916_ sky130_fd_sc_hd__clkbuf_4
XTAP_2119 VGND VPWR sky130_fd_sc_hd__tapvpwrvgnd_1
X_08635_ _03001_ VGND VGND VPWR VPWR _03002_ sky130_fd_sc_hd__inv_2
X_08566_ _02340_ _02937_ VGND VGND VPWR VPWR _02939_ sky130_fd_sc_hd__or2_1
XTAP_1429 VGND VPWR sky130_fd_sc_hd__tapvpwrvgnd_1
XTAP_1418 VGND VPWR sky130_fd_sc_hd__tapvpwrvgnd_1
XTAP_1407 VGND VPWR sky130_fd_sc_hd__tapvpwrvgnd_1
XFILLER_0_119_332 VGND VGND VPWR VPWR sky130_fd_sc_hd__decap_4
X_08497_ _02873_ _02874_ VGND VGND VPWR VPWR _02875_ sky130_fd_sc_hd__and2b_1
XFILLER_0_135_825 VGND VGND VPWR VPWR sky130_fd_sc_hd__fill_1
XFILLER_0_9_585 VGND VGND VPWR VPWR sky130_fd_sc_hd__fill_1
XFILLER_0_91_277 VGND VGND VPWR VPWR sky130_fd_sc_hd__decap_3
XFILLER_0_51_119 VGND VGND VPWR VPWR sky130_fd_sc_hd__decap_8
XFILLER_0_17_341 VGND VGND VPWR VPWR sky130_fd_sc_hd__fill_1
X_09118_ _03311_ _03396_ VGND VGND VPWR VPWR _03397_ sky130_fd_sc_hd__or2_1
X_10390_ cpuregs\[20\]\[22\] cpuregs\[21\]\[22\] cpuregs\[22\]\[22\] cpuregs\[23\]\[22\]
+ _04100_ _03936_ VGND VGND VPWR VPWR _04604_ sky130_fd_sc_hd__mux4_1
X_09049_ _03324_ VGND VGND VPWR VPWR _03330_ sky130_fd_sc_hd__clkbuf_8
XFILLER_0_20_528 VGND VGND VPWR VPWR sky130_fd_sc_hd__fill_1
Xhold470 cpuregs\[3\]\[25\] VGND VGND VPWR VPWR net828 sky130_fd_sc_hd__dlygate4sd3_1
XFILLER_0_130_574 VGND VGND VPWR VPWR sky130_fd_sc_hd__decap_3
Xhold481 cpuregs\[28\]\[23\] VGND VGND VPWR VPWR net839 sky130_fd_sc_hd__dlygate4sd3_1
X_12060_ _05688_ _05710_ _05711_ _02142_ VGND VGND VPWR VPWR _00653_ sky130_fd_sc_hd__o211a_1
X_11011_ _05087_ VGND VGND VPWR VPWR _05088_ sky130_fd_sc_hd__buf_4
Xhold492 cpuregs\[12\]\[0\] VGND VGND VPWR VPWR net850 sky130_fd_sc_hd__dlygate4sd3_1
Xhold1170 cpuregs\[18\]\[22\] VGND VGND VPWR VPWR net1528 sky130_fd_sc_hd__dlygate4sd3_1
X_15750_ clknet_leaf_105_clk _00400_ VGND VGND VPWR VPWR cpuregs\[15\]\[12\] sky130_fd_sc_hd__dfxtp_1
X_12962_ _03329_ VGND VGND VPWR VPWR _06456_ sky130_fd_sc_hd__buf_6
Xhold1192 cpuregs\[29\]\[28\] VGND VGND VPWR VPWR net1550 sky130_fd_sc_hd__dlygate4sd3_1
Xhold1181 reg_pc\[19\] VGND VGND VPWR VPWR net1539 sky130_fd_sc_hd__dlygate4sd3_1
XFILLER_0_59_208 VGND VGND VPWR VPWR sky130_fd_sc_hd__decap_6
X_14701_ _01719_ VGND VGND VPWR VPWR _01720_ sky130_fd_sc_hd__buf_4
X_12893_ cpuregs\[24\]\[1\] cpuregs\[25\]\[1\] cpuregs\[26\]\[1\] cpuregs\[27\]\[1\]
+ _03329_ _03330_ VGND VGND VPWR VPWR _06391_ sky130_fd_sc_hd__mux4_1
X_11913_ net743 _05602_ _05605_ VGND VGND VPWR VPWR _00612_ sky130_fd_sc_hd__o21a_1
X_15681_ clknet_leaf_142_clk _00331_ VGND VGND VPWR VPWR cpuregs\[27\]\[7\] sky130_fd_sc_hd__dfxtp_1
XFILLER_0_87_539 VGND VGND VPWR VPWR sky130_fd_sc_hd__decap_4
X_14632_ _03444_ _05264_ VGND VGND VPWR VPWR _01683_ sky130_fd_sc_hd__nor2_4
X_11844_ net444 _05552_ _05555_ VGND VGND VPWR VPWR _00593_ sky130_fd_sc_hd__a21oi_1
XTAP_1952 VGND VPWR sky130_fd_sc_hd__tapvpwrvgnd_1
XTAP_1930 VGND VPWR sky130_fd_sc_hd__tapvpwrvgnd_1
XTAP_1941 VGND VPWR sky130_fd_sc_hd__tapvpwrvgnd_1
XFILLER_0_95_561 VGND VGND VPWR VPWR sky130_fd_sc_hd__fill_1
X_11775_ _05033_ net1253 _05505_ VGND VGND VPWR VPWR _05509_ sky130_fd_sc_hd__mux2_1
XTAP_1985 VGND VPWR sky130_fd_sc_hd__tapvpwrvgnd_1
XTAP_1974 VGND VPWR sky130_fd_sc_hd__tapvpwrvgnd_1
XTAP_1963 VGND VPWR sky130_fd_sc_hd__tapvpwrvgnd_1
X_14563_ _01646_ VGND VGND VPWR VPWR _01156_ sky130_fd_sc_hd__clkbuf_1
XFILLER_0_137_173 VGND VGND VPWR VPWR sky130_fd_sc_hd__fill_1
XTAP_1996 VGND VPWR sky130_fd_sc_hd__tapvpwrvgnd_1
X_13514_ _06780_ _06981_ _06985_ _06991_ _06800_ VGND VGND VPWR VPWR _06992_ sky130_fd_sc_hd__a311o_1
X_14494_ net722 _05225_ _01575_ VGND VGND VPWR VPWR _01610_ sky130_fd_sc_hd__mux2_1
X_10726_ net844 _03519_ _04918_ VGND VGND VPWR VPWR _04920_ sky130_fd_sc_hd__mux2_1
XFILLER_0_55_447 VGND VGND VPWR VPWR sky130_fd_sc_hd__fill_1
X_16302_ clknet_leaf_7_clk _00887_ VGND VGND VPWR VPWR decoded_imm_j\[6\] sky130_fd_sc_hd__dfxtp_1
X_10657_ _03687_ _04857_ _04863_ VGND VGND VPWR VPWR _04864_ sky130_fd_sc_hd__or3_1
X_13445_ _06794_ _06924_ VGND VGND VPWR VPWR _06925_ sky130_fd_sc_hd__and2_1
XFILLER_0_82_266 VGND VGND VPWR VPWR sky130_fd_sc_hd__decap_8
X_16233_ clknet_leaf_20_clk alu_out\[6\] VGND VGND VPWR VPWR alu_out_q\[6\] sky130_fd_sc_hd__dfxtp_1
X_10588_ decoded_imm\[28\] _02621_ VGND VGND VPWR VPWR _04796_ sky130_fd_sc_hd__nor2_1
X_13376_ cpuregs\[28\]\[17\] cpuregs\[29\]\[17\] _06687_ VGND VGND VPWR VPWR _06858_
+ sky130_fd_sc_hd__mux2_1
XFILLER_0_50_141 VGND VGND VPWR VPWR sky130_fd_sc_hd__decap_4
X_16164_ clknet_leaf_116_clk _00782_ VGND VGND VPWR VPWR net37 sky130_fd_sc_hd__dfxtp_1
X_12327_ _05938_ _05940_ VGND VGND VPWR VPWR _05941_ sky130_fd_sc_hd__xnor2_1
X_15115_ net1375 _03455_ _01937_ VGND VGND VPWR VPWR _01940_ sky130_fd_sc_hd__mux2_1
X_16095_ clknet_leaf_148_clk _00745_ VGND VGND VPWR VPWR count_cycle\[38\] sky130_fd_sc_hd__dfxtp_1
X_12258_ decoded_imm_j\[11\] _05714_ VGND VGND VPWR VPWR _05877_ sky130_fd_sc_hd__nor2_1
X_15046_ _01903_ VGND VGND VPWR VPWR _01382_ sky130_fd_sc_hd__clkbuf_1
X_11209_ _03576_ VGND VGND VPWR VPWR _05202_ sky130_fd_sc_hd__clkbuf_4
X_12189_ _05792_ _05809_ _05810_ _05813_ VGND VGND VPWR VPWR _05814_ sky130_fd_sc_hd__a31oi_1
X_15948_ clknet_leaf_146_clk _00598_ VGND VGND VPWR VPWR count_instr\[17\] sky130_fd_sc_hd__dfxtp_1
X_08420_ _02378_ _02780_ _02684_ _02794_ _02800_ VGND VGND VPWR VPWR _02801_ sky130_fd_sc_hd__o221a_1
X_15879_ clknet_leaf_135_clk _00529_ VGND VGND VPWR VPWR cpuregs\[20\]\[13\] sky130_fd_sc_hd__dfxtp_1
XFILLER_0_58_241 VGND VGND VPWR VPWR sky130_fd_sc_hd__fill_1
XFILLER_0_25_95 VGND VGND VPWR VPWR sky130_fd_sc_hd__decap_8
X_08351_ net190 net222 VGND VGND VPWR VPWR _02732_ sky130_fd_sc_hd__nand2_1
XFILLER_0_58_274 VGND VGND VPWR VPWR sky130_fd_sc_hd__decap_6
XFILLER_0_116_302 VGND VGND VPWR VPWR sky130_fd_sc_hd__fill_1
X_08282_ net200 net249 VGND VGND VPWR VPWR _02663_ sky130_fd_sc_hd__or2_1
XFILLER_0_18_127 VGND VGND VPWR VPWR sky130_fd_sc_hd__fill_1
XFILLER_0_128_195 VGND VGND VPWR VPWR sky130_fd_sc_hd__fill_1
XFILLER_0_73_266 VGND VGND VPWR VPWR sky130_fd_sc_hd__fill_1
XFILLER_0_42_642 VGND VGND VPWR VPWR sky130_fd_sc_hd__fill_2
XFILLER_0_1_260 VGND VGND VPWR VPWR sky130_fd_sc_hd__fill_2
Xfanout246 net212 VGND VGND VPWR VPWR net246 sky130_fd_sc_hd__clkbuf_8
X_09805_ _04034_ _02310_ _03715_ VGND VGND VPWR VPWR _04035_ sky130_fd_sc_hd__mux2_1
X_07997_ net410 _02232_ _02396_ VGND VGND VPWR VPWR _02397_ sky130_fd_sc_hd__a21oi_2
X_09736_ cpuregs\[2\]\[5\] cpuregs\[3\]\[5\] _03755_ VGND VGND VPWR VPWR _03967_ sky130_fd_sc_hd__mux2_1
X_09667_ _03722_ VGND VGND VPWR VPWR _03900_ sky130_fd_sc_hd__clkbuf_8
X_08618_ _02391_ _02685_ _02915_ _02840_ VGND VGND VPWR VPWR _02987_ sky130_fd_sc_hd__a31o_1
XTAP_1204 VGND VPWR sky130_fd_sc_hd__tapvpwrvgnd_1
XTAP_1248 VGND VPWR sky130_fd_sc_hd__tapvpwrvgnd_1
XTAP_1237 VGND VPWR sky130_fd_sc_hd__tapvpwrvgnd_1
XTAP_1226 VGND VPWR sky130_fd_sc_hd__tapvpwrvgnd_1
XTAP_1215 VGND VPWR sky130_fd_sc_hd__tapvpwrvgnd_1
X_09598_ _03668_ VGND VGND VPWR VPWR _03832_ sky130_fd_sc_hd__clkbuf_8
X_08549_ _02664_ _02884_ _02907_ _02922_ VGND VGND VPWR VPWR _02923_ sky130_fd_sc_hd__o31a_1
XTAP_1259 VGND VPWR sky130_fd_sc_hd__tapvpwrvgnd_1
XFILLER_0_135_611 VGND VGND VPWR VPWR sky130_fd_sc_hd__decap_3
XFILLER_0_92_553 VGND VGND VPWR VPWR sky130_fd_sc_hd__fill_1
X_11560_ _05022_ net1307 _05386_ VGND VGND VPWR VPWR _05395_ sky130_fd_sc_hd__mux2_1
XFILLER_0_49_296 VGND VGND VPWR VPWR sky130_fd_sc_hd__decap_8
XFILLER_0_134_121 VGND VGND VPWR VPWR sky130_fd_sc_hd__fill_1
X_10511_ decoded_imm\[26\] net189 VGND VGND VPWR VPWR _04721_ sky130_fd_sc_hd__or2_1
XFILLER_0_119_184 VPWR VGND VPWR VGND sky130_ef_sc_hd__decap_12
XFILLER_0_107_313 VGND VGND VPWR VPWR sky130_fd_sc_hd__fill_1
X_11491_ net794 _05198_ _05349_ VGND VGND VPWR VPWR _05358_ sky130_fd_sc_hd__mux2_1
X_13230_ cpuregs\[22\]\[13\] cpuregs\[23\]\[13\] _06450_ VGND VGND VPWR VPWR _06716_
+ sky130_fd_sc_hd__mux2_1
XFILLER_0_24_119 VGND VGND VPWR VPWR sky130_fd_sc_hd__decap_4
XFILLER_0_122_338 VGND VGND VPWR VPWR sky130_fd_sc_hd__fill_1
X_10442_ cpuregs\[5\]\[24\] VGND VGND VPWR VPWR _04654_ sky130_fd_sc_hd__inv_2
XFILLER_0_17_193 VGND VGND VPWR VPWR sky130_fd_sc_hd__decap_3
XFILLER_0_32_141 VGND VGND VPWR VPWR sky130_fd_sc_hd__fill_1
X_10373_ _02156_ _04584_ _04586_ _02159_ VGND VGND VPWR VPWR _04587_ sky130_fd_sc_hd__o211a_1
X_13161_ cpuregs\[16\]\[11\] cpuregs\[17\]\[11\] cpuregs\[18\]\[11\] cpuregs\[19\]\[11\]
+ _06614_ _06648_ VGND VGND VPWR VPWR _06649_ sky130_fd_sc_hd__mux4_1
X_12112_ _05735_ _05747_ _05748_ _05730_ VGND VGND VPWR VPWR _00668_ sky130_fd_sc_hd__o211a_1
X_13092_ _06580_ _06581_ VGND VGND VPWR VPWR _06582_ sky130_fd_sc_hd__or2_1
X_12043_ _03466_ reg_next_pc\[4\] _03221_ VGND VGND VPWR VPWR _05700_ sky130_fd_sc_hd__mux2_2
X_16920_ clknet_leaf_112_clk _01484_ VGND VGND VPWR VPWR cpuregs\[0\]\[7\] sky130_fd_sc_hd__dfxtp_1
X_16851_ clknet_leaf_134_clk _01415_ VGND VGND VPWR VPWR cpuregs\[22\]\[2\] sky130_fd_sc_hd__dfxtp_1
X_16782_ clknet_leaf_70_clk _01346_ VGND VGND VPWR VPWR cpuregs\[5\]\[29\] sky130_fd_sc_hd__dfxtp_1
X_15802_ clknet_leaf_125_clk _00452_ VGND VGND VPWR VPWR cpuregs\[16\]\[0\] sky130_fd_sc_hd__dfxtp_1
X_15733_ clknet_leaf_46_clk _00383_ VGND VGND VPWR VPWR cpuregs\[21\]\[27\] sky130_fd_sc_hd__dfxtp_1
X_13994_ mem_rdata_q\[29\] mem_rdata_q\[28\] mem_rdata_q\[19\] mem_rdata_q\[18\] VGND
+ VGND VPWR VPWR _07409_ sky130_fd_sc_hd__or4_1
XFILLER_0_62_27 VGND VGND VPWR VPWR sky130_fd_sc_hd__fill_1
X_12945_ _06430_ _06433_ _06436_ _06342_ _06438_ VGND VGND VPWR VPWR _06439_ sky130_fd_sc_hd__o311a_1
XANTENNA_151 net200 VGND VGND VPWR VPWR sky130_fd_sc_hd__diode_2
X_15664_ clknet_leaf_80_clk _00314_ VGND VGND VPWR VPWR cpuregs\[14\]\[22\] sky130_fd_sc_hd__dfxtp_1
XANTENNA_140 net96 VGND VGND VPWR VPWR sky130_fd_sc_hd__diode_2
X_12876_ _06374_ VGND VGND VPWR VPWR _06375_ sky130_fd_sc_hd__clkbuf_4
X_14615_ _01674_ VGND VGND VPWR VPWR _01180_ sky130_fd_sc_hd__clkbuf_1
XTAP_1760 VGND VPWR sky130_fd_sc_hd__tapvpwrvgnd_1
XANTENNA_162 net120 VGND VGND VPWR VPWR sky130_fd_sc_hd__diode_2
X_15595_ clknet_leaf_94_clk _00245_ VGND VGND VPWR VPWR cpuregs\[28\]\[17\] sky130_fd_sc_hd__dfxtp_1
X_11827_ _05542_ _05530_ _05543_ VGND VGND VPWR VPWR _05544_ sky130_fd_sc_hd__and3b_1
X_14546_ net877 _05209_ _01634_ VGND VGND VPWR VPWR _01638_ sky130_fd_sc_hd__mux2_1
XTAP_1793 VGND VPWR sky130_fd_sc_hd__tapvpwrvgnd_1
XTAP_1782 VGND VPWR sky130_fd_sc_hd__tapvpwrvgnd_1
XTAP_1771 VGND VPWR sky130_fd_sc_hd__tapvpwrvgnd_1
X_11758_ _05016_ net1363 _05494_ VGND VGND VPWR VPWR _05500_ sky130_fd_sc_hd__mux2_1
XFILLER_0_55_277 VGND VGND VPWR VPWR sky130_fd_sc_hd__decap_3
X_10709_ net1024 _03464_ _04907_ VGND VGND VPWR VPWR _04911_ sky130_fd_sc_hd__mux2_1
X_14477_ _01601_ VGND VGND VPWR VPWR _01083_ sky130_fd_sc_hd__clkbuf_1
X_11689_ _05463_ VGND VGND VPWR VPWR _00530_ sky130_fd_sc_hd__clkbuf_1
XFILLER_0_55_288 VGND VGND VPWR VPWR sky130_fd_sc_hd__fill_2
XFILLER_0_36_480 VGND VGND VPWR VPWR sky130_fd_sc_hd__fill_2
X_16216_ clknet_leaf_63_clk _00833_ VGND VGND VPWR VPWR net222 sky130_fd_sc_hd__dfxtp_4
XFILLER_0_113_305 VGND VGND VPWR VPWR sky130_fd_sc_hd__decap_6
XFILLER_0_102_77 VGND VGND VPWR VPWR sky130_fd_sc_hd__decap_6
X_13428_ _06639_ _06907_ VGND VGND VPWR VPWR _06908_ sky130_fd_sc_hd__and2_1
XFILLER_0_23_141 VGND VGND VPWR VPWR sky130_fd_sc_hd__fill_1
X_16147_ clknet_leaf_40_clk _07635_ VGND VGND VPWR VPWR reg_out\[25\] sky130_fd_sc_hd__dfxtp_1
X_13359_ _06639_ _06840_ VGND VGND VPWR VPWR _06841_ sky130_fd_sc_hd__and2_1
XFILLER_0_87_57 VGND VGND VPWR VPWR sky130_fd_sc_hd__fill_2
XFILLER_0_11_347 VGND VGND VPWR VPWR sky130_fd_sc_hd__decap_3
X_07920_ net7 net25 _02134_ VGND VGND VPWR VPWR _02326_ sky130_fd_sc_hd__mux2_1
X_16078_ clknet_leaf_153_clk _00728_ VGND VGND VPWR VPWR count_cycle\[21\] sky130_fd_sc_hd__dfxtp_1
X_15029_ _03616_ net1151 _01887_ VGND VGND VPWR VPWR _01894_ sky130_fd_sc_hd__mux2_1
X_07851_ net11 _02216_ _02260_ _02212_ VGND VGND VPWR VPWR _02261_ sky130_fd_sc_hd__a22o_1
Xinput2 mem_rdata[10] VGND VGND VPWR VPWR net2 sky130_fd_sc_hd__buf_2
X_07782_ _02186_ _02196_ VGND VGND VPWR VPWR _00023_ sky130_fd_sc_hd__nor2_1
X_09521_ _03755_ VGND VGND VPWR VPWR _03756_ sky130_fd_sc_hd__clkbuf_8
XFILLER_0_36_94 VGND VGND VPWR VPWR sky130_fd_sc_hd__decap_4
X_09452_ _03687_ VGND VGND VPWR VPWR _03688_ sky130_fd_sc_hd__buf_4
X_09383_ _03623_ VGND VGND VPWR VPWR _00064_ sky130_fd_sc_hd__clkbuf_1
XFILLER_0_59_561 VGND VGND VPWR VPWR sky130_fd_sc_hd__fill_2
X_08403_ _02208_ _02748_ VGND VGND VPWR VPWR _02784_ sky130_fd_sc_hd__and2_1
X_08334_ _02713_ _02714_ VGND VGND VPWR VPWR _02715_ sky130_fd_sc_hd__and2_1
XFILLER_0_74_531 VGND VGND VPWR VPWR sky130_fd_sc_hd__fill_1
XFILLER_0_116_110 VGND VGND VPWR VPWR sky130_fd_sc_hd__decap_4
XFILLER_0_74_586 VGND VGND VPWR VPWR sky130_fd_sc_hd__fill_2
XFILLER_0_46_277 VGND VGND VPWR VPWR sky130_fd_sc_hd__decap_8
X_08265_ _02309_ _02646_ _02446_ _02647_ VGND VGND VPWR VPWR _02648_ sky130_fd_sc_hd__o2bb2a_1
XFILLER_0_61_214 VGND VGND VPWR VPWR sky130_fd_sc_hd__fill_1
XFILLER_0_131_113 VGND VGND VPWR VPWR sky130_fd_sc_hd__decap_3
X_08196_ count_instr\[26\] _02201_ count_cycle\[58\] _02456_ VGND VGND VPWR VPWR _02583_
+ sky130_fd_sc_hd__a22o_1
XFILLER_0_131_146 VGND VGND VPWR VPWR sky130_fd_sc_hd__decap_6
XFILLER_0_14_174 VGND VGND VPWR VPWR sky130_fd_sc_hd__fill_1
XFILLER_0_30_645 VGND VGND VPWR VPWR sky130_fd_sc_hd__decap_3
XFILLER_0_100_511 VGND VGND VPWR VPWR sky130_fd_sc_hd__fill_1
XFILLER_0_10_380 VGND VGND VPWR VPWR sky130_fd_sc_hd__fill_1
X_10991_ _05077_ VGND VGND VPWR VPWR _00218_ sky130_fd_sc_hd__clkbuf_1
XFILLER_0_69_325 VGND VGND VPWR VPWR sky130_fd_sc_hd__decap_6
X_09719_ _02280_ _02310_ _03651_ VGND VGND VPWR VPWR _03950_ sky130_fd_sc_hd__mux2_1
XFILLER_0_96_122 VGND VGND VPWR VPWR sky130_fd_sc_hd__fill_1
X_12730_ cpuregs\[2\]\[31\] cpuregs\[3\]\[31\] _03801_ VGND VGND VPWR VPWR _06264_
+ sky130_fd_sc_hd__mux2_1
XTAP_1012 VGND VPWR sky130_fd_sc_hd__tapvpwrvgnd_1
XTAP_1001 VGND VPWR sky130_fd_sc_hd__tapvpwrvgnd_1
XFILLER_0_84_328 VGND VGND VPWR VPWR sky130_fd_sc_hd__fill_1
XTAP_1056 VGND VPWR sky130_fd_sc_hd__tapvpwrvgnd_1
XTAP_1045 VGND VPWR sky130_fd_sc_hd__tapvpwrvgnd_1
XTAP_1034 VGND VPWR sky130_fd_sc_hd__tapvpwrvgnd_1
XTAP_1023 VGND VPWR sky130_fd_sc_hd__tapvpwrvgnd_1
X_12661_ _06210_ _06179_ _06211_ VGND VGND VPWR VPWR _06212_ sky130_fd_sc_hd__and3b_1
XFILLER_0_38_701 VGND VGND VPWR VPWR sky130_fd_sc_hd__fill_1
X_14400_ _01560_ VGND VGND VPWR VPWR _01047_ sky130_fd_sc_hd__clkbuf_1
XTAP_1089 VGND VPWR sky130_fd_sc_hd__tapvpwrvgnd_1
XTAP_1078 VGND VPWR sky130_fd_sc_hd__tapvpwrvgnd_1
XTAP_1067 VGND VPWR sky130_fd_sc_hd__tapvpwrvgnd_1
X_11612_ _05005_ net1243 _05422_ VGND VGND VPWR VPWR _05423_ sky130_fd_sc_hd__mux2_1
XFILLER_0_92_361 VGND VGND VPWR VPWR sky130_fd_sc_hd__decap_3
X_15380_ _05523_ _02076_ net235 _02078_ VGND VGND VPWR VPWR _02079_ sky130_fd_sc_hd__a31o_1
X_12592_ count_cycle\[26\] count_cycle\[27\] net359 _02085_ VGND VGND VPWR VPWR _06163_
+ sky130_fd_sc_hd__a31o_1
XFILLER_0_107_154 VGND VGND VPWR VPWR sky130_fd_sc_hd__decap_3
X_11543_ _05374_ VGND VGND VPWR VPWR _05386_ sky130_fd_sc_hd__buf_4
X_14331_ _06025_ decoded_imm_j\[12\] _07570_ mem_rdata_q\[12\] _07388_ VGND VGND VPWR
+ VPWR _07598_ sky130_fd_sc_hd__a221o_1
XFILLER_0_122_102 VGND VGND VPWR VPWR sky130_fd_sc_hd__decap_3
X_11474_ _05337_ VGND VGND VPWR VPWR _05349_ sky130_fd_sc_hd__buf_4
X_14262_ _02115_ net132 _02113_ VGND VGND VPWR VPWR _07557_ sky130_fd_sc_hd__o21a_1
X_14193_ net554 _02748_ _07519_ VGND VGND VPWR VPWR _07521_ sky130_fd_sc_hd__mux2_1
X_10425_ cpuregs\[28\]\[23\] cpuregs\[29\]\[23\] _03754_ VGND VGND VPWR VPWR _04638_
+ sky130_fd_sc_hd__mux2_1
X_16001_ clknet_leaf_10_clk _00651_ VGND VGND VPWR VPWR reg_pc\[7\] sky130_fd_sc_hd__dfxtp_2
X_13213_ _03337_ VGND VGND VPWR VPWR _06699_ sky130_fd_sc_hd__buf_4
X_13144_ cpuregs\[12\]\[11\] cpuregs\[13\]\[11\] cpuregs\[14\]\[11\] cpuregs\[15\]\[11\]
+ _06418_ _06419_ VGND VGND VPWR VPWR _06632_ sky130_fd_sc_hd__mux4_1
XFILLER_0_131_691 VGND VGND VPWR VPWR sky130_fd_sc_hd__decap_8
X_10356_ _03834_ _04568_ _04570_ VGND VGND VPWR VPWR _04571_ sky130_fd_sc_hd__a21o_1
XFILLER_0_20_166 VGND VGND VPWR VPWR sky130_fd_sc_hd__fill_1
XTAP_807 VGND VPWR sky130_fd_sc_hd__tapvpwrvgnd_1
X_10287_ _03732_ _04499_ _04503_ _03873_ VGND VGND VPWR VPWR _04504_ sky130_fd_sc_hd__o211a_1
XFILLER_0_57_49 VGND VGND VPWR VPWR sky130_fd_sc_hd__decap_6
X_13075_ _06441_ _06553_ _06557_ _06565_ _06468_ VGND VGND VPWR VPWR _06566_ sky130_fd_sc_hd__a311o_1
XTAP_818 VGND VPWR sky130_fd_sc_hd__tapvpwrvgnd_1
XTAP_829 VGND VPWR sky130_fd_sc_hd__tapvpwrvgnd_1
X_12026_ _02108_ VGND VGND VPWR VPWR _05686_ sky130_fd_sc_hd__clkbuf_4
X_16903_ clknet_leaf_78_clk _01467_ VGND VGND VPWR VPWR cpuregs\[8\]\[22\] sky130_fd_sc_hd__dfxtp_1
X_16834_ clknet_leaf_89_clk _01398_ VGND VGND VPWR VPWR cpuregs\[7\]\[17\] sky130_fd_sc_hd__dfxtp_1
XFILLER_0_88_612 VGND VGND VPWR VPWR sky130_fd_sc_hd__fill_1
X_16765_ clknet_leaf_108_clk _01329_ VGND VGND VPWR VPWR cpuregs\[5\]\[12\] sky130_fd_sc_hd__dfxtp_1
X_13977_ _07377_ _07397_ VGND VGND VPWR VPWR _07398_ sky130_fd_sc_hd__and2_1
X_15716_ clknet_leaf_137_clk _00366_ VGND VGND VPWR VPWR cpuregs\[21\]\[10\] sky130_fd_sc_hd__dfxtp_1
X_12928_ _03342_ VGND VGND VPWR VPWR _06422_ sky130_fd_sc_hd__clkbuf_8
X_16696_ clknet_leaf_110_clk _01263_ VGND VGND VPWR VPWR cpuregs\[3\]\[10\] sky130_fd_sc_hd__dfxtp_1
XTAP_2280 VGND VPWR sky130_fd_sc_hd__tapvpwrvgnd_1
X_15647_ clknet_leaf_131_clk _00297_ VGND VGND VPWR VPWR cpuregs\[14\]\[5\] sky130_fd_sc_hd__dfxtp_1
XTAP_2291 VGND VPWR sky130_fd_sc_hd__tapvpwrvgnd_1
X_12859_ _03345_ _06357_ _03310_ VGND VGND VPWR VPWR _06358_ sky130_fd_sc_hd__a21o_1
XFILLER_0_113_54 VGND VGND VPWR VPWR sky130_fd_sc_hd__fill_2
XFILLER_0_90_309 VGND VGND VPWR VPWR sky130_fd_sc_hd__fill_2
XTAP_1590 VGND VPWR sky130_fd_sc_hd__tapvpwrvgnd_1
XFILLER_0_7_127 VGND VGND VPWR VPWR sky130_fd_sc_hd__fill_1
X_15578_ clknet_leaf_125_clk _00228_ VGND VGND VPWR VPWR cpuregs\[28\]\[0\] sky130_fd_sc_hd__dfxtp_1
X_14529_ net791 _05192_ _01623_ VGND VGND VPWR VPWR _01629_ sky130_fd_sc_hd__mux2_1
XFILLER_0_56_586 VGND VGND VPWR VPWR sky130_fd_sc_hd__fill_2
XFILLER_0_98_12 VGND VGND VPWR VPWR sky130_fd_sc_hd__decap_8
X_08050_ _02209_ VGND VGND VPWR VPWR _02447_ sky130_fd_sc_hd__buf_4
XFILLER_0_113_146 VGND VGND VPWR VPWR sky130_fd_sc_hd__decap_6
XFILLER_0_12_601 VGND VGND VPWR VPWR sky130_fd_sc_hd__fill_1
XFILLER_0_12_623 VGND VGND VPWR VPWR sky130_fd_sc_hd__fill_2
XFILLER_0_12_645 VGND VGND VPWR VPWR sky130_fd_sc_hd__decap_4
Xpicorv32_266 VGND VGND VPWR VPWR picorv32_266/HI eoi[13] sky130_fd_sc_hd__conb_1
Xpicorv32_255 VGND VGND VPWR VPWR picorv32_255/HI eoi[2] sky130_fd_sc_hd__conb_1
Xpicorv32_277 VGND VGND VPWR VPWR picorv32_277/HI eoi[24] sky130_fd_sc_hd__conb_1
XFILLER_0_11_155 VGND VGND VPWR VPWR sky130_fd_sc_hd__decap_6
X_08952_ reg_out\[17\] reg_next_pc\[17\] _03248_ VGND VGND VPWR VPWR _03259_ sky130_fd_sc_hd__mux2_1
Xpicorv32_299 VGND VGND VPWR VPWR picorv32_299/HI pcpi_insn[10] sky130_fd_sc_hd__conb_1
Xpicorv32_288 VGND VGND VPWR VPWR picorv32_288/HI mem_la_addr[1] sky130_fd_sc_hd__conb_1
X_08883_ net123 net215 _02447_ VGND VGND VPWR VPWR _03217_ sky130_fd_sc_hd__mux2_2
X_07903_ net199 VGND VGND VPWR VPWR _02310_ sky130_fd_sc_hd__buf_2
X_07834_ _02228_ _02244_ VGND VGND VPWR VPWR _02245_ sky130_fd_sc_hd__xnor2_1
X_07765_ instr_rdcycle _02126_ _02182_ _02131_ VGND VGND VPWR VPWR _02183_ sky130_fd_sc_hd__nor4b_1
X_09504_ _03738_ VGND VGND VPWR VPWR _03739_ sky130_fd_sc_hd__clkbuf_8
XFILLER_0_79_667 VGND VGND VPWR VPWR sky130_fd_sc_hd__fill_2
X_07696_ instr_sub VGND VGND VPWR VPWR _02122_ sky130_fd_sc_hd__clkbuf_8
XPHY_106 VGND VGND VPWR VPWR sky130_fd_sc_hd__decap_3
X_09435_ cpuregs\[16\]\[0\] cpuregs\[17\]\[0\] cpuregs\[18\]\[0\] cpuregs\[19\]\[0\]
+ _03667_ _03670_ VGND VGND VPWR VPWR _03671_ sky130_fd_sc_hd__mux4_1
XFILLER_0_94_648 VGND VGND VPWR VPWR sky130_fd_sc_hd__fill_1
XFILLER_0_93_136 VGND VGND VPWR VPWR sky130_fd_sc_hd__decap_8
XPHY_139 VGND VGND VPWR VPWR sky130_fd_sc_hd__decap_3
XPHY_128 VGND VGND VPWR VPWR sky130_fd_sc_hd__decap_3
XFILLER_0_59_391 VGND VGND VPWR VPWR sky130_fd_sc_hd__fill_1
XPHY_117 VGND VGND VPWR VPWR sky130_fd_sc_hd__decap_3
XFILLER_0_47_520 VGND VGND VPWR VPWR sky130_fd_sc_hd__fill_2
X_09366_ _03546_ _03605_ _03606_ _03608_ VGND VGND VPWR VPWR _03609_ sky130_fd_sc_hd__a22o_2
XFILLER_0_93_169 VGND VGND VPWR VPWR sky130_fd_sc_hd__decap_6
X_09297_ reg_pc\[16\] reg_pc\[15\] _03534_ VGND VGND VPWR VPWR _03549_ sky130_fd_sc_hd__and3_1
X_08317_ _02670_ _02684_ _02697_ VGND VGND VPWR VPWR _02698_ sky130_fd_sc_hd__or3_1
XANTENNA_40 net19 VGND VGND VPWR VPWR sky130_fd_sc_hd__diode_2
XFILLER_0_34_214 VGND VGND VPWR VPWR sky130_fd_sc_hd__fill_1
X_08248_ net192 VGND VGND VPWR VPWR _02632_ sky130_fd_sc_hd__clkbuf_4
XANTENNA_62 net72 VGND VGND VPWR VPWR sky130_fd_sc_hd__diode_2
XANTENNA_84 net115 VGND VGND VPWR VPWR sky130_fd_sc_hd__diode_2
XANTENNA_51 net56 VGND VGND VPWR VPWR sky130_fd_sc_hd__diode_2
XANTENNA_73 net94 VGND VGND VPWR VPWR sky130_fd_sc_hd__diode_2
XFILLER_0_104_135 VGND VGND VPWR VPWR sky130_fd_sc_hd__decap_4
XFILLER_0_62_589 VGND VGND VPWR VPWR sky130_fd_sc_hd__fill_1
XANTENNA_95 net128 VGND VGND VPWR VPWR sky130_fd_sc_hd__diode_2
XFILLER_0_132_477 VGND VGND VPWR VPWR sky130_fd_sc_hd__decap_4
X_08179_ _02221_ _02465_ _02566_ _02160_ _02567_ VGND VGND VPWR VPWR _02568_ sky130_fd_sc_hd__a32o_1
XFILLER_0_104_179 VGND VGND VPWR VPWR sky130_fd_sc_hd__fill_1
X_10210_ cpuregs\[30\]\[17\] cpuregs\[31\]\[17\] _04058_ VGND VGND VPWR VPWR _04429_
+ sky130_fd_sc_hd__mux2_1
XFILLER_0_101_831 VGND VGND VPWR VPWR sky130_fd_sc_hd__fill_1
X_11190_ _05189_ VGND VGND VPWR VPWR _00305_ sky130_fd_sc_hd__clkbuf_1
XFILLER_0_100_352 VGND VGND VPWR VPWR sky130_fd_sc_hd__fill_1
X_10141_ _04154_ _04188_ VGND VGND VPWR VPWR _04361_ sky130_fd_sc_hd__or2_1
Xoutput180 net180 VGND VGND VPWR VPWR pcpi_rs1[18] sky130_fd_sc_hd__buf_2
X_10072_ decoded_imm\[14\] net176 VGND VGND VPWR VPWR _04294_ sky130_fd_sc_hd__or2_1
Xoutput191 net191 VGND VGND VPWR VPWR pcpi_rs1[28] sky130_fd_sc_hd__clkbuf_4
X_13900_ instr_bltu _07325_ _07346_ _07347_ VGND VGND VPWR VPWR _07348_ sky130_fd_sc_hd__a22o_1
X_14880_ _01792_ VGND VGND VPWR VPWR _01815_ sky130_fd_sc_hd__clkbuf_8
XFILLER_0_69_100 VPWR VGND VPWR VGND sky130_ef_sc_hd__decap_12
X_13831_ _02149_ instr_jalr _07291_ VGND VGND VPWR VPWR _07296_ sky130_fd_sc_hd__o21ai_1
X_13762_ cpuregs\[12\]\[30\] cpuregs\[13\]\[30\] cpuregs\[14\]\[30\] cpuregs\[15\]\[30\]
+ _07027_ _06392_ VGND VGND VPWR VPWR _07231_ sky130_fd_sc_hd__mux4_1
XFILLER_0_97_431 VGND VGND VPWR VPWR sky130_fd_sc_hd__fill_1
X_10974_ _05068_ VGND VGND VPWR VPWR _00210_ sky130_fd_sc_hd__clkbuf_1
X_16550_ clknet_leaf_131_clk _01127_ VGND VGND VPWR VPWR cpuregs\[24\]\[2\] sky130_fd_sc_hd__dfxtp_1
X_15501_ clknet_leaf_93_clk _00151_ VGND VGND VPWR VPWR cpuregs\[30\]\[19\] sky130_fd_sc_hd__dfxtp_1
XPHY_8 VGND VGND VPWR VPWR sky130_fd_sc_hd__decap_3
X_12713_ _06249_ VGND VGND VPWR VPWR _00768_ sky130_fd_sc_hd__clkbuf_1
X_13693_ cpuregs\[28\]\[27\] cpuregs\[29\]\[27\] _07018_ VGND VGND VPWR VPWR _07165_
+ sky130_fd_sc_hd__mux2_1
X_16481_ clknet_leaf_133_clk _01063_ VGND VGND VPWR VPWR cpuregs\[19\]\[2\] sky130_fd_sc_hd__dfxtp_1
X_15432_ clknet_leaf_54_clk _00082_ VGND VGND VPWR VPWR net175 sky130_fd_sc_hd__dfxtp_2
XFILLER_0_72_309 VGND VGND VPWR VPWR sky130_fd_sc_hd__fill_1
X_12644_ _06199_ VGND VGND VPWR VPWR _00749_ sky130_fd_sc_hd__clkbuf_1
XFILLER_0_136_761 VGND VGND VPWR VPWR sky130_fd_sc_hd__fill_1
X_15363_ _03610_ net945 _02063_ VGND VGND VPWR VPWR _02069_ sky130_fd_sc_hd__mux2_1
X_12575_ net441 _06148_ _05533_ VGND VGND VPWR VPWR _06151_ sky130_fd_sc_hd__o21ai_1
XFILLER_0_25_214 VGND VGND VPWR VPWR sky130_fd_sc_hd__decap_8
XFILLER_0_92_191 VGND VGND VPWR VPWR sky130_fd_sc_hd__decap_3
Xwire241 _07387_ VGND VGND VPWR VPWR net241 sky130_fd_sc_hd__clkbuf_2
X_14314_ is_beq_bne_blt_bge_bltu_bgeu _02189_ _07460_ VGND VGND VPWR VPWR _07588_
+ sky130_fd_sc_hd__or3_4
X_11526_ _05377_ VGND VGND VPWR VPWR _00453_ sky130_fd_sc_hd__clkbuf_1
X_15294_ _02032_ VGND VGND VPWR VPWR _01501_ sky130_fd_sc_hd__clkbuf_1
XFILLER_0_25_269 VGND VGND VPWR VPWR sky130_fd_sc_hd__decap_4
XFILLER_0_123_477 VGND VGND VPWR VPWR sky130_fd_sc_hd__fill_1
X_14245_ net516 net115 _07541_ VGND VGND VPWR VPWR _07548_ sky130_fd_sc_hd__mux2_1
X_11457_ _05340_ VGND VGND VPWR VPWR _00421_ sky130_fd_sc_hd__clkbuf_1
XFILLER_0_21_431 VGND VGND VPWR VPWR sky130_fd_sc_hd__fill_1
X_14176_ _07507_ VGND VGND VPWR VPWR _00952_ sky130_fd_sc_hd__clkbuf_1
X_10408_ _03766_ _04618_ _04620_ VGND VGND VPWR VPWR _04621_ sky130_fd_sc_hd__a21o_1
X_11388_ net1652 _05163_ _05302_ VGND VGND VPWR VPWR _05304_ sky130_fd_sc_hd__mux2_1
X_10339_ cpuregs\[4\]\[21\] cpuregs\[5\]\[21\] cpuregs\[6\]\[21\] cpuregs\[7\]\[21\]
+ _03864_ _03820_ VGND VGND VPWR VPWR _04554_ sky130_fd_sc_hd__mux4_1
X_13127_ _06518_ _06615_ VGND VGND VPWR VPWR _06616_ sky130_fd_sc_hd__or2_1
XTAP_604 VGND VPWR sky130_fd_sc_hd__tapvpwrvgnd_1
XTAP_615 VGND VPWR sky130_fd_sc_hd__tapvpwrvgnd_1
XTAP_626 VGND VPWR sky130_fd_sc_hd__tapvpwrvgnd_1
XTAP_637 VGND VPWR sky130_fd_sc_hd__tapvpwrvgnd_1
XTAP_648 VGND VPWR sky130_fd_sc_hd__tapvpwrvgnd_1
XTAP_659 VGND VPWR sky130_fd_sc_hd__tapvpwrvgnd_1
X_13058_ _03321_ _06548_ VGND VGND VPWR VPWR _06549_ sky130_fd_sc_hd__or2_1
X_12009_ count_instr\[57\] _05671_ count_instr\[58\] VGND VGND VPWR VPWR _05675_ sky130_fd_sc_hd__a21o_1
XFILLER_0_108_32 VGND VGND VPWR VPWR sky130_fd_sc_hd__decap_4
X_16817_ clknet_leaf_119_clk _01381_ VGND VGND VPWR VPWR cpuregs\[7\]\[0\] sky130_fd_sc_hd__dfxtp_1
X_16748_ clknet_leaf_74_clk _01312_ VGND VGND VPWR VPWR cpuregs\[4\]\[27\] sky130_fd_sc_hd__dfxtp_1
XFILLER_0_17_85 VGND VGND VPWR VPWR sky130_fd_sc_hd__decap_4
XFILLER_0_88_475 VGND VGND VPWR VPWR sky130_fd_sc_hd__fill_1
XFILLER_0_75_103 VGND VGND VPWR VPWR sky130_fd_sc_hd__fill_2
X_16679_ clknet_leaf_67_clk _01246_ VGND VGND VPWR VPWR cpuregs\[29\]\[25\] sky130_fd_sc_hd__dfxtp_1
X_09220_ reg_pc\[6\] _03474_ VGND VGND VPWR VPWR _03482_ sky130_fd_sc_hd__or2_1
XFILLER_0_118_238 VGND VGND VPWR VPWR sky130_fd_sc_hd__fill_1
XFILLER_0_33_73 VGND VGND VPWR VPWR sky130_fd_sc_hd__decap_3
XFILLER_0_90_139 VGND VGND VPWR VPWR sky130_fd_sc_hd__fill_1
X_09151_ mem_rdata_q\[22\] net15 _03292_ VGND VGND VPWR VPWR _03425_ sky130_fd_sc_hd__mux2_1
XFILLER_0_44_523 VGND VGND VPWR VPWR sky130_fd_sc_hd__fill_1
X_08102_ _02286_ _02485_ _02495_ VGND VGND VPWR VPWR _07628_ sky130_fd_sc_hd__o21a_1
X_09082_ reg_sh\[3\] reg_sh\[2\] reg_sh\[4\] VGND VGND VPWR VPWR _03363_ sky130_fd_sc_hd__nor3_1
XFILLER_0_140_85 VGND VGND VPWR VPWR sky130_fd_sc_hd__decap_4
X_08033_ latched_is_lh _02430_ _02338_ VGND VGND VPWR VPWR _02431_ sky130_fd_sc_hd__a21oi_1
Xhold811 cpuregs\[14\]\[28\] VGND VGND VPWR VPWR net1169 sky130_fd_sc_hd__dlygate4sd3_1
XFILLER_0_114_477 VGND VGND VPWR VPWR sky130_fd_sc_hd__fill_2
Xhold800 cpuregs\[15\]\[5\] VGND VGND VPWR VPWR net1158 sky130_fd_sc_hd__dlygate4sd3_1
Xhold844 cpuregs\[5\]\[22\] VGND VGND VPWR VPWR net1202 sky130_fd_sc_hd__dlygate4sd3_1
Xhold855 net155 VGND VGND VPWR VPWR net1213 sky130_fd_sc_hd__dlygate4sd3_1
Xhold833 cpuregs\[18\]\[17\] VGND VGND VPWR VPWR net1191 sky130_fd_sc_hd__dlygate4sd3_1
Xhold822 cpuregs\[5\]\[31\] VGND VGND VPWR VPWR net1180 sky130_fd_sc_hd__dlygate4sd3_1
Xhold877 cpuregs\[7\]\[15\] VGND VGND VPWR VPWR net1235 sky130_fd_sc_hd__dlygate4sd3_1
Xhold888 cpuregs\[17\]\[0\] VGND VGND VPWR VPWR net1246 sky130_fd_sc_hd__dlygate4sd3_1
Xhold866 cpuregs\[17\]\[7\] VGND VGND VPWR VPWR net1224 sky130_fd_sc_hd__dlygate4sd3_1
Xhold899 cpuregs\[20\]\[15\] VGND VGND VPWR VPWR net1257 sky130_fd_sc_hd__dlygate4sd3_1
XFILLER_0_58_70 VGND VGND VPWR VPWR sky130_fd_sc_hd__fill_1
X_09984_ cpuregs\[22\]\[11\] cpuregs\[23\]\[11\] _04194_ VGND VGND VPWR VPWR _04209_
+ sky130_fd_sc_hd__mux2_1
X_08935_ _03247_ VGND VGND VPWR VPWR net67 sky130_fd_sc_hd__clkbuf_4
X_08866_ net205 _03204_ _03208_ VGND VGND VPWR VPWR net99 sky130_fd_sc_hd__a21o_4
X_08797_ _03150_ _03138_ _03151_ VGND VGND VPWR VPWR _03152_ sky130_fd_sc_hd__a21o_1
X_07817_ reg_pc\[1\] decoded_imm\[1\] VGND VGND VPWR VPWR _02229_ sky130_fd_sc_hd__or2_1
XFILLER_0_74_91 VGND VGND VPWR VPWR sky130_fd_sc_hd__fill_1
X_07748_ _02138_ _02167_ VGND VGND VPWR VPWR _02168_ sky130_fd_sc_hd__and2_1
X_07679_ _02108_ _02084_ VGND VGND VPWR VPWR _02109_ sky130_fd_sc_hd__nor2_2
X_10690_ _03688_ _04895_ _03959_ VGND VGND VPWR VPWR _04896_ sky130_fd_sc_hd__o21a_1
X_09418_ _02224_ _02280_ _03653_ VGND VGND VPWR VPWR _03654_ sky130_fd_sc_hd__mux2_1
X_09349_ reg_pc\[23\] _03588_ _03460_ VGND VGND VPWR VPWR _03594_ sky130_fd_sc_hd__o21ai_1
XFILLER_0_94_489 VGND VGND VPWR VPWR sky130_fd_sc_hd__fill_2
X_12360_ _05969_ _05970_ VGND VGND VPWR VPWR _05971_ sky130_fd_sc_hd__nor2_1
XFILLER_0_74_191 VGND VGND VPWR VPWR sky130_fd_sc_hd__decap_4
X_11311_ net1033 _05223_ _05228_ VGND VGND VPWR VPWR _05262_ sky130_fd_sc_hd__mux2_1
X_12291_ _05904_ VGND VGND VPWR VPWR _05908_ sky130_fd_sc_hd__inv_2
XFILLER_0_62_386 VGND VGND VPWR VPWR sky130_fd_sc_hd__decap_4
XFILLER_0_120_414 VGND VGND VPWR VPWR sky130_fd_sc_hd__decap_6
X_11242_ _05224_ VGND VGND VPWR VPWR _00322_ sky130_fd_sc_hd__clkbuf_1
X_14030_ _07431_ VGND VGND VPWR VPWR _01122_ sky130_fd_sc_hd__clkbuf_1
X_11173_ net938 _05177_ _05161_ VGND VGND VPWR VPWR _05178_ sky130_fd_sc_hd__mux2_1
XFILLER_0_30_250 VGND VGND VPWR VPWR sky130_fd_sc_hd__fill_2
X_10124_ cpuregs\[22\]\[15\] cpuregs\[23\]\[15\] _03750_ VGND VGND VPWR VPWR _04345_
+ sky130_fd_sc_hd__mux2_1
XFILLER_0_38_29 VGND VGND VPWR VPWR sky130_fd_sc_hd__decap_3
X_15981_ clknet_leaf_151_clk _00631_ VGND VGND VPWR VPWR count_instr\[50\] sky130_fd_sc_hd__dfxtp_1
X_10055_ cpuregs\[22\]\[13\] cpuregs\[23\]\[13\] _03750_ VGND VGND VPWR VPWR _04278_
+ sky130_fd_sc_hd__mux2_1
X_14932_ _03525_ net811 _01840_ VGND VGND VPWR VPWR _01843_ sky130_fd_sc_hd__mux2_1
X_14863_ _01806_ VGND VGND VPWR VPWR _01296_ sky130_fd_sc_hd__clkbuf_1
X_13814_ cpuregs\[30\]\[31\] cpuregs\[31\]\[31\] _06510_ VGND VGND VPWR VPWR _07282_
+ sky130_fd_sc_hd__mux2_1
X_16602_ clknet_leaf_106_clk _01169_ VGND VGND VPWR VPWR cpuregs\[9\]\[12\] sky130_fd_sc_hd__dfxtp_1
XFILLER_0_97_250 VGND VGND VPWR VPWR sky130_fd_sc_hd__fill_2
X_14794_ _01769_ VGND VGND VPWR VPWR _01264_ sky130_fd_sc_hd__clkbuf_1
X_13745_ _06962_ _07207_ _07214_ VGND VGND VPWR VPWR _07215_ sky130_fd_sc_hd__or3_1
XFILLER_0_97_272 VGND VGND VPWR VPWR sky130_fd_sc_hd__fill_2
XFILLER_0_85_412 VGND VGND VPWR VPWR sky130_fd_sc_hd__decap_6
X_16533_ clknet_leaf_28_clk _01110_ VGND VGND VPWR VPWR mem_rdata_q\[17\] sky130_fd_sc_hd__dfxtp_1
XFILLER_0_58_637 VGND VGND VPWR VPWR sky130_fd_sc_hd__fill_1
X_10957_ _05059_ VGND VGND VPWR VPWR _00202_ sky130_fd_sc_hd__clkbuf_1
X_13676_ _06868_ _07145_ _07147_ VGND VGND VPWR VPWR _07148_ sky130_fd_sc_hd__a21o_1
X_16464_ clknet_leaf_97_clk _01046_ VGND VGND VPWR VPWR cpuregs\[18\]\[17\] sky130_fd_sc_hd__dfxtp_1
XFILLER_0_57_169 VGND VGND VPWR VPWR sky130_fd_sc_hd__decap_4
X_10888_ _05014_ net1351 _05006_ VGND VGND VPWR VPWR _05015_ sky130_fd_sc_hd__mux2_1
XFILLER_0_66_670 VGND VGND VPWR VPWR sky130_fd_sc_hd__decap_3
X_15415_ clknet_leaf_100_clk _00028_ VGND VGND VPWR VPWR _00008_ sky130_fd_sc_hd__dfxtp_2
X_12627_ _06186_ _06187_ VGND VGND VPWR VPWR _00744_ sky130_fd_sc_hd__nor2_1
X_16395_ clknet_leaf_116_clk _00977_ VGND VGND VPWR VPWR net149 sky130_fd_sc_hd__dfxtp_1
X_15346_ _03558_ net868 _02052_ VGND VGND VPWR VPWR _02060_ sky130_fd_sc_hd__mux2_1
X_12558_ net788 _06135_ _06138_ VGND VGND VPWR VPWR _00724_ sky130_fd_sc_hd__o21a_1
X_12489_ _06005_ _05757_ _06078_ VGND VGND VPWR VPWR _06089_ sky130_fd_sc_hd__a21oi_1
X_11509_ _05367_ VGND VGND VPWR VPWR _00446_ sky130_fd_sc_hd__clkbuf_1
XFILLER_0_110_22 VGND VGND VPWR VPWR sky130_fd_sc_hd__decap_6
XFILLER_0_79_47 VGND VGND VPWR VPWR sky130_fd_sc_hd__fill_1
X_15277_ net491 VGND VGND VPWR VPWR _02024_ sky130_fd_sc_hd__clkbuf_1
XFILLER_0_53_386 VGND VGND VPWR VPWR sky130_fd_sc_hd__decap_6
Xhold107 count_instr\[28\] VGND VGND VPWR VPWR net465 sky130_fd_sc_hd__dlygate4sd3_1
XFILLER_0_41_559 VGND VGND VPWR VPWR sky130_fd_sc_hd__fill_1
XFILLER_0_110_77 VGND VGND VPWR VPWR sky130_fd_sc_hd__decap_6
Xhold118 _01025_ VGND VGND VPWR VPWR net476 sky130_fd_sc_hd__dlygate4sd3_1
X_14228_ net144 net106 _07530_ VGND VGND VPWR VPWR _07539_ sky130_fd_sc_hd__mux2_1
Xhold129 net161 VGND VGND VPWR VPWR net487 sky130_fd_sc_hd__dlygate4sd3_1
XFILLER_0_21_272 VGND VGND VPWR VPWR sky130_fd_sc_hd__fill_1
X_14159_ _05039_ net1367 _07493_ VGND VGND VPWR VPWR _07500_ sky130_fd_sc_hd__mux2_1
XTAP_423 VGND VPWR sky130_fd_sc_hd__tapvpwrvgnd_1
XTAP_412 VGND VPWR sky130_fd_sc_hd__tapvpwrvgnd_1
XTAP_401 VGND VPWR sky130_fd_sc_hd__tapvpwrvgnd_1
XFILLER_0_1_689 VGND VGND VPWR VPWR sky130_fd_sc_hd__decap_6
XFILLER_0_119_53 VGND VGND VPWR VPWR sky130_fd_sc_hd__decap_3
XTAP_445 VGND VPWR sky130_fd_sc_hd__tapvpwrvgnd_1
XTAP_434 VGND VPWR sky130_fd_sc_hd__tapvpwrvgnd_1
XTAP_456 VGND VPWR sky130_fd_sc_hd__tapvpwrvgnd_1
XTAP_467 VGND VPWR sky130_fd_sc_hd__tapvpwrvgnd_1
X_08720_ _02522_ _03079_ VGND VGND VPWR VPWR _03080_ sky130_fd_sc_hd__xnor2_1
XTAP_478 VGND VPWR sky130_fd_sc_hd__tapvpwrvgnd_1
XTAP_489 VGND VPWR sky130_fd_sc_hd__tapvpwrvgnd_1
X_08651_ _03015_ _03016_ VGND VGND VPWR VPWR _03017_ sky130_fd_sc_hd__and2b_1
X_08582_ _02675_ _02895_ _02952_ VGND VGND VPWR VPWR _02953_ sky130_fd_sc_hd__a21o_1
XFILLER_0_49_604 VGND VGND VPWR VPWR sky130_fd_sc_hd__fill_1
XFILLER_0_48_114 VGND VGND VPWR VPWR sky130_fd_sc_hd__decap_6
XFILLER_0_9_745 VPWR VGND VPWR VGND sky130_ef_sc_hd__decap_12
X_09203_ _03433_ VGND VGND VPWR VPWR _03467_ sky130_fd_sc_hd__clkbuf_4
XFILLER_0_63_139 VGND VGND VPWR VPWR sky130_fd_sc_hd__fill_1
X_09134_ cpuregs\[16\]\[4\] cpuregs\[17\]\[4\] _03342_ VGND VGND VPWR VPWR _03413_
+ sky130_fd_sc_hd__mux2_1
XFILLER_0_71_161 VGND VGND VPWR VPWR sky130_fd_sc_hd__fill_2
X_09065_ _03345_ VGND VGND VPWR VPWR _03346_ sky130_fd_sc_hd__buf_4
XFILLER_0_102_436 VGND VGND VPWR VPWR sky130_fd_sc_hd__fill_1
X_08016_ _02336_ _02414_ _02338_ VGND VGND VPWR VPWR _02415_ sky130_fd_sc_hd__a21o_1
XFILLER_0_4_472 VGND VGND VPWR VPWR sky130_fd_sc_hd__fill_1
Xhold630 cpuregs\[27\]\[4\] VGND VGND VPWR VPWR net988 sky130_fd_sc_hd__dlygate4sd3_1
Xhold641 cpuregs\[10\]\[26\] VGND VGND VPWR VPWR net999 sky130_fd_sc_hd__dlygate4sd3_1
Xhold652 cpuregs\[28\]\[24\] VGND VGND VPWR VPWR net1010 sky130_fd_sc_hd__dlygate4sd3_1
Xhold663 cpuregs\[17\]\[14\] VGND VGND VPWR VPWR net1021 sky130_fd_sc_hd__dlygate4sd3_1
XFILLER_0_69_91 VGND VGND VPWR VPWR sky130_fd_sc_hd__decap_3
XFILLER_0_69_80 VGND VGND VPWR VPWR sky130_fd_sc_hd__fill_2
Xhold685 cpuregs\[19\]\[13\] VGND VGND VPWR VPWR net1043 sky130_fd_sc_hd__dlygate4sd3_1
Xhold674 cpuregs\[18\]\[12\] VGND VGND VPWR VPWR net1032 sky130_fd_sc_hd__dlygate4sd3_1
Xhold696 cpuregs\[4\]\[6\] VGND VGND VPWR VPWR net1054 sky130_fd_sc_hd__dlygate4sd3_1
X_09967_ _03980_ VGND VGND VPWR VPWR _04192_ sky130_fd_sc_hd__clkbuf_8
X_08918_ _02310_ _03235_ _03227_ VGND VGND VPWR VPWR _03236_ sky130_fd_sc_hd__mux2_2
X_09898_ _03675_ VGND VGND VPWR VPWR _04125_ sky130_fd_sc_hd__clkbuf_8
XTAP_990 VGND VPWR sky130_fd_sc_hd__tapvpwrvgnd_1
X_08849_ _02934_ net226 _03188_ VGND VGND VPWR VPWR _03199_ sky130_fd_sc_hd__a21oi_1
X_11860_ count_instr\[15\] count_instr\[14\] _05557_ _05566_ VGND VGND VPWR VPWR _05567_
+ sky130_fd_sc_hd__and4_1
X_10811_ net845 _03564_ _04957_ VGND VGND VPWR VPWR _04966_ sky130_fd_sc_hd__mux2_1
X_11791_ _05049_ net981 _05482_ VGND VGND VPWR VPWR _05517_ sky130_fd_sc_hd__mux2_1
XFILLER_0_39_103 VGND VGND VPWR VPWR sky130_fd_sc_hd__fill_1
X_13530_ _06911_ _07006_ VGND VGND VPWR VPWR _07007_ sky130_fd_sc_hd__or2_1
XFILLER_0_94_253 VGND VGND VPWR VPWR sky130_fd_sc_hd__decap_4
XFILLER_0_94_242 VGND VGND VPWR VPWR sky130_fd_sc_hd__decap_8
X_10742_ net843 _03571_ _04918_ VGND VGND VPWR VPWR _04928_ sky130_fd_sc_hd__mux2_1
XFILLER_0_27_309 VGND VGND VPWR VPWR sky130_fd_sc_hd__decap_6
XFILLER_0_39_136 VGND VGND VPWR VPWR sky130_fd_sc_hd__fill_1
XFILLER_0_54_117 VGND VGND VPWR VPWR sky130_fd_sc_hd__decap_3
XFILLER_0_39_169 VPWR VGND VPWR VGND sky130_ef_sc_hd__decap_12
X_10673_ cpuregs\[14\]\[30\] cpuregs\[15\]\[30\] _03756_ VGND VGND VPWR VPWR _04879_
+ sky130_fd_sc_hd__mux2_1
X_13461_ _06773_ _06939_ VGND VGND VPWR VPWR _06940_ sky130_fd_sc_hd__and2_1
X_15200_ _03511_ net834 _01984_ VGND VGND VPWR VPWR _01985_ sky130_fd_sc_hd__mux2_1
XFILLER_0_54_139 VGND VGND VPWR VPWR sky130_fd_sc_hd__fill_1
X_16180_ clknet_leaf_36_clk _00798_ VGND VGND VPWR VPWR net53 sky130_fd_sc_hd__dfxtp_1
X_12412_ _06015_ _06018_ VGND VGND VPWR VPWR _06019_ sky130_fd_sc_hd__xnor2_1
X_13392_ _03332_ VGND VGND VPWR VPWR _06873_ sky130_fd_sc_hd__buf_4
XFILLER_0_63_673 VGND VGND VPWR VPWR sky130_fd_sc_hd__fill_1
XFILLER_0_62_150 VGND VGND VPWR VPWR sky130_fd_sc_hd__fill_1
XFILLER_0_121_701 VGND VGND VPWR VPWR sky130_fd_sc_hd__fill_1
XFILLER_0_105_252 VGND VGND VPWR VPWR sky130_fd_sc_hd__fill_2
X_12343_ _05723_ _05955_ _05920_ _05728_ VGND VGND VPWR VPWR _05956_ sky130_fd_sc_hd__nor4b_2
X_15131_ _01936_ VGND VGND VPWR VPWR _01948_ sky130_fd_sc_hd__buf_4
XFILLER_0_105_263 VGND VGND VPWR VPWR sky130_fd_sc_hd__fill_2
X_12274_ _05714_ _05868_ _05716_ VGND VGND VPWR VPWR _05892_ sky130_fd_sc_hd__a21o_1
XFILLER_0_50_345 VGND VGND VPWR VPWR sky130_fd_sc_hd__fill_1
X_15062_ _01911_ VGND VGND VPWR VPWR _01390_ sky130_fd_sc_hd__clkbuf_1
X_11225_ _03609_ VGND VGND VPWR VPWR _05213_ sky130_fd_sc_hd__clkbuf_4
X_14013_ mem_rdata_q\[25\] net18 _07422_ VGND VGND VPWR VPWR _07423_ sky130_fd_sc_hd__mux2_1
X_11156_ _05166_ VGND VGND VPWR VPWR _00294_ sky130_fd_sc_hd__clkbuf_1
X_10107_ _04295_ _04299_ _04327_ VGND VGND VPWR VPWR _04328_ sky130_fd_sc_hd__nand3_1
X_15964_ clknet_leaf_150_clk _00614_ VGND VGND VPWR VPWR count_instr\[33\] sky130_fd_sc_hd__dfxtp_1
X_11087_ _05128_ VGND VGND VPWR VPWR _00263_ sky130_fd_sc_hd__clkbuf_1
X_10038_ _04226_ _04230_ _04260_ VGND VGND VPWR VPWR _04261_ sky130_fd_sc_hd__nand3_1
X_14915_ _03472_ net1500 _01829_ VGND VGND VPWR VPWR _01834_ sky130_fd_sc_hd__mux2_1
X_15895_ clknet_leaf_61_clk _00545_ VGND VGND VPWR VPWR cpuregs\[20\]\[29\] sky130_fd_sc_hd__dfxtp_1
XFILLER_0_81_26 VGND VGND VPWR VPWR sky130_fd_sc_hd__decap_3
X_14846_ _01797_ VGND VGND VPWR VPWR _01288_ sky130_fd_sc_hd__clkbuf_1
XFILLER_0_98_581 VGND VGND VPWR VPWR sky130_fd_sc_hd__decap_6
X_14777_ _01760_ VGND VGND VPWR VPWR _01256_ sky130_fd_sc_hd__clkbuf_1
XFILLER_0_129_823 VGND VGND VPWR VPWR sky130_fd_sc_hd__fill_1
X_13728_ _06377_ _07188_ _07192_ _07198_ _06341_ VGND VGND VPWR VPWR _07199_ sky130_fd_sc_hd__a311o_1
XFILLER_0_85_231 VPWR VGND VPWR VGND sky130_ef_sc_hd__decap_12
X_11989_ _02140_ VGND VGND VPWR VPWR _05661_ sky130_fd_sc_hd__clkbuf_4
X_16516_ clknet_leaf_6_clk _01093_ VGND VGND VPWR VPWR mem_rdata_q\[0\] sky130_fd_sc_hd__dfxtp_1
XFILLER_0_128_355 VGND VGND VPWR VPWR sky130_fd_sc_hd__fill_1
XFILLER_0_105_99 VPWR VGND VPWR VGND sky130_ef_sc_hd__decap_12
XFILLER_0_14_64 VGND VGND VPWR VPWR sky130_fd_sc_hd__decap_6
X_13659_ cpuregs\[22\]\[26\] cpuregs\[23\]\[26\] _06386_ VGND VGND VPWR VPWR _07132_
+ sky130_fd_sc_hd__mux2_1
X_16447_ clknet_leaf_126_clk _01029_ VGND VGND VPWR VPWR cpuregs\[18\]\[0\] sky130_fd_sc_hd__dfxtp_1
X_16378_ clknet_leaf_119_clk _00960_ VGND VGND VPWR VPWR net162 sky130_fd_sc_hd__dfxtp_1
XFILLER_0_26_386 VGND VGND VPWR VPWR sky130_fd_sc_hd__fill_1
X_15329_ _03504_ net898 _02041_ VGND VGND VPWR VPWR _02051_ sky130_fd_sc_hd__mux2_1
X_09821_ _00016_ _04042_ _04049_ VGND VGND VPWR VPWR _04050_ sky130_fd_sc_hd__or3_2
X_09752_ _03720_ _03978_ _03982_ VGND VGND VPWR VPWR _03983_ sky130_fd_sc_hd__a21o_1
X_08703_ _03022_ _03063_ VGND VGND VPWR VPWR _03064_ sky130_fd_sc_hd__nor2_2
XTAP_286 VGND VPWR sky130_fd_sc_hd__tapvpwrvgnd_1
XTAP_297 VGND VPWR sky130_fd_sc_hd__tapvpwrvgnd_1
X_09683_ _03911_ _03912_ _03913_ VGND VGND VPWR VPWR _03915_ sky130_fd_sc_hd__nand3_1
XTAP_2109 VGND VPWR sky130_fd_sc_hd__tapvpwrvgnd_1
X_08634_ net176 _03000_ VGND VGND VPWR VPWR _03001_ sky130_fd_sc_hd__nand2_1
X_08565_ _02340_ _02937_ VGND VGND VPWR VPWR _02938_ sky130_fd_sc_hd__nand2_1
XTAP_1419 VGND VPWR sky130_fd_sc_hd__tapvpwrvgnd_1
XTAP_1408 VGND VPWR sky130_fd_sc_hd__tapvpwrvgnd_1
XFILLER_0_119_322 VGND VGND VPWR VPWR sky130_fd_sc_hd__fill_2
X_08496_ net196 _02872_ VGND VGND VPWR VPWR _02874_ sky130_fd_sc_hd__or2_1
XFILLER_0_18_810 VGND VGND VPWR VPWR sky130_fd_sc_hd__fill_2
XFILLER_0_107_517 VGND VGND VPWR VPWR sky130_fd_sc_hd__fill_1
XFILLER_0_134_369 VGND VGND VPWR VPWR sky130_fd_sc_hd__fill_1
XFILLER_0_60_621 VGND VGND VPWR VPWR sky130_fd_sc_hd__fill_1
X_09117_ cpuregs\[4\]\[4\] cpuregs\[5\]\[4\] cpuregs\[6\]\[4\] cpuregs\[7\]\[4\] _03336_
+ _03337_ VGND VGND VPWR VPWR _03396_ sky130_fd_sc_hd__mux4_1
X_09048_ _03322_ VGND VGND VPWR VPWR _03329_ sky130_fd_sc_hd__buf_6
XFILLER_0_20_507 VGND VGND VPWR VPWR sky130_fd_sc_hd__decap_3
XFILLER_0_102_222 VPWR VGND VPWR VGND sky130_ef_sc_hd__decap_12
XFILLER_0_13_570 VGND VGND VPWR VPWR sky130_fd_sc_hd__decap_3
Xhold460 cpuregs\[3\]\[21\] VGND VGND VPWR VPWR net818 sky130_fd_sc_hd__dlygate4sd3_1
XFILLER_0_130_586 VGND VGND VPWR VPWR sky130_fd_sc_hd__fill_2
Xhold471 cpuregs\[30\]\[15\] VGND VGND VPWR VPWR net829 sky130_fd_sc_hd__dlygate4sd3_1
XFILLER_0_130_597 VGND VGND VPWR VPWR sky130_fd_sc_hd__decap_4
Xhold493 cpuregs\[14\]\[21\] VGND VGND VPWR VPWR net851 sky130_fd_sc_hd__dlygate4sd3_1
X_11010_ _04905_ _04942_ VGND VGND VPWR VPWR _05087_ sky130_fd_sc_hd__nor2_2
Xhold482 cpuregs\[8\]\[3\] VGND VGND VPWR VPWR net840 sky130_fd_sc_hd__dlygate4sd3_1
XFILLER_0_99_334 VGND VGND VPWR VPWR sky130_fd_sc_hd__fill_2
Xhold1160 cpuregs\[18\]\[8\] VGND VGND VPWR VPWR net1518 sky130_fd_sc_hd__dlygate4sd3_1
X_12961_ _06382_ VGND VGND VPWR VPWR _06455_ sky130_fd_sc_hd__buf_4
Xhold1171 cpuregs\[4\]\[20\] VGND VGND VPWR VPWR net1529 sky130_fd_sc_hd__dlygate4sd3_1
Xhold1182 cpuregs\[21\]\[10\] VGND VGND VPWR VPWR net1540 sky130_fd_sc_hd__dlygate4sd3_1
X_14700_ _04942_ _04983_ VGND VGND VPWR VPWR _01719_ sky130_fd_sc_hd__or2_4
X_15680_ clknet_leaf_144_clk _00330_ VGND VGND VPWR VPWR cpuregs\[27\]\[6\] sky130_fd_sc_hd__dfxtp_1
X_12892_ _06377_ _06379_ _06381_ _06385_ _06389_ VGND VGND VPWR VPWR _06390_ sky130_fd_sc_hd__a32o_1
X_11912_ count_instr\[31\] _05602_ _02164_ VGND VGND VPWR VPWR _05605_ sky130_fd_sc_hd__a21oi_1
Xhold1193 cpuregs\[29\]\[7\] VGND VGND VPWR VPWR net1551 sky130_fd_sc_hd__dlygate4sd3_1
X_14631_ _01682_ VGND VGND VPWR VPWR _01188_ sky130_fd_sc_hd__clkbuf_1
X_11843_ net444 _05552_ _05533_ VGND VGND VPWR VPWR _05555_ sky130_fd_sc_hd__o21ai_1
XFILLER_0_129_119 VGND VGND VPWR VPWR sky130_fd_sc_hd__fill_2
XTAP_1931 VGND VPWR sky130_fd_sc_hd__tapvpwrvgnd_1
XTAP_1942 VGND VPWR sky130_fd_sc_hd__tapvpwrvgnd_1
XTAP_1920 VGND VPWR sky130_fd_sc_hd__tapvpwrvgnd_1
XFILLER_0_68_754 VGND VGND VPWR VPWR sky130_fd_sc_hd__fill_2
X_11774_ _05508_ VGND VGND VPWR VPWR _00570_ sky130_fd_sc_hd__clkbuf_1
XTAP_1986 VGND VPWR sky130_fd_sc_hd__tapvpwrvgnd_1
XTAP_1975 VGND VPWR sky130_fd_sc_hd__tapvpwrvgnd_1
XTAP_1964 VGND VPWR sky130_fd_sc_hd__tapvpwrvgnd_1
XTAP_1953 VGND VPWR sky130_fd_sc_hd__tapvpwrvgnd_1
XFILLER_0_83_724 VGND VGND VPWR VPWR sky130_fd_sc_hd__decap_4
X_14562_ net1613 _05225_ _01611_ VGND VGND VPWR VPWR _01646_ sky130_fd_sc_hd__mux2_1
X_16301_ clknet_leaf_9_clk _00886_ VGND VGND VPWR VPWR decoded_imm_j\[5\] sky130_fd_sc_hd__dfxtp_1
XTAP_1997 VGND VPWR sky130_fd_sc_hd__tapvpwrvgnd_1
X_13513_ _06751_ _06986_ _06990_ _06798_ VGND VGND VPWR VPWR _06991_ sky130_fd_sc_hd__o211a_1
X_14493_ _01609_ VGND VGND VPWR VPWR _01091_ sky130_fd_sc_hd__clkbuf_1
X_10725_ _04919_ VGND VGND VPWR VPWR _00110_ sky130_fd_sc_hd__clkbuf_1
XFILLER_0_137_196 VGND VGND VPWR VPWR sky130_fd_sc_hd__fill_1
X_10656_ _03818_ _04858_ _04862_ _03806_ VGND VGND VPWR VPWR _04863_ sky130_fd_sc_hd__o211a_1
X_13444_ cpuregs\[30\]\[19\] cpuregs\[31\]\[19\] _06754_ VGND VGND VPWR VPWR _06924_
+ sky130_fd_sc_hd__mux2_1
X_16232_ clknet_leaf_16_clk alu_out\[5\] VGND VGND VPWR VPWR alu_out_q\[5\] sky130_fd_sc_hd__dfxtp_1
X_16163_ clknet_leaf_76_clk _00781_ VGND VGND VPWR VPWR net36 sky130_fd_sc_hd__dfxtp_1
X_10587_ _04677_ _04687_ _04792_ _04794_ VGND VGND VPWR VPWR _04795_ sky130_fd_sc_hd__o31a_1
X_13375_ cpuregs\[24\]\[17\] cpuregs\[25\]\[17\] cpuregs\[26\]\[17\] cpuregs\[27\]\[17\]
+ _06856_ _06558_ VGND VGND VPWR VPWR _06857_ sky130_fd_sc_hd__mux4_1
XFILLER_0_50_120 VGND VGND VPWR VPWR sky130_fd_sc_hd__decap_3
X_15114_ _01939_ VGND VGND VPWR VPWR _01414_ sky130_fd_sc_hd__clkbuf_1
XFILLER_0_23_345 VGND VGND VPWR VPWR sky130_fd_sc_hd__fill_1
XFILLER_0_133_391 VGND VGND VPWR VPWR sky130_fd_sc_hd__fill_1
X_12326_ _05924_ _05927_ _05939_ VGND VGND VPWR VPWR _05940_ sky130_fd_sc_hd__a21bo_1
X_16094_ clknet_leaf_141_clk _00744_ VGND VGND VPWR VPWR count_cycle\[37\] sky130_fd_sc_hd__dfxtp_1
XFILLER_0_23_389 VGND VGND VPWR VPWR sky130_fd_sc_hd__decap_3
X_12257_ _05852_ net529 _05816_ _05876_ VGND VGND VPWR VPWR _00685_ sky130_fd_sc_hd__o211a_1
X_15045_ net1439 _05163_ _01901_ VGND VGND VPWR VPWR _01903_ sky130_fd_sc_hd__mux2_1
X_11208_ _05201_ VGND VGND VPWR VPWR _00311_ sky130_fd_sc_hd__clkbuf_1
X_12188_ _05811_ _05812_ decoder_trigger VGND VGND VPWR VPWR _05813_ sky130_fd_sc_hd__o21ai_1
X_11139_ _05155_ VGND VGND VPWR VPWR _00288_ sky130_fd_sc_hd__clkbuf_1
X_15947_ clknet_leaf_146_clk _00597_ VGND VGND VPWR VPWR count_instr\[16\] sky130_fd_sc_hd__dfxtp_1
X_15878_ clknet_leaf_137_clk _00528_ VGND VGND VPWR VPWR cpuregs\[20\]\[12\] sky130_fd_sc_hd__dfxtp_1
X_14829_ _01787_ VGND VGND VPWR VPWR _01281_ sky130_fd_sc_hd__clkbuf_1
XFILLER_0_59_721 VGND VGND VPWR VPWR sky130_fd_sc_hd__fill_1
X_08350_ _02729_ _02730_ VGND VGND VPWR VPWR _02731_ sky130_fd_sc_hd__nand2_1
XFILLER_0_58_253 VGND VGND VPWR VPWR sky130_fd_sc_hd__decap_8
XFILLER_0_128_141 VPWR VGND VPWR VGND sky130_ef_sc_hd__decap_12
X_08281_ net200 net249 VGND VGND VPWR VPWR _02662_ sky130_fd_sc_hd__nand2_1
XFILLER_0_46_459 VGND VGND VPWR VPWR sky130_fd_sc_hd__fill_1
Xclkbuf_leaf_152_clk clknet_4_0_0_clk VGND VGND VPWR VPWR clknet_leaf_152_clk sky130_fd_sc_hd__clkbuf_16
XFILLER_0_18_139 VGND VGND VPWR VPWR sky130_fd_sc_hd__fill_1
XFILLER_0_41_62 VPWR VGND VPWR VGND sky130_ef_sc_hd__decap_12
XFILLER_0_6_589 VGND VGND VPWR VPWR sky130_fd_sc_hd__decap_6
XFILLER_0_14_378 VGND VGND VPWR VPWR sky130_fd_sc_hd__fill_1
X_09804_ _03862_ _04010_ _04033_ VGND VGND VPWR VPWR _04034_ sky130_fd_sc_hd__o21a_1
Xfanout247 net204 VGND VGND VPWR VPWR net247 sky130_fd_sc_hd__clkbuf_4
XFILLER_0_10_584 VGND VGND VPWR VPWR sky130_fd_sc_hd__fill_1
X_07996_ count_instr\[45\] _02269_ _02235_ _02395_ VGND VGND VPWR VPWR _02396_ sky130_fd_sc_hd__a211o_1
XFILLER_0_5_84 VPWR VGND VPWR VGND sky130_ef_sc_hd__decap_12
X_09735_ cpuregs\[4\]\[5\] cpuregs\[5\]\[5\] cpuregs\[6\]\[5\] cpuregs\[7\]\[5\] _03875_
+ _03669_ VGND VGND VPWR VPWR _03966_ sky130_fd_sc_hd__mux4_1
X_09666_ cpuregs\[30\]\[3\] cpuregs\[31\]\[3\] _03898_ VGND VGND VPWR VPWR _03899_
+ sky130_fd_sc_hd__mux2_1
X_08617_ _02846_ VGND VGND VPWR VPWR _02986_ sky130_fd_sc_hd__clkbuf_4
XTAP_1205 VGND VPWR sky130_fd_sc_hd__tapvpwrvgnd_1
XTAP_1238 VGND VPWR sky130_fd_sc_hd__tapvpwrvgnd_1
XTAP_1227 VGND VPWR sky130_fd_sc_hd__tapvpwrvgnd_1
XTAP_1216 VGND VPWR sky130_fd_sc_hd__tapvpwrvgnd_1
X_09597_ _03797_ VGND VGND VPWR VPWR _03831_ sky130_fd_sc_hd__buf_8
XFILLER_0_49_220 VGND VGND VPWR VPWR sky130_fd_sc_hd__decap_4
XFILLER_0_92_510 VGND VGND VPWR VPWR sky130_fd_sc_hd__fill_1
X_08548_ _02850_ VGND VGND VPWR VPWR _02922_ sky130_fd_sc_hd__clkbuf_4
XTAP_1249 VGND VPWR sky130_fd_sc_hd__tapvpwrvgnd_1
XFILLER_0_119_130 VGND VGND VPWR VPWR sky130_fd_sc_hd__fill_2
X_08479_ _02857_ _02858_ _02749_ VGND VGND VPWR VPWR _02859_ sky130_fd_sc_hd__o21a_1
Xclkbuf_leaf_143_clk clknet_4_2_0_clk VGND VGND VPWR VPWR clknet_leaf_143_clk sky130_fd_sc_hd__clkbuf_16
X_10510_ _04720_ VGND VGND VPWR VPWR _00094_ sky130_fd_sc_hd__clkbuf_1
XFILLER_0_119_196 VGND VGND VPWR VPWR sky130_fd_sc_hd__fill_1
X_11490_ _05357_ VGND VGND VPWR VPWR _00437_ sky130_fd_sc_hd__clkbuf_1
X_10441_ cpuregs\[0\]\[24\] cpuregs\[1\]\[24\] cpuregs\[2\]\[24\] cpuregs\[3\]\[24\]
+ _03865_ _03727_ VGND VGND VPWR VPWR _04653_ sky130_fd_sc_hd__mux4_1
XFILLER_0_80_749 VGND VGND VPWR VPWR sky130_fd_sc_hd__decap_4
X_10372_ _03364_ _04585_ VGND VGND VPWR VPWR _04586_ sky130_fd_sc_hd__or2_1
X_13160_ _03325_ VGND VGND VPWR VPWR _06648_ sky130_fd_sc_hd__buf_4
X_12111_ _05737_ reg_pc\[24\] VGND VGND VPWR VPWR _05748_ sky130_fd_sc_hd__or2_1
X_13091_ cpuregs\[0\]\[9\] cpuregs\[1\]\[9\] cpuregs\[2\]\[9\] cpuregs\[3\]\[9\] _06364_
+ _03400_ VGND VGND VPWR VPWR _06581_ sky130_fd_sc_hd__mux4_1
XFILLER_0_130_394 VGND VGND VPWR VPWR sky130_fd_sc_hd__fill_1
X_12042_ _05696_ net1650 _05697_ _05699_ VGND VGND VPWR VPWR _00647_ sky130_fd_sc_hd__o211a_1
Xhold290 cpuregs\[10\]\[3\] VGND VGND VPWR VPWR net648 sky130_fd_sc_hd__dlygate4sd3_1
X_16850_ clknet_leaf_144_clk _01414_ VGND VGND VPWR VPWR cpuregs\[22\]\[1\] sky130_fd_sc_hd__dfxtp_1
X_16781_ clknet_leaf_72_clk _01345_ VGND VGND VPWR VPWR cpuregs\[5\]\[28\] sky130_fd_sc_hd__dfxtp_1
XFILLER_0_99_120 VGND VGND VPWR VPWR sky130_fd_sc_hd__fill_2
X_13993_ mem_rdata_q\[17\] mem_rdata_q\[16\] mem_rdata_q\[15\] mem_rdata_q\[14\] VGND
+ VGND VPWR VPWR _07408_ sky130_fd_sc_hd__or4_1
X_15801_ clknet_leaf_97_clk _00451_ VGND VGND VPWR VPWR cpuregs\[26\]\[31\] sky130_fd_sc_hd__dfxtp_1
X_15732_ clknet_leaf_48_clk _00382_ VGND VGND VPWR VPWR cpuregs\[21\]\[26\] sky130_fd_sc_hd__dfxtp_1
X_12944_ _03321_ _06437_ VGND VGND VPWR VPWR _06438_ sky130_fd_sc_hd__or2_1
XFILLER_0_99_197 VPWR VGND VPWR VGND sky130_ef_sc_hd__decap_12
XFILLER_0_87_337 VGND VGND VPWR VPWR sky130_fd_sc_hd__decap_3
XANTENNA_130 _07519_ VGND VGND VPWR VPWR sky130_fd_sc_hd__diode_2
X_15663_ clknet_leaf_80_clk _00313_ VGND VGND VPWR VPWR cpuregs\[14\]\[21\] sky130_fd_sc_hd__dfxtp_1
XANTENNA_152 net205 VGND VGND VPWR VPWR sky130_fd_sc_hd__diode_2
X_12875_ net34 cpu_state\[2\] VGND VGND VPWR VPWR _06374_ sky130_fd_sc_hd__nand2_4
XANTENNA_141 net99 VGND VGND VPWR VPWR sky130_fd_sc_hd__diode_2
X_14614_ _05033_ net1290 _01670_ VGND VGND VPWR VPWR _01674_ sky130_fd_sc_hd__mux2_1
XTAP_1761 VGND VPWR sky130_fd_sc_hd__tapvpwrvgnd_1
XTAP_1750 VGND VPWR sky130_fd_sc_hd__tapvpwrvgnd_1
XANTENNA_163 net120 VGND VGND VPWR VPWR sky130_fd_sc_hd__diode_2
X_15594_ clknet_leaf_94_clk _00244_ VGND VGND VPWR VPWR cpuregs\[28\]\[16\] sky130_fd_sc_hd__dfxtp_1
X_11826_ count_instr\[7\] _05540_ VGND VGND VPWR VPWR _05543_ sky130_fd_sc_hd__or2_1
XFILLER_0_134_7 VGND VGND VPWR VPWR sky130_fd_sc_hd__fill_1
X_14545_ _01637_ VGND VGND VPWR VPWR _01147_ sky130_fd_sc_hd__clkbuf_1
XTAP_1794 VGND VPWR sky130_fd_sc_hd__tapvpwrvgnd_1
XTAP_1783 VGND VPWR sky130_fd_sc_hd__tapvpwrvgnd_1
XTAP_1772 VGND VPWR sky130_fd_sc_hd__tapvpwrvgnd_1
XFILLER_0_83_521 VGND VGND VPWR VPWR sky130_fd_sc_hd__decap_8
X_11757_ _05499_ VGND VGND VPWR VPWR _00562_ sky130_fd_sc_hd__clkbuf_1
XFILLER_0_56_746 VGND VGND VPWR VPWR sky130_fd_sc_hd__fill_1
Xclkbuf_leaf_134_clk clknet_4_9_0_clk VGND VGND VPWR VPWR clknet_leaf_134_clk sky130_fd_sc_hd__clkbuf_16
XFILLER_0_28_426 VGND VGND VPWR VPWR sky130_fd_sc_hd__decap_8
XFILLER_0_127_6 VGND VGND VPWR VPWR sky130_fd_sc_hd__decap_3
XFILLER_0_125_111 VGND VGND VPWR VPWR sky130_fd_sc_hd__fill_1
XFILLER_0_71_716 VGND VGND VPWR VPWR sky130_fd_sc_hd__decap_3
X_10708_ _04910_ VGND VGND VPWR VPWR _00102_ sky130_fd_sc_hd__clkbuf_1
XFILLER_0_125_133 VGND VGND VPWR VPWR sky130_fd_sc_hd__fill_2
X_16215_ clknet_leaf_44_clk _00832_ VGND VGND VPWR VPWR net221 sky130_fd_sc_hd__dfxtp_4
X_14476_ net592 _05207_ _01598_ VGND VGND VPWR VPWR _01601_ sky130_fd_sc_hd__mux2_1
X_11688_ net825 _05190_ _05458_ VGND VGND VPWR VPWR _05463_ sky130_fd_sc_hd__mux2_1
X_10639_ cpuregs\[2\]\[29\] cpuregs\[3\]\[29\] _03768_ VGND VGND VPWR VPWR _04846_
+ sky130_fd_sc_hd__mux2_1
XFILLER_0_125_188 VGND VGND VPWR VPWR sky130_fd_sc_hd__fill_1
XFILLER_0_102_67 VGND VGND VPWR VPWR sky130_fd_sc_hd__fill_1
X_13427_ cpuregs\[4\]\[19\] cpuregs\[5\]\[19\] _06906_ VGND VGND VPWR VPWR _06907_
+ sky130_fd_sc_hd__mux2_1
XFILLER_0_24_643 VGND VGND VPWR VPWR sky130_fd_sc_hd__fill_1
X_16146_ clknet_leaf_38_clk _07634_ VGND VGND VPWR VPWR reg_out\[24\] sky130_fd_sc_hd__dfxtp_1
X_13358_ cpuregs\[4\]\[17\] cpuregs\[5\]\[17\] _06575_ VGND VGND VPWR VPWR _06840_
+ sky130_fd_sc_hd__mux2_1
XFILLER_0_140_169 VGND VGND VPWR VPWR sky130_fd_sc_hd__fill_2
X_12309_ decoded_imm_j\[15\] _05723_ VGND VGND VPWR VPWR _05924_ sky130_fd_sc_hd__xnor2_2
XFILLER_0_11_337 VGND VGND VPWR VPWR sky130_fd_sc_hd__fill_1
X_16077_ clknet_leaf_150_clk _00727_ VGND VGND VPWR VPWR count_cycle\[20\] sky130_fd_sc_hd__dfxtp_1
X_15028_ _01893_ VGND VGND VPWR VPWR _01374_ sky130_fd_sc_hd__clkbuf_1
X_13289_ _03325_ VGND VGND VPWR VPWR _06773_ sky130_fd_sc_hd__clkbuf_4
X_07850_ net3 net20 _02213_ VGND VGND VPWR VPWR _02260_ sky130_fd_sc_hd__mux2_1
XFILLER_0_127_42 VGND VGND VPWR VPWR sky130_fd_sc_hd__decap_3
X_07781_ net1496 _02193_ _02195_ VGND VGND VPWR VPWR _02196_ sky130_fd_sc_hd__a21oi_1
X_09520_ _03754_ VGND VGND VPWR VPWR _03755_ sky130_fd_sc_hd__buf_6
Xinput3 mem_rdata[11] VGND VGND VPWR VPWR net3 sky130_fd_sc_hd__clkbuf_4
X_09451_ _00016_ VGND VGND VPWR VPWR _03687_ sky130_fd_sc_hd__inv_2
X_09382_ net1114 _03622_ _03578_ VGND VGND VPWR VPWR _03623_ sky130_fd_sc_hd__mux2_1
X_08402_ _02243_ net252 VGND VGND VPWR VPWR _02783_ sky130_fd_sc_hd__and2b_1
XFILLER_0_52_50 VGND VGND VPWR VPWR sky130_fd_sc_hd__fill_2
XFILLER_0_117_601 VGND VGND VPWR VPWR sky130_fd_sc_hd__decap_4
X_08333_ net179 net211 VGND VGND VPWR VPWR _02714_ sky130_fd_sc_hd__or2_1
Xclkbuf_leaf_125_clk clknet_4_8_0_clk VGND VGND VPWR VPWR clknet_leaf_125_clk sky130_fd_sc_hd__clkbuf_16
XFILLER_0_129_494 VGND VGND VPWR VPWR sky130_fd_sc_hd__fill_1
X_08264_ net24 _02466_ _02429_ VGND VGND VPWR VPWR _02647_ sky130_fd_sc_hd__a21oi_1
XFILLER_0_27_481 VGND VGND VPWR VPWR sky130_fd_sc_hd__fill_2
XFILLER_0_34_418 VGND VGND VPWR VPWR sky130_fd_sc_hd__fill_2
XFILLER_0_132_615 VGND VGND VPWR VPWR sky130_fd_sc_hd__decap_4
XFILLER_0_116_188 VGND VGND VPWR VPWR sky130_fd_sc_hd__fill_1
XFILLER_0_116_166 VPWR VGND VPWR VGND sky130_ef_sc_hd__decap_12
XFILLER_0_61_259 VGND VGND VPWR VPWR sky130_fd_sc_hd__decap_3
X_08195_ count_instr\[58\] _02233_ VGND VGND VPWR VPWR _02582_ sky130_fd_sc_hd__and2_1
XFILLER_0_131_125 VGND VGND VPWR VPWR sky130_fd_sc_hd__fill_1
XFILLER_0_131_169 VGND VGND VPWR VPWR sky130_fd_sc_hd__decap_3
X_07979_ _02242_ _02378_ _02380_ _02194_ _02199_ VGND VGND VPWR VPWR _02381_ sky130_fd_sc_hd__a221o_1
X_09718_ _03949_ VGND VGND VPWR VPWR _00073_ sky130_fd_sc_hd__clkbuf_1
X_10990_ _05031_ net716 _05074_ VGND VGND VPWR VPWR _05077_ sky130_fd_sc_hd__mux2_1
XFILLER_0_139_203 VGND VGND VPWR VPWR sky130_fd_sc_hd__decap_3
XTAP_1013 VGND VPWR sky130_fd_sc_hd__tapvpwrvgnd_1
XTAP_1002 VGND VPWR sky130_fd_sc_hd__tapvpwrvgnd_1
X_09649_ cpuregs\[0\]\[3\] cpuregs\[1\]\[3\] _03881_ VGND VGND VPWR VPWR _03882_ sky130_fd_sc_hd__mux2_1
XFILLER_0_84_307 VGND VGND VPWR VPWR sky130_fd_sc_hd__fill_1
XTAP_1046 VGND VPWR sky130_fd_sc_hd__tapvpwrvgnd_1
XTAP_1035 VGND VPWR sky130_fd_sc_hd__tapvpwrvgnd_1
XTAP_1024 VGND VPWR sky130_fd_sc_hd__tapvpwrvgnd_1
X_12660_ count_cycle\[47\] _06207_ VGND VGND VPWR VPWR _06211_ sky130_fd_sc_hd__or2_1
X_11611_ _05410_ VGND VGND VPWR VPWR _05422_ sky130_fd_sc_hd__buf_4
XFILLER_0_77_370 VGND VGND VPWR VPWR sky130_fd_sc_hd__fill_1
XTAP_1079 VGND VPWR sky130_fd_sc_hd__tapvpwrvgnd_1
XTAP_1057 VGND VPWR sky130_fd_sc_hd__tapvpwrvgnd_1
XTAP_1068 VGND VPWR sky130_fd_sc_hd__tapvpwrvgnd_1
XFILLER_0_92_351 VGND VGND VPWR VPWR sky130_fd_sc_hd__fill_1
X_14330_ net1590 _07587_ _07590_ _07597_ VGND VGND VPWR VPWR _01016_ sky130_fd_sc_hd__o22a_1
Xclkbuf_leaf_116_clk clknet_4_10_0_clk VGND VGND VPWR VPWR clknet_leaf_116_clk sky130_fd_sc_hd__clkbuf_16
X_12591_ net453 VGND VGND VPWR VPWR _06162_ sky130_fd_sc_hd__inv_2
XFILLER_0_52_204 VGND VGND VPWR VPWR sky130_fd_sc_hd__fill_1
XFILLER_0_46_790 VGND VGND VPWR VPWR sky130_fd_sc_hd__fill_2
X_11542_ _05385_ VGND VGND VPWR VPWR _00461_ sky130_fd_sc_hd__clkbuf_1
X_14261_ net1462 _06290_ _07555_ _07556_ VGND VGND VPWR VPWR _00988_ sky130_fd_sc_hd__a22o_1
X_11473_ _05348_ VGND VGND VPWR VPWR _00429_ sky130_fd_sc_hd__clkbuf_1
X_10424_ cpuregs\[30\]\[23\] cpuregs\[31\]\[23\] _03835_ VGND VGND VPWR VPWR _04637_
+ sky130_fd_sc_hd__mux2_1
XFILLER_0_61_760 VGND VGND VPWR VPWR sky130_fd_sc_hd__fill_2
X_13212_ cpuregs\[8\]\[13\] cpuregs\[9\]\[13\] _06422_ VGND VGND VPWR VPWR _06698_
+ sky130_fd_sc_hd__mux2_1
X_16000_ clknet_leaf_11_clk _00650_ VGND VGND VPWR VPWR reg_pc\[6\] sky130_fd_sc_hd__dfxtp_2
X_14192_ _07520_ VGND VGND VPWR VPWR _00955_ sky130_fd_sc_hd__clkbuf_1
X_13143_ _00011_ VGND VGND VPWR VPWR _06631_ sky130_fd_sc_hd__clkbuf_4
XFILLER_0_20_101 VGND VGND VPWR VPWR sky130_fd_sc_hd__fill_2
X_10355_ _03837_ _04569_ _03826_ VGND VGND VPWR VPWR _04570_ sky130_fd_sc_hd__a21o_1
XTAP_808 VGND VPWR sky130_fd_sc_hd__tapvpwrvgnd_1
X_10286_ _03696_ _04500_ _04502_ VGND VGND VPWR VPWR _04503_ sky130_fd_sc_hd__a21o_1
X_13074_ _06455_ _06559_ _06564_ _06466_ VGND VGND VPWR VPWR _06565_ sky130_fd_sc_hd__o211a_1
XTAP_819 VGND VPWR sky130_fd_sc_hd__tapvpwrvgnd_1
X_16902_ clknet_leaf_78_clk _01466_ VGND VGND VPWR VPWR cpuregs\[8\]\[21\] sky130_fd_sc_hd__dfxtp_1
X_12025_ net385 _05683_ _05685_ VGND VGND VPWR VPWR _00644_ sky130_fd_sc_hd__a21oi_1
X_16833_ clknet_leaf_87_clk _01397_ VGND VGND VPWR VPWR cpuregs\[7\]\[16\] sky130_fd_sc_hd__dfxtp_1
X_16764_ clknet_leaf_102_clk _01328_ VGND VGND VPWR VPWR cpuregs\[5\]\[11\] sky130_fd_sc_hd__dfxtp_1
X_13976_ instr_xor _07367_ _07338_ _07384_ VGND VGND VPWR VPWR _07397_ sky130_fd_sc_hd__a22o_1
XFILLER_0_76_808 VGND VGND VPWR VPWR sky130_fd_sc_hd__fill_1
X_12927_ _03346_ VGND VGND VPWR VPWR _06421_ sky130_fd_sc_hd__clkbuf_8
X_16695_ clknet_leaf_110_clk _01262_ VGND VGND VPWR VPWR cpuregs\[3\]\[9\] sky130_fd_sc_hd__dfxtp_1
X_15715_ clknet_leaf_133_clk _00365_ VGND VGND VPWR VPWR cpuregs\[21\]\[9\] sky130_fd_sc_hd__dfxtp_1
XTAP_2270 VGND VPWR sky130_fd_sc_hd__tapvpwrvgnd_1
XFILLER_0_87_156 VGND VGND VPWR VPWR sky130_fd_sc_hd__fill_2
X_15646_ clknet_leaf_125_clk _00296_ VGND VGND VPWR VPWR cpuregs\[14\]\[4\] sky130_fd_sc_hd__dfxtp_1
X_12858_ cpuregs\[28\]\[0\] cpuregs\[29\]\[0\] _03312_ VGND VGND VPWR VPWR _06357_
+ sky130_fd_sc_hd__mux2_1
XTAP_2292 VGND VPWR sky130_fd_sc_hd__tapvpwrvgnd_1
XTAP_2281 VGND VPWR sky130_fd_sc_hd__tapvpwrvgnd_1
X_11809_ net34 VGND VGND VPWR VPWR _05530_ sky130_fd_sc_hd__clkbuf_4
XFILLER_0_29_724 VGND VGND VPWR VPWR sky130_fd_sc_hd__fill_1
XTAP_1591 VGND VPWR sky130_fd_sc_hd__tapvpwrvgnd_1
XTAP_1580 VGND VPWR sky130_fd_sc_hd__tapvpwrvgnd_1
XFILLER_0_83_340 VGND VGND VPWR VPWR sky130_fd_sc_hd__decap_8
X_15577_ clknet_leaf_99_clk _00227_ VGND VGND VPWR VPWR cpuregs\[2\]\[31\] sky130_fd_sc_hd__dfxtp_1
Xclkbuf_leaf_107_clk clknet_4_11_0_clk VGND VGND VPWR VPWR clknet_leaf_107_clk sky130_fd_sc_hd__clkbuf_16
X_12789_ net1051 net71 _06302_ VGND VGND VPWR VPWR _06309_ sky130_fd_sc_hd__mux2_1
XFILLER_0_125_3 VGND VGND VPWR VPWR sky130_fd_sc_hd__decap_4
X_14528_ _01628_ VGND VGND VPWR VPWR _01139_ sky130_fd_sc_hd__clkbuf_1
XFILLER_0_28_289 VGND VGND VPWR VPWR sky130_fd_sc_hd__fill_1
XFILLER_0_43_204 VGND VGND VPWR VPWR sky130_fd_sc_hd__fill_2
XFILLER_0_43_215 VGND VGND VPWR VPWR sky130_fd_sc_hd__fill_1
X_14459_ net888 _05190_ _01587_ VGND VGND VPWR VPWR _01592_ sky130_fd_sc_hd__mux2_1
XFILLER_0_4_813 VPWR VGND VPWR VGND sky130_ef_sc_hd__decap_12
XFILLER_0_3_334 VGND VGND VPWR VPWR sky130_fd_sc_hd__fill_2
XFILLER_0_3_312 VGND VGND VPWR VPWR sky130_fd_sc_hd__fill_1
XFILLER_0_12_613 VGND VGND VPWR VPWR sky130_fd_sc_hd__fill_1
X_16129_ clknet_leaf_12_clk _07647_ VGND VGND VPWR VPWR reg_out\[7\] sky130_fd_sc_hd__dfxtp_1
XFILLER_0_51_281 VGND VGND VPWR VPWR sky130_fd_sc_hd__decap_3
Xpicorv32_256 VGND VGND VPWR VPWR picorv32_256/HI eoi[3] sky130_fd_sc_hd__conb_1
XFILLER_0_110_810 VGND VGND VPWR VPWR sky130_fd_sc_hd__fill_2
Xpicorv32_278 VGND VGND VPWR VPWR picorv32_278/HI eoi[25] sky130_fd_sc_hd__conb_1
Xpicorv32_267 VGND VGND VPWR VPWR picorv32_267/HI eoi[14] sky130_fd_sc_hd__conb_1
Xpicorv32_289 VGND VGND VPWR VPWR picorv32_289/HI pcpi_insn[0] sky130_fd_sc_hd__conb_1
X_08951_ _03258_ VGND VGND VPWR VPWR net72 sky130_fd_sc_hd__buf_4
X_07902_ _02241_ VGND VGND VPWR VPWR _02309_ sky130_fd_sc_hd__clkbuf_4
X_08882_ _03216_ VGND VGND VPWR VPWR net107 sky130_fd_sc_hd__clkbuf_4
XFILLER_0_138_85 VPWR VGND VPWR VGND sky130_ef_sc_hd__decap_12
XFILLER_0_138_74 VGND VGND VPWR VPWR sky130_fd_sc_hd__fill_2
X_07833_ reg_pc\[2\] decoded_imm\[2\] VGND VGND VPWR VPWR _02244_ sky130_fd_sc_hd__xor2_1
X_07764_ is_lb_lh_lw_lbu_lhu _02181_ is_sll_srl_sra VGND VGND VPWR VPWR _02182_ sky130_fd_sc_hd__or3b_1
X_09503_ _03661_ VGND VGND VPWR VPWR _03738_ sky130_fd_sc_hd__clkbuf_8
X_07695_ instr_xori instr_addi instr_bltu instr_blt VGND VGND VPWR VPWR _02121_ sky130_fd_sc_hd__or4_1
XFILLER_0_94_605 VGND VGND VPWR VPWR sky130_fd_sc_hd__fill_1
XFILLER_0_63_71 VGND VGND VPWR VPWR sky130_fd_sc_hd__decap_4
XPHY_107 VGND VGND VPWR VPWR sky130_fd_sc_hd__decap_3
X_09434_ _03669_ VGND VGND VPWR VPWR _03670_ sky130_fd_sc_hd__buf_4
XFILLER_0_75_830 VGND VGND VPWR VPWR sky130_fd_sc_hd__fill_2
XFILLER_0_66_329 VGND VGND VPWR VPWR sky130_fd_sc_hd__fill_1
XPHY_129 VGND VGND VPWR VPWR sky130_fd_sc_hd__decap_3
XPHY_118 VGND VGND VPWR VPWR sky130_fd_sc_hd__decap_3
XFILLER_0_19_201 VGND VGND VPWR VPWR sky130_fd_sc_hd__decap_4
X_09365_ _03433_ _03607_ VGND VGND VPWR VPWR _03608_ sky130_fd_sc_hd__nor2_1
XANTENNA_30 _06269_ VGND VGND VPWR VPWR sky130_fd_sc_hd__diode_2
X_08316_ _02686_ _02687_ _02696_ VGND VGND VPWR VPWR _02697_ sky130_fd_sc_hd__a21bo_1
X_09296_ reg_pc\[15\] reg_pc\[14\] _03529_ reg_pc\[16\] VGND VGND VPWR VPWR _03548_
+ sky130_fd_sc_hd__a31o_1
XFILLER_0_74_373 VGND VGND VPWR VPWR sky130_fd_sc_hd__decap_3
XANTENNA_41 net21 VGND VGND VPWR VPWR sky130_fd_sc_hd__diode_2
XFILLER_0_34_204 VGND VGND VPWR VPWR sky130_fd_sc_hd__fill_1
XFILLER_0_35_738 VGND VGND VPWR VPWR sky130_fd_sc_hd__fill_1
X_08247_ _02627_ _02628_ _02629_ _02170_ VGND VGND VPWR VPWR _02631_ sky130_fd_sc_hd__a31o_1
XANTENNA_74 net98 VGND VGND VPWR VPWR sky130_fd_sc_hd__diode_2
XFILLER_0_105_604 VGND VGND VPWR VPWR sky130_fd_sc_hd__decap_4
XANTENNA_52 net56 VGND VGND VPWR VPWR sky130_fd_sc_hd__diode_2
XFILLER_0_7_673 VGND VGND VPWR VPWR sky130_fd_sc_hd__decap_4
XANTENNA_63 net74 VGND VGND VPWR VPWR sky130_fd_sc_hd__diode_2
XANTENNA_96 net132 VGND VGND VPWR VPWR sky130_fd_sc_hd__diode_2
XANTENNA_85 net115 VGND VGND VPWR VPWR sky130_fd_sc_hd__diode_2
X_08178_ net187 VGND VGND VPWR VPWR _02567_ sky130_fd_sc_hd__clkbuf_4
XFILLER_0_104_147 VGND VGND VPWR VPWR sky130_fd_sc_hd__decap_4
XFILLER_0_30_410 VGND VGND VPWR VPWR sky130_fd_sc_hd__fill_2
XFILLER_0_30_443 VGND VGND VPWR VPWR sky130_fd_sc_hd__fill_1
XFILLER_0_112_180 VPWR VGND VPWR VGND sky130_ef_sc_hd__decap_12
X_10140_ _04360_ VGND VGND VPWR VPWR _00084_ sky130_fd_sc_hd__clkbuf_1
Xoutput170 net170 VGND VGND VPWR VPWR mem_wstrb[3] sky130_fd_sc_hd__clkbuf_4
X_10071_ _04293_ VGND VGND VPWR VPWR _00082_ sky130_fd_sc_hd__clkbuf_1
Xoutput181 net181 VGND VGND VPWR VPWR pcpi_rs1[19] sky130_fd_sc_hd__clkbuf_4
Xoutput192 net192 VGND VGND VPWR VPWR pcpi_rs1[29] sky130_fd_sc_hd__clkbuf_4
X_13830_ _07294_ _07295_ _02142_ VGND VGND VPWR VPWR _00839_ sky130_fd_sc_hd__o21a_1
X_13761_ _07230_ VGND VGND VPWR VPWR _00835_ sky130_fd_sc_hd__clkbuf_1
X_10973_ _05014_ net1152 _05063_ VGND VGND VPWR VPWR _05068_ sky130_fd_sc_hd__mux2_1
X_15500_ clknet_leaf_59_clk _00150_ VGND VGND VPWR VPWR cpuregs\[30\]\[18\] sky130_fd_sc_hd__dfxtp_1
X_16480_ clknet_leaf_144_clk _01062_ VGND VGND VPWR VPWR cpuregs\[19\]\[1\] sky130_fd_sc_hd__dfxtp_1
XPHY_9 VGND VGND VPWR VPWR sky130_fd_sc_hd__decap_3
X_12712_ _06247_ _05523_ _06248_ VGND VGND VPWR VPWR _06249_ sky130_fd_sc_hd__and3b_1
X_13692_ cpuregs\[24\]\[27\] cpuregs\[25\]\[27\] cpuregs\[26\]\[27\] cpuregs\[27\]\[27\]
+ _06443_ _06889_ VGND VGND VPWR VPWR _07164_ sky130_fd_sc_hd__mux4_1
XFILLER_0_85_649 VGND VGND VPWR VPWR sky130_fd_sc_hd__fill_1
XFILLER_0_84_137 VGND VGND VPWR VPWR sky130_fd_sc_hd__decap_3
XFILLER_0_84_126 VGND VGND VPWR VPWR sky130_fd_sc_hd__decap_3
X_15431_ clknet_leaf_21_clk _00081_ VGND VGND VPWR VPWR net174 sky130_fd_sc_hd__dfxtp_4
X_12643_ _06197_ _06179_ _06198_ VGND VGND VPWR VPWR _06199_ sky130_fd_sc_hd__and3b_1
XFILLER_0_38_565 VGND VGND VPWR VPWR sky130_fd_sc_hd__fill_2
X_15362_ _02068_ VGND VGND VPWR VPWR _01533_ sky130_fd_sc_hd__clkbuf_1
X_12574_ count_cycle\[20\] count_cycle\[21\] count_cycle\[22\] _06142_ VGND VGND VPWR
+ VPWR _06150_ sky130_fd_sc_hd__and4_2
XFILLER_0_136_784 VGND VGND VPWR VPWR sky130_fd_sc_hd__fill_1
X_15293_ net490 VGND VGND VPWR VPWR _02032_ sky130_fd_sc_hd__clkbuf_1
XFILLER_0_80_332 VGND VGND VPWR VPWR sky130_fd_sc_hd__fill_1
XFILLER_0_53_546 VGND VGND VPWR VPWR sky130_fd_sc_hd__fill_1
X_14313_ _07359_ VGND VGND VPWR VPWR _07587_ sky130_fd_sc_hd__clkbuf_4
X_11525_ _04987_ net1347 _05375_ VGND VGND VPWR VPWR _05377_ sky130_fd_sc_hd__mux2_1
XFILLER_0_4_109 VGND VGND VPWR VPWR sky130_fd_sc_hd__fill_1
X_14244_ _07547_ VGND VGND VPWR VPWR _00980_ sky130_fd_sc_hd__clkbuf_1
X_11456_ net1591 _05163_ _05338_ VGND VGND VPWR VPWR _05340_ sky130_fd_sc_hd__mux2_1
XFILLER_0_1_816 VGND VGND VPWR VPWR sky130_fd_sc_hd__fill_2
XFILLER_0_33_281 VGND VGND VPWR VPWR sky130_fd_sc_hd__decap_8
X_14175_ net506 _07506_ _06293_ VGND VGND VPWR VPWR _07507_ sky130_fd_sc_hd__mux2_1
X_10407_ _04045_ _04619_ _04121_ VGND VGND VPWR VPWR _04620_ sky130_fd_sc_hd__a21o_1
X_11387_ _05303_ VGND VGND VPWR VPWR _00388_ sky130_fd_sc_hd__clkbuf_1
XFILLER_0_0_337 VGND VGND VPWR VPWR sky130_fd_sc_hd__fill_2
X_10338_ _04116_ _04548_ _04552_ _04063_ VGND VGND VPWR VPWR _04553_ sky130_fd_sc_hd__o211a_1
XFILLER_0_110_139 VGND VGND VPWR VPWR sky130_fd_sc_hd__fill_1
X_13126_ cpuregs\[16\]\[10\] cpuregs\[17\]\[10\] cpuregs\[18\]\[10\] cpuregs\[19\]\[10\]
+ _06614_ _06444_ VGND VGND VPWR VPWR _06615_ sky130_fd_sc_hd__mux4_1
XTAP_605 VGND VPWR sky130_fd_sc_hd__tapvpwrvgnd_1
XTAP_616 VGND VPWR sky130_fd_sc_hd__tapvpwrvgnd_1
XTAP_627 VGND VPWR sky130_fd_sc_hd__tapvpwrvgnd_1
XTAP_638 VGND VPWR sky130_fd_sc_hd__tapvpwrvgnd_1
XTAP_649 VGND VPWR sky130_fd_sc_hd__tapvpwrvgnd_1
X_13057_ cpuregs\[0\]\[8\] cpuregs\[1\]\[8\] cpuregs\[2\]\[8\] cpuregs\[3\]\[8\] _06364_
+ _03400_ VGND VGND VPWR VPWR _06548_ sky130_fd_sc_hd__mux4_1
XFILLER_0_108_11 VGND VGND VPWR VPWR sky130_fd_sc_hd__decap_4
X_10269_ cpuregs\[4\]\[19\] cpuregs\[5\]\[19\] cpuregs\[6\]\[19\] cpuregs\[7\]\[19\]
+ _04192_ _04200_ VGND VGND VPWR VPWR _04486_ sky130_fd_sc_hd__mux4_1
X_12008_ count_instr\[58\] count_instr\[57\] _05671_ VGND VGND VPWR VPWR _05674_ sky130_fd_sc_hd__and3_1
X_16816_ clknet_leaf_99_clk _01380_ VGND VGND VPWR VPWR cpuregs\[6\]\[31\] sky130_fd_sc_hd__dfxtp_1
X_16747_ clknet_leaf_74_clk _01311_ VGND VGND VPWR VPWR cpuregs\[4\]\[26\] sky130_fd_sc_hd__dfxtp_1
XFILLER_0_16_9 VGND VGND VPWR VPWR sky130_fd_sc_hd__decap_3
X_13959_ instr_add _07367_ _07328_ _07384_ VGND VGND VPWR VPWR _07385_ sky130_fd_sc_hd__a22o_1
XFILLER_0_88_487 VGND VGND VPWR VPWR sky130_fd_sc_hd__fill_1
X_16678_ clknet_leaf_60_clk _01245_ VGND VGND VPWR VPWR cpuregs\[29\]\[24\] sky130_fd_sc_hd__dfxtp_1
XFILLER_0_119_729 VGND VGND VPWR VPWR sky130_fd_sc_hd__decap_4
X_15629_ clknet_leaf_93_clk _00279_ VGND VGND VPWR VPWR cpuregs\[31\]\[19\] sky130_fd_sc_hd__dfxtp_1
X_09150_ _03424_ VGND VGND VPWR VPWR _00028_ sky130_fd_sc_hd__clkbuf_1
XFILLER_0_16_215 VGND VGND VPWR VPWR sky130_fd_sc_hd__fill_1
X_08101_ _02490_ _02491_ _02494_ _02200_ VGND VGND VPWR VPWR _02495_ sky130_fd_sc_hd__a211o_1
XFILLER_0_99_6 VGND VGND VPWR VPWR sky130_fd_sc_hd__fill_2
X_09081_ _03361_ decoded_imm_j\[2\] is_slli_srli_srai VGND VGND VPWR VPWR _03362_
+ sky130_fd_sc_hd__mux2_1
XFILLER_0_114_412 VGND VGND VPWR VPWR sky130_fd_sc_hd__decap_8
X_08032_ _02134_ _02133_ net25 net7 _02210_ VGND VGND VPWR VPWR _02430_ sky130_fd_sc_hd__a32o_1
Xhold812 cpuregs\[15\]\[29\] VGND VGND VPWR VPWR net1170 sky130_fd_sc_hd__dlygate4sd3_1
Xhold801 cpuregs\[2\]\[26\] VGND VGND VPWR VPWR net1159 sky130_fd_sc_hd__dlygate4sd3_1
Xhold834 cpuregs\[7\]\[29\] VGND VGND VPWR VPWR net1192 sky130_fd_sc_hd__dlygate4sd3_1
Xhold823 cpuregs\[7\]\[16\] VGND VGND VPWR VPWR net1181 sky130_fd_sc_hd__dlygate4sd3_1
Xhold845 cpuregs\[25\]\[3\] VGND VGND VPWR VPWR net1203 sky130_fd_sc_hd__dlygate4sd3_1
Xhold867 cpuregs\[11\]\[28\] VGND VGND VPWR VPWR net1225 sky130_fd_sc_hd__dlygate4sd3_1
Xhold856 cpuregs\[16\]\[30\] VGND VGND VPWR VPWR net1214 sky130_fd_sc_hd__dlygate4sd3_1
Xhold889 cpuregs\[2\]\[16\] VGND VGND VPWR VPWR net1247 sky130_fd_sc_hd__dlygate4sd3_1
X_09983_ cpuregs\[16\]\[11\] cpuregs\[17\]\[11\] cpuregs\[18\]\[11\] cpuregs\[19\]\[11\]
+ _04192_ _03719_ VGND VGND VPWR VPWR _04208_ sky130_fd_sc_hd__mux4_1
Xhold878 cpuregs\[2\]\[5\] VGND VGND VPWR VPWR net1236 sky130_fd_sc_hd__dlygate4sd3_1
X_08934_ _02378_ _03245_ _03246_ VGND VGND VPWR VPWR _03247_ sky130_fd_sc_hd__mux2_1
X_08865_ _02143_ _02753_ net205 _02187_ VGND VGND VPWR VPWR _03208_ sky130_fd_sc_hd__a22o_1
X_08796_ _03150_ _03138_ _03130_ VGND VGND VPWR VPWR _03151_ sky130_fd_sc_hd__o21a_1
XFILLER_0_98_229 VGND VGND VPWR VPWR sky130_fd_sc_hd__decap_8
XFILLER_0_98_218 VGND VGND VPWR VPWR sky130_fd_sc_hd__fill_1
X_07816_ reg_pc\[1\] decoded_imm\[1\] VGND VGND VPWR VPWR _02228_ sky130_fd_sc_hd__nand2_1
X_07747_ _02109_ _02166_ VGND VGND VPWR VPWR _02167_ sky130_fd_sc_hd__and2_1
XFILLER_0_67_649 VGND VGND VPWR VPWR sky130_fd_sc_hd__fill_1
X_07678_ cpu_state\[1\] VGND VGND VPWR VPWR _02108_ sky130_fd_sc_hd__inv_2
X_09417_ _02156_ VGND VGND VPWR VPWR _03653_ sky130_fd_sc_hd__clkbuf_4
X_09348_ reg_pc\[23\] _03588_ VGND VGND VPWR VPWR _03593_ sky130_fd_sc_hd__and2_1
X_11310_ _05261_ VGND VGND VPWR VPWR _00353_ sky130_fd_sc_hd__clkbuf_1
XFILLER_0_62_365 VGND VGND VPWR VPWR sky130_fd_sc_hd__decap_4
X_09279_ _03533_ VGND VGND VPWR VPWR _00050_ sky130_fd_sc_hd__clkbuf_1
X_12290_ _05900_ _05904_ _05906_ VGND VGND VPWR VPWR _05907_ sky130_fd_sc_hd__or3b_1
XFILLER_0_15_281 VGND VGND VPWR VPWR sky130_fd_sc_hd__fill_1
XFILLER_0_16_793 VPWR VGND VPWR VGND sky130_ef_sc_hd__decap_12
XFILLER_0_132_275 VGND VGND VPWR VPWR sky130_fd_sc_hd__fill_1
X_11241_ net593 _05223_ _05160_ VGND VGND VPWR VPWR _05224_ sky130_fd_sc_hd__mux2_1
X_11172_ _03497_ VGND VGND VPWR VPWR _05177_ sky130_fd_sc_hd__clkbuf_4
XFILLER_0_31_785 VGND VGND VPWR VPWR sky130_fd_sc_hd__fill_1
X_10123_ cpuregs\[16\]\[15\] cpuregs\[17\]\[15\] cpuregs\[18\]\[15\] cpuregs\[19\]\[15\]
+ _03819_ _03799_ VGND VGND VPWR VPWR _04344_ sky130_fd_sc_hd__mux4_1
X_15980_ clknet_leaf_151_clk _00630_ VGND VGND VPWR VPWR count_instr\[49\] sky130_fd_sc_hd__dfxtp_1
X_10054_ cpuregs\[16\]\[13\] cpuregs\[17\]\[13\] cpuregs\[18\]\[13\] cpuregs\[19\]\[13\]
+ _03819_ _03799_ VGND VGND VPWR VPWR _04277_ sky130_fd_sc_hd__mux4_1
X_14931_ _01842_ VGND VGND VPWR VPWR _01328_ sky130_fd_sc_hd__clkbuf_1
XFILLER_0_54_29 VPWR VGND VPWR VGND sky130_ef_sc_hd__decap_12
X_14862_ _03519_ net1636 _01804_ VGND VGND VPWR VPWR _01806_ sky130_fd_sc_hd__mux2_1
X_13813_ cpuregs\[28\]\[31\] cpuregs\[29\]\[31\] _07018_ VGND VGND VPWR VPWR _07281_
+ sky130_fd_sc_hd__mux2_1
X_16601_ clknet_leaf_103_clk _01168_ VGND VGND VPWR VPWR cpuregs\[9\]\[11\] sky130_fd_sc_hd__dfxtp_1
XFILLER_0_97_240 VGND VGND VPWR VPWR sky130_fd_sc_hd__decap_8
X_16532_ clknet_leaf_27_clk _01109_ VGND VGND VPWR VPWR mem_rdata_q\[16\] sky130_fd_sc_hd__dfxtp_1
X_14793_ net1265 _05184_ _01767_ VGND VGND VPWR VPWR _01769_ sky130_fd_sc_hd__mux2_1
X_13744_ _06969_ _07209_ _07211_ _03309_ _07213_ VGND VGND VPWR VPWR _07214_ sky130_fd_sc_hd__o311a_1
X_10956_ _04997_ net696 _05052_ VGND VGND VPWR VPWR _05059_ sky130_fd_sc_hd__mux2_1
X_13675_ _03340_ _07146_ _06998_ VGND VGND VPWR VPWR _07147_ sky130_fd_sc_hd__a21o_1
XFILLER_0_85_446 VGND VGND VPWR VPWR sky130_fd_sc_hd__fill_2
X_16463_ clknet_leaf_19_clk _01045_ VGND VGND VPWR VPWR cpuregs\[18\]\[16\] sky130_fd_sc_hd__dfxtp_1
X_10887_ _03537_ VGND VGND VPWR VPWR _05014_ sky130_fd_sc_hd__clkbuf_4
X_16394_ clknet_leaf_67_clk _00976_ VGND VGND VPWR VPWR net148 sky130_fd_sc_hd__dfxtp_1
X_15414_ clknet_leaf_17_clk _00027_ VGND VGND VPWR VPWR _00007_ sky130_fd_sc_hd__dfxtp_2
X_12626_ net474 _06183_ _05533_ VGND VGND VPWR VPWR _06187_ sky130_fd_sc_hd__o21ai_1
X_15345_ _02059_ VGND VGND VPWR VPWR _01525_ sky130_fd_sc_hd__clkbuf_1
X_12557_ count_cycle\[17\] net379 _05640_ VGND VGND VPWR VPWR _06138_ sky130_fd_sc_hd__a21oi_1
Xhold108 cpuregs\[0\]\[28\] VGND VGND VPWR VPWR net466 sky130_fd_sc_hd__dlygate4sd3_1
X_12488_ _06086_ _06087_ VGND VGND VPWR VPWR _06088_ sky130_fd_sc_hd__and2b_1
X_11508_ net1588 _05215_ _05360_ VGND VGND VPWR VPWR _05367_ sky130_fd_sc_hd__mux2_1
X_15276_ _02023_ VGND VGND VPWR VPWR _01492_ sky130_fd_sc_hd__clkbuf_1
Xhold119 reg_next_pc\[28\] VGND VGND VPWR VPWR net477 sky130_fd_sc_hd__dlygate4sd3_1
X_11439_ _05330_ VGND VGND VPWR VPWR _00413_ sky130_fd_sc_hd__clkbuf_1
X_14227_ _07538_ VGND VGND VPWR VPWR _00972_ sky130_fd_sc_hd__clkbuf_1
X_14158_ _07499_ VGND VGND VPWR VPWR _00942_ sky130_fd_sc_hd__clkbuf_1
XTAP_424 VGND VPWR sky130_fd_sc_hd__tapvpwrvgnd_1
XTAP_413 VGND VPWR sky130_fd_sc_hd__tapvpwrvgnd_1
XTAP_402 VGND VPWR sky130_fd_sc_hd__tapvpwrvgnd_1
X_13109_ _06598_ net248 _06375_ VGND VGND VPWR VPWR _06599_ sky130_fd_sc_hd__mux2_1
XTAP_446 VGND VPWR sky130_fd_sc_hd__tapvpwrvgnd_1
XTAP_435 VGND VPWR sky130_fd_sc_hd__tapvpwrvgnd_1
XFILLER_0_0_189 VGND VGND VPWR VPWR sky130_fd_sc_hd__fill_1
XTAP_457 VGND VPWR sky130_fd_sc_hd__tapvpwrvgnd_1
X_14089_ _07309_ _01096_ _01095_ VGND VGND VPWR VPWR _07462_ sky130_fd_sc_hd__nor3_1
XTAP_468 VGND VPWR sky130_fd_sc_hd__tapvpwrvgnd_1
XTAP_479 VGND VPWR sky130_fd_sc_hd__tapvpwrvgnd_1
X_08650_ net177 _03014_ VGND VGND VPWR VPWR _03016_ sky130_fd_sc_hd__or2b_1
XFILLER_0_135_42 VPWR VGND VPWR VGND sky130_ef_sc_hd__decap_12
XFILLER_0_89_763 VGND VGND VPWR VPWR sky130_fd_sc_hd__decap_4
X_08581_ _02366_ net247 _02942_ _02841_ VGND VGND VPWR VPWR _02952_ sky130_fd_sc_hd__a31o_1
XFILLER_0_119_559 VGND VGND VPWR VPWR sky130_fd_sc_hd__fill_1
X_09202_ reg_out\[4\] alu_out_q\[4\] latched_stalu VGND VGND VPWR VPWR _03466_ sky130_fd_sc_hd__mux2_1
XFILLER_0_57_682 VGND VGND VPWR VPWR sky130_fd_sc_hd__fill_2
XFILLER_0_9_757 VGND VGND VPWR VPWR sky130_fd_sc_hd__decap_3
XFILLER_0_106_209 VGND VGND VPWR VPWR sky130_fd_sc_hd__fill_1
XFILLER_0_91_449 VGND VGND VPWR VPWR sky130_fd_sc_hd__decap_3
XFILLER_0_72_641 VGND VGND VPWR VPWR sky130_fd_sc_hd__decap_3
XFILLER_0_56_170 VGND VGND VPWR VPWR sky130_fd_sc_hd__fill_2
X_09133_ cpuregs\[20\]\[4\] cpuregs\[21\]\[4\] cpuregs\[22\]\[4\] cpuregs\[23\]\[4\]
+ _03313_ _03314_ VGND VGND VPWR VPWR _03412_ sky130_fd_sc_hd__mux4_1
XFILLER_0_127_570 VGND VGND VPWR VPWR sky130_fd_sc_hd__fill_1
XFILLER_0_114_253 VGND VGND VPWR VPWR sky130_fd_sc_hd__decap_8
XFILLER_0_114_242 VGND VGND VPWR VPWR sky130_fd_sc_hd__decap_8
X_09064_ _00008_ VGND VGND VPWR VPWR _03345_ sky130_fd_sc_hd__inv_4
XFILLER_0_114_275 VGND VGND VPWR VPWR sky130_fd_sc_hd__decap_8
X_08015_ _02224_ _02187_ net24 _02210_ net6 VGND VGND VPWR VPWR _02414_ sky130_fd_sc_hd__a32o_1
Xhold620 cpuregs\[24\]\[6\] VGND VGND VPWR VPWR net978 sky130_fd_sc_hd__dlygate4sd3_1
Xhold642 cpuregs\[4\]\[23\] VGND VGND VPWR VPWR net1000 sky130_fd_sc_hd__dlygate4sd3_1
Xhold653 cpuregs\[17\]\[28\] VGND VGND VPWR VPWR net1011 sky130_fd_sc_hd__dlygate4sd3_1
XFILLER_0_130_757 VGND VGND VPWR VPWR sky130_fd_sc_hd__fill_1
Xhold631 cpuregs\[25\]\[30\] VGND VGND VPWR VPWR net989 sky130_fd_sc_hd__dlygate4sd3_1
XFILLER_0_69_70 VGND VGND VPWR VPWR sky130_fd_sc_hd__fill_2
XFILLER_0_13_785 VPWR VGND VPWR VGND sky130_ef_sc_hd__decap_12
XFILLER_0_40_582 VGND VGND VPWR VPWR sky130_fd_sc_hd__decap_6
Xhold686 cpuregs\[31\]\[22\] VGND VGND VPWR VPWR net1044 sky130_fd_sc_hd__dlygate4sd3_1
Xhold675 cpuregs\[27\]\[30\] VGND VGND VPWR VPWR net1033 sky130_fd_sc_hd__dlygate4sd3_1
Xhold697 cpuregs\[1\]\[14\] VGND VGND VPWR VPWR net1055 sky130_fd_sc_hd__dlygate4sd3_1
Xhold664 cpuregs\[17\]\[11\] VGND VGND VPWR VPWR net1022 sky130_fd_sc_hd__dlygate4sd3_1
X_09966_ _02325_ _02366_ _02426_ _02391_ _03365_ _03652_ VGND VGND VPWR VPWR _04191_
+ sky130_fd_sc_hd__mux4_1
XFILLER_0_0_690 VGND VGND VPWR VPWR sky130_fd_sc_hd__fill_2
X_08917_ reg_out\[6\] reg_next_pc\[6\] _03225_ VGND VGND VPWR VPWR _03235_ sky130_fd_sc_hd__mux2_1
X_09897_ _04116_ _04117_ _04123_ _04063_ VGND VGND VPWR VPWR _04124_ sky130_fd_sc_hd__o211a_1
XTAP_980 VGND VPWR sky130_fd_sc_hd__tapvpwrvgnd_1
X_08848_ _03191_ _03194_ _03190_ VGND VGND VPWR VPWR _03198_ sky130_fd_sc_hd__o21bai_1
XFILLER_0_99_505 VGND VGND VPWR VPWR sky130_fd_sc_hd__fill_2
Xclkbuf_leaf_96_clk clknet_4_12_0_clk VGND VGND VPWR VPWR clknet_leaf_96_clk sky130_fd_sc_hd__clkbuf_16
XTAP_991 VGND VPWR sky130_fd_sc_hd__tapvpwrvgnd_1
X_08779_ _02578_ net220 _02915_ _03031_ VGND VGND VPWR VPWR _03135_ sky130_fd_sc_hd__a31o_1
XFILLER_0_138_802 VGND VGND VPWR VPWR sky130_fd_sc_hd__decap_8
X_11790_ _05516_ VGND VGND VPWR VPWR _00578_ sky130_fd_sc_hd__clkbuf_1
XFILLER_0_79_273 VGND VGND VPWR VPWR sky130_fd_sc_hd__fill_1
X_10810_ _04965_ VGND VGND VPWR VPWR _00149_ sky130_fd_sc_hd__clkbuf_1
XFILLER_0_138_813 VGND VGND VPWR VPWR sky130_fd_sc_hd__decap_6
X_10741_ _04927_ VGND VGND VPWR VPWR _00118_ sky130_fd_sc_hd__clkbuf_1
XFILLER_0_39_159 VGND VGND VPWR VPWR sky130_fd_sc_hd__decap_8
X_13460_ cpuregs\[6\]\[20\] cpuregs\[7\]\[20\] _06842_ VGND VGND VPWR VPWR _06939_
+ sky130_fd_sc_hd__mux2_1
X_12411_ _05997_ _06003_ _06017_ VGND VGND VPWR VPWR _06018_ sky130_fd_sc_hd__a21o_1
X_10672_ cpuregs\[8\]\[30\] cpuregs\[9\]\[30\] cpuregs\[10\]\[30\] cpuregs\[11\]\[30\]
+ _03876_ _03727_ VGND VGND VPWR VPWR _04878_ sky130_fd_sc_hd__mux4_1
X_13391_ _06868_ _06869_ _06871_ VGND VGND VPWR VPWR _06872_ sky130_fd_sc_hd__a21o_1
Xclkbuf_leaf_20_clk clknet_4_6_0_clk VGND VGND VPWR VPWR clknet_leaf_20_clk sky130_fd_sc_hd__clkbuf_16
X_12342_ _05726_ VGND VGND VPWR VPWR _05955_ sky130_fd_sc_hd__inv_2
XFILLER_0_50_324 VGND VGND VPWR VPWR sky130_fd_sc_hd__fill_1
X_15130_ _01947_ VGND VGND VPWR VPWR _01422_ sky130_fd_sc_hd__clkbuf_1
X_12273_ _05878_ _05881_ _05889_ VGND VGND VPWR VPWR _05891_ sky130_fd_sc_hd__o21ai_1
XFILLER_0_62_195 VGND VGND VPWR VPWR sky130_fd_sc_hd__fill_1
XFILLER_0_50_368 VGND VGND VPWR VPWR sky130_fd_sc_hd__fill_1
X_15061_ net763 _05179_ _01901_ VGND VGND VPWR VPWR _01911_ sky130_fd_sc_hd__mux2_1
XFILLER_0_120_223 VGND VGND VPWR VPWR sky130_fd_sc_hd__fill_1
X_11224_ _05212_ VGND VGND VPWR VPWR _00316_ sky130_fd_sc_hd__clkbuf_1
X_14012_ _03291_ VGND VGND VPWR VPWR _07422_ sky130_fd_sc_hd__buf_4
X_11155_ net1006 _05165_ _05161_ VGND VGND VPWR VPWR _05166_ sky130_fd_sc_hd__mux2_1
X_10106_ _04325_ _04326_ VGND VGND VPWR VPWR _04327_ sky130_fd_sc_hd__or2b_1
X_15963_ clknet_leaf_150_clk _00613_ VGND VGND VPWR VPWR count_instr\[32\] sky130_fd_sc_hd__dfxtp_1
X_11086_ net1220 _03464_ _05124_ VGND VGND VPWR VPWR _05128_ sky130_fd_sc_hd__mux2_1
X_10037_ _04257_ _04259_ VGND VGND VPWR VPWR _04260_ sky130_fd_sc_hd__nand2_1
Xclkbuf_leaf_87_clk clknet_4_14_0_clk VGND VGND VPWR VPWR clknet_leaf_87_clk sky130_fd_sc_hd__clkbuf_16
X_14914_ _01833_ VGND VGND VPWR VPWR _01320_ sky130_fd_sc_hd__clkbuf_1
X_15894_ clknet_leaf_66_clk _00544_ VGND VGND VPWR VPWR cpuregs\[20\]\[28\] sky130_fd_sc_hd__dfxtp_1
X_14845_ _03464_ net1327 _01793_ VGND VGND VPWR VPWR _01797_ sky130_fd_sc_hd__mux2_1
X_11988_ count_instr\[52\] count_instr\[51\] _05654_ VGND VGND VPWR VPWR _05660_ sky130_fd_sc_hd__and3_1
X_14776_ net782 _05167_ _01756_ VGND VGND VPWR VPWR _01760_ sky130_fd_sc_hd__mux2_1
X_13727_ _06442_ _07193_ _07197_ _06428_ VGND VGND VPWR VPWR _07198_ sky130_fd_sc_hd__o211a_1
XFILLER_0_85_243 VGND VGND VPWR VPWR sky130_fd_sc_hd__decap_8
X_16515_ clknet_leaf_19_clk _00036_ VGND VGND VPWR VPWR _00016_ sky130_fd_sc_hd__dfxtp_4
X_10939_ _03645_ VGND VGND VPWR VPWR _05049_ sky130_fd_sc_hd__buf_2
XFILLER_0_14_76 VGND VGND VPWR VPWR sky130_fd_sc_hd__fill_1
X_13658_ cpuregs\[20\]\[26\] cpuregs\[21\]\[26\] _06456_ VGND VGND VPWR VPWR _07131_
+ sky130_fd_sc_hd__mux2_1
XFILLER_0_116_518 VGND VGND VPWR VPWR sky130_fd_sc_hd__decap_3
XFILLER_0_54_641 VGND VGND VPWR VPWR sky130_fd_sc_hd__decap_3
X_16446_ clknet_leaf_14_clk _01028_ VGND VGND VPWR VPWR decoded_imm\[1\] sky130_fd_sc_hd__dfxtp_2
X_13589_ _06383_ cpuregs\[4\]\[24\] VGND VGND VPWR VPWR _07064_ sky130_fd_sc_hd__nor2_1
Xclkbuf_leaf_11_clk clknet_4_1_0_clk VGND VGND VPWR VPWR clknet_leaf_11_clk sky130_fd_sc_hd__clkbuf_16
XFILLER_0_6_738 VGND VGND VPWR VPWR sky130_fd_sc_hd__decap_3
XFILLER_0_5_215 VGND VGND VPWR VPWR sky130_fd_sc_hd__decap_8
X_16377_ clknet_leaf_151_clk _00959_ VGND VGND VPWR VPWR net161 sky130_fd_sc_hd__dfxtp_1
X_12609_ net1183 _06171_ _06174_ VGND VGND VPWR VPWR _00739_ sky130_fd_sc_hd__o21a_1
XFILLER_0_26_354 VGND VGND VPWR VPWR sky130_fd_sc_hd__fill_1
XFILLER_0_38_192 VGND VGND VPWR VPWR sky130_fd_sc_hd__fill_1
XFILLER_0_54_685 VGND VGND VPWR VPWR sky130_fd_sc_hd__decap_4
X_15328_ _02050_ VGND VGND VPWR VPWR _01517_ sky130_fd_sc_hd__clkbuf_1
X_15259_ net479 VGND VGND VPWR VPWR _02015_ sky130_fd_sc_hd__clkbuf_1
XFILLER_0_111_256 VGND VGND VPWR VPWR sky130_fd_sc_hd__fill_1
X_09820_ _03796_ _04043_ _04048_ _03658_ VGND VGND VPWR VPWR _04049_ sky130_fd_sc_hd__o211a_1
X_09751_ _03979_ _03981_ _03796_ VGND VGND VPWR VPWR _03982_ sky130_fd_sc_hd__a21o_1
XFILLER_0_39_95 VGND VGND VPWR VPWR sky130_fd_sc_hd__fill_1
X_08702_ net213 net246 net211 net210 VGND VGND VPWR VPWR _03063_ sky130_fd_sc_hd__or4_1
Xclkbuf_leaf_78_clk clknet_4_15_0_clk VGND VGND VPWR VPWR clknet_leaf_78_clk sky130_fd_sc_hd__clkbuf_16
XTAP_287 VGND VPWR sky130_fd_sc_hd__tapvpwrvgnd_1
XTAP_298 VGND VPWR sky130_fd_sc_hd__tapvpwrvgnd_1
X_09682_ _03911_ _03912_ _03913_ VGND VGND VPWR VPWR _03914_ sky130_fd_sc_hd__a21o_1
X_08633_ _02688_ _02999_ VGND VGND VPWR VPWR _03000_ sky130_fd_sc_hd__xnor2_1
X_08564_ _02671_ _02936_ VGND VGND VPWR VPWR _02937_ sky130_fd_sc_hd__xor2_1
XTAP_1409 VGND VPWR sky130_fd_sc_hd__tapvpwrvgnd_1
XFILLER_0_138_109 VPWR VGND VPWR VGND sky130_ef_sc_hd__decap_12
XFILLER_0_76_243 VGND VGND VPWR VPWR sky130_fd_sc_hd__fill_2
XFILLER_0_49_435 VGND VGND VPWR VPWR sky130_fd_sc_hd__decap_8
XFILLER_0_77_777 VGND VGND VPWR VPWR sky130_fd_sc_hd__fill_1
X_08495_ net196 _02872_ VGND VGND VPWR VPWR _02873_ sky130_fd_sc_hd__and2_1
XFILLER_0_29_192 VGND VGND VPWR VPWR sky130_fd_sc_hd__decap_6
XFILLER_0_72_471 VGND VGND VPWR VPWR sky130_fd_sc_hd__decap_4
X_09116_ reg_sh\[3\] reg_sh\[2\] net1649 VGND VGND VPWR VPWR _03395_ sky130_fd_sc_hd__o21a_1
X_09047_ _03310_ VGND VGND VPWR VPWR _03328_ sky130_fd_sc_hd__clkbuf_8
XFILLER_0_102_234 VGND VGND VPWR VPWR sky130_fd_sc_hd__decap_8
XFILLER_0_20_519 VGND VGND VPWR VPWR sky130_fd_sc_hd__fill_1
Xhold461 cpuregs\[26\]\[15\] VGND VGND VPWR VPWR net819 sky130_fd_sc_hd__dlygate4sd3_1
Xhold450 cpuregs\[14\]\[31\] VGND VGND VPWR VPWR net808 sky130_fd_sc_hd__dlygate4sd3_1
Xhold472 cpuregs\[19\]\[4\] VGND VGND VPWR VPWR net830 sky130_fd_sc_hd__dlygate4sd3_1
Xhold483 cpuregs\[15\]\[22\] VGND VGND VPWR VPWR net841 sky130_fd_sc_hd__dlygate4sd3_1
Xhold494 cpuregs\[30\]\[17\] VGND VGND VPWR VPWR net852 sky130_fd_sc_hd__dlygate4sd3_1
X_09949_ _03677_ _04170_ _04174_ _03660_ VGND VGND VPWR VPWR _04175_ sky130_fd_sc_hd__o211a_1
Xclkbuf_leaf_69_clk clknet_4_13_0_clk VGND VGND VPWR VPWR clknet_leaf_69_clk sky130_fd_sc_hd__clkbuf_16
Xhold1150 cpuregs\[21\]\[27\] VGND VGND VPWR VPWR net1508 sky130_fd_sc_hd__dlygate4sd3_1
XFILLER_0_99_346 VGND VGND VPWR VPWR sky130_fd_sc_hd__fill_2
X_12960_ _06447_ _06449_ _06452_ _06453_ VGND VGND VPWR VPWR _06454_ sky130_fd_sc_hd__a211o_1
Xhold1183 cpuregs\[24\]\[26\] VGND VGND VPWR VPWR net1541 sky130_fd_sc_hd__dlygate4sd3_1
Xhold1194 cpuregs\[29\]\[19\] VGND VGND VPWR VPWR net1552 sky130_fd_sc_hd__dlygate4sd3_1
Xhold1172 cpuregs\[18\]\[6\] VGND VGND VPWR VPWR net1530 sky130_fd_sc_hd__dlygate4sd3_1
Xhold1161 cpuregs\[8\]\[1\] VGND VGND VPWR VPWR net1519 sky130_fd_sc_hd__dlygate4sd3_1
X_11911_ _05604_ VGND VGND VPWR VPWR _00611_ sky130_fd_sc_hd__clkbuf_1
X_12891_ _03328_ _06388_ _03335_ VGND VGND VPWR VPWR _06389_ sky130_fd_sc_hd__o21a_1
XTAP_1910 VGND VPWR sky130_fd_sc_hd__tapvpwrvgnd_1
X_14630_ _05049_ net1421 _01647_ VGND VGND VPWR VPWR _01682_ sky130_fd_sc_hd__mux2_1
X_11842_ _05554_ VGND VGND VPWR VPWR _00592_ sky130_fd_sc_hd__clkbuf_1
XTAP_1932 VGND VPWR sky130_fd_sc_hd__tapvpwrvgnd_1
XTAP_1943 VGND VPWR sky130_fd_sc_hd__tapvpwrvgnd_1
XTAP_1921 VGND VPWR sky130_fd_sc_hd__tapvpwrvgnd_1
X_14561_ _01645_ VGND VGND VPWR VPWR _01155_ sky130_fd_sc_hd__clkbuf_1
X_11773_ _05031_ net1133 _05505_ VGND VGND VPWR VPWR _05508_ sky130_fd_sc_hd__mux2_1
XTAP_1976 VGND VPWR sky130_fd_sc_hd__tapvpwrvgnd_1
XTAP_1965 VGND VPWR sky130_fd_sc_hd__tapvpwrvgnd_1
XTAP_1954 VGND VPWR sky130_fd_sc_hd__tapvpwrvgnd_1
X_13512_ _06792_ _06987_ _06989_ _06894_ VGND VGND VPWR VPWR _06990_ sky130_fd_sc_hd__a211o_1
XFILLER_0_51_19 VGND VGND VPWR VPWR sky130_fd_sc_hd__decap_4
X_16300_ clknet_leaf_7_clk _00885_ VGND VGND VPWR VPWR decoded_imm_j\[4\] sky130_fd_sc_hd__dfxtp_2
XFILLER_0_126_816 VGND VGND VPWR VPWR sky130_fd_sc_hd__fill_1
XTAP_1998 VGND VPWR sky130_fd_sc_hd__tapvpwrvgnd_1
XTAP_1987 VGND VPWR sky130_fd_sc_hd__tapvpwrvgnd_1
X_14492_ net622 _05223_ _01575_ VGND VGND VPWR VPWR _01609_ sky130_fd_sc_hd__mux2_1
X_10724_ net662 _03511_ _04918_ VGND VGND VPWR VPWR _04919_ sky130_fd_sc_hd__mux2_1
XFILLER_0_55_427 VGND VGND VPWR VPWR sky130_fd_sc_hd__fill_1
XFILLER_0_125_337 VGND VGND VPWR VPWR sky130_fd_sc_hd__fill_1
X_10655_ _04127_ _04859_ _04861_ VGND VGND VPWR VPWR _04862_ sky130_fd_sc_hd__a21o_1
X_13443_ cpuregs\[28\]\[19\] cpuregs\[29\]\[19\] _06687_ VGND VGND VPWR VPWR _06923_
+ sky130_fd_sc_hd__mux2_1
X_16231_ clknet_leaf_15_clk alu_out\[4\] VGND VGND VPWR VPWR alu_out_q\[4\] sky130_fd_sc_hd__dfxtp_1
X_13374_ _03329_ VGND VGND VPWR VPWR _06856_ sky130_fd_sc_hd__clkbuf_8
X_16162_ clknet_leaf_86_clk _00780_ VGND VGND VPWR VPWR net35 sky130_fd_sc_hd__dfxtp_1
XFILLER_0_140_307 VGND VGND VPWR VPWR sky130_fd_sc_hd__fill_1
X_10586_ _04722_ _04791_ _04792_ _04793_ _04752_ VGND VGND VPWR VPWR _04794_ sky130_fd_sc_hd__o221a_1
X_12325_ _05723_ decoded_imm_j\[15\] VGND VGND VPWR VPWR _05939_ sky130_fd_sc_hd__or2b_1
X_15113_ net1582 _03450_ _01937_ VGND VGND VPWR VPWR _01939_ sky130_fd_sc_hd__mux2_1
XFILLER_0_121_543 VGND VGND VPWR VPWR sky130_fd_sc_hd__fill_2
XFILLER_0_11_519 VGND VGND VPWR VPWR sky130_fd_sc_hd__fill_2
X_16093_ clknet_leaf_141_clk _00743_ VGND VGND VPWR VPWR count_cycle\[36\] sky130_fd_sc_hd__dfxtp_1
X_12256_ _05866_ _05875_ _05687_ VGND VGND VPWR VPWR _05876_ sky130_fd_sc_hd__a21o_1
X_15044_ _01902_ VGND VGND VPWR VPWR _01381_ sky130_fd_sc_hd__clkbuf_1
X_11207_ net824 _05200_ _05182_ VGND VGND VPWR VPWR _05201_ sky130_fd_sc_hd__mux2_1
XFILLER_0_76_49 VGND VGND VPWR VPWR sky130_fd_sc_hd__decap_3
X_12187_ _05693_ _05698_ _05700_ _05702_ VGND VGND VPWR VPWR _05812_ sky130_fd_sc_hd__and4_1
X_11138_ net1436 _03629_ _05146_ VGND VGND VPWR VPWR _05155_ sky130_fd_sc_hd__mux2_1
X_11069_ _05118_ VGND VGND VPWR VPWR _00255_ sky130_fd_sc_hd__clkbuf_1
XFILLER_0_92_26 VGND VGND VPWR VPWR sky130_fd_sc_hd__fill_2
X_15946_ clknet_leaf_146_clk _00596_ VGND VGND VPWR VPWR count_instr\[15\] sky130_fd_sc_hd__dfxtp_1
Xclkbuf_leaf_0_clk clknet_4_0_0_clk VGND VGND VPWR VPWR clknet_leaf_0_clk sky130_fd_sc_hd__clkbuf_16
X_15877_ clknet_leaf_135_clk _00527_ VGND VGND VPWR VPWR cpuregs\[20\]\[11\] sky130_fd_sc_hd__dfxtp_1
X_14828_ net1162 _05219_ _01778_ VGND VGND VPWR VPWR _01787_ sky130_fd_sc_hd__mux2_1
X_14759_ _01750_ VGND VGND VPWR VPWR _01248_ sky130_fd_sc_hd__clkbuf_1
XFILLER_0_59_788 VGND VGND VPWR VPWR sky130_fd_sc_hd__fill_1
XFILLER_0_128_153 VPWR VGND VPWR VGND sky130_ef_sc_hd__decap_12
X_08280_ net198 net250 VGND VGND VPWR VPWR _02661_ sky130_fd_sc_hd__or2_1
XFILLER_0_128_197 VPWR VGND VPWR VGND sky130_ef_sc_hd__decap_12
X_16429_ clknet_leaf_23_clk net860 VGND VGND VPWR VPWR decoded_imm\[18\] sky130_fd_sc_hd__dfxtp_2
XFILLER_0_41_74 VGND VGND VPWR VPWR sky130_fd_sc_hd__fill_1
XFILLER_0_54_493 VGND VGND VPWR VPWR sky130_fd_sc_hd__fill_2
XFILLER_0_26_195 VGND VGND VPWR VPWR sky130_fd_sc_hd__fill_1
XFILLER_0_140_830 VGND VGND VPWR VPWR sky130_fd_sc_hd__fill_2
XFILLER_0_2_730 VPWR VGND VPWR VGND sky130_ef_sc_hd__decap_12
XFILLER_0_100_727 VGND VGND VPWR VPWR sky130_fd_sc_hd__decap_6
X_09803_ reg_pc\[6\] _03776_ _04024_ _04032_ _03946_ VGND VGND VPWR VPWR _04033_ sky130_fd_sc_hd__a221o_1
X_07995_ count_instr\[13\] _02236_ count_cycle\[45\] _02237_ VGND VGND VPWR VPWR _02395_
+ sky130_fd_sc_hd__a22o_1
Xfanout248 net234 VGND VGND VPWR VPWR net248 sky130_fd_sc_hd__buf_4
X_09734_ _03738_ _03960_ _03964_ _03684_ VGND VGND VPWR VPWR _03965_ sky130_fd_sc_hd__o211a_1
X_09665_ _03755_ VGND VGND VPWR VPWR _03898_ sky130_fd_sc_hd__clkbuf_8
X_08616_ _02977_ _02983_ VGND VGND VPWR VPWR _02985_ sky130_fd_sc_hd__nand2_1
XFILLER_0_96_349 VGND VGND VPWR VPWR sky130_fd_sc_hd__decap_6
XTAP_1239 VGND VPWR sky130_fd_sc_hd__tapvpwrvgnd_1
XTAP_1228 VGND VPWR sky130_fd_sc_hd__tapvpwrvgnd_1
XTAP_1217 VGND VPWR sky130_fd_sc_hd__tapvpwrvgnd_1
XTAP_1206 VGND VPWR sky130_fd_sc_hd__tapvpwrvgnd_1
X_09596_ _03818_ _03821_ _03828_ _03829_ VGND VGND VPWR VPWR _03830_ sky130_fd_sc_hd__o211a_1
X_08547_ _02910_ _02914_ VGND VGND VPWR VPWR _02921_ sky130_fd_sc_hd__nand2_1
XFILLER_0_65_758 VGND VGND VPWR VPWR sky130_fd_sc_hd__decap_3
X_08478_ _02839_ _02846_ _02750_ VGND VGND VPWR VPWR _02858_ sky130_fd_sc_hd__mux2_1
XFILLER_0_49_287 VGND VGND VPWR VPWR sky130_fd_sc_hd__decap_6
XFILLER_0_37_438 VGND VGND VPWR VPWR sky130_fd_sc_hd__decap_4
XFILLER_0_107_337 VPWR VGND VPWR VGND sky130_ef_sc_hd__decap_12
XFILLER_0_123_819 VGND VGND VPWR VPWR sky130_fd_sc_hd__fill_1
X_10440_ _04030_ _04647_ _04651_ _03684_ VGND VGND VPWR VPWR _04652_ sky130_fd_sc_hd__o211a_1
X_10371_ _02480_ _02593_ _03650_ VGND VGND VPWR VPWR _04585_ sky130_fd_sc_hd__mux2_1
XFILLER_0_33_699 VGND VGND VPWR VPWR sky130_fd_sc_hd__fill_1
X_12110_ _03599_ reg_next_pc\[24\] _03223_ VGND VGND VPWR VPWR _05747_ sky130_fd_sc_hd__mux2_2
X_13090_ _03317_ VGND VGND VPWR VPWR _06580_ sky130_fd_sc_hd__clkbuf_4
X_12041_ _02108_ _05698_ VGND VGND VPWR VPWR _05699_ sky130_fd_sc_hd__or2_1
Xhold280 cpuregs\[28\]\[10\] VGND VGND VPWR VPWR net638 sky130_fd_sc_hd__dlygate4sd3_1
Xhold291 cpuregs\[30\]\[7\] VGND VGND VPWR VPWR net649 sky130_fd_sc_hd__dlygate4sd3_1
XFILLER_0_46_19 VGND VGND VPWR VPWR sky130_fd_sc_hd__decap_8
X_16780_ clknet_leaf_73_clk _01344_ VGND VGND VPWR VPWR cpuregs\[5\]\[27\] sky130_fd_sc_hd__dfxtp_1
X_15800_ clknet_leaf_57_clk _00450_ VGND VGND VPWR VPWR cpuregs\[26\]\[30\] sky130_fd_sc_hd__dfxtp_1
X_13992_ net430 _07358_ net241 _07407_ VGND VGND VPWR VPWR _00880_ sky130_fd_sc_hd__a22o_1
X_15731_ clknet_leaf_69_clk _00381_ VGND VGND VPWR VPWR cpuregs\[21\]\[25\] sky130_fd_sc_hd__dfxtp_1
X_12943_ cpuregs\[0\]\[5\] cpuregs\[1\]\[5\] cpuregs\[2\]\[5\] cpuregs\[3\]\[5\] _06364_
+ _03400_ VGND VGND VPWR VPWR _06437_ sky130_fd_sc_hd__mux4_1
XANTENNA_142 net99 VGND VGND VPWR VPWR sky130_fd_sc_hd__diode_2
X_15662_ clknet_leaf_81_clk _00312_ VGND VGND VPWR VPWR cpuregs\[14\]\[20\] sky130_fd_sc_hd__dfxtp_1
XANTENNA_131 reg_next_pc\[15\] VGND VGND VPWR VPWR sky130_fd_sc_hd__diode_2
XFILLER_0_68_541 VGND VGND VPWR VPWR sky130_fd_sc_hd__decap_3
XFILLER_0_62_29 VGND VGND VPWR VPWR sky130_fd_sc_hd__decap_8
XANTENNA_120 _02664_ VGND VGND VPWR VPWR sky130_fd_sc_hd__diode_2
X_12874_ decoded_imm\[0\] _06372_ _02171_ VGND VGND VPWR VPWR _06373_ sky130_fd_sc_hd__mux2_1
X_14613_ _01673_ VGND VGND VPWR VPWR _01179_ sky130_fd_sc_hd__clkbuf_1
XTAP_1740 VGND VPWR sky130_fd_sc_hd__tapvpwrvgnd_1
XTAP_1751 VGND VPWR sky130_fd_sc_hd__tapvpwrvgnd_1
XANTENNA_164 net120 VGND VGND VPWR VPWR sky130_fd_sc_hd__diode_2
XANTENNA_153 net218 VGND VGND VPWR VPWR sky130_fd_sc_hd__diode_2
X_15593_ clknet_leaf_93_clk _00243_ VGND VGND VPWR VPWR cpuregs\[28\]\[15\] sky130_fd_sc_hd__dfxtp_1
X_11825_ count_instr\[7\] count_instr\[6\] _05536_ VGND VGND VPWR VPWR _05542_ sky130_fd_sc_hd__and3_1
XFILLER_0_28_416 VGND VGND VPWR VPWR sky130_fd_sc_hd__decap_4
X_14544_ net588 _05207_ _01634_ VGND VGND VPWR VPWR _01637_ sky130_fd_sc_hd__mux2_1
XTAP_1784 VGND VPWR sky130_fd_sc_hd__tapvpwrvgnd_1
XTAP_1773 VGND VPWR sky130_fd_sc_hd__tapvpwrvgnd_1
XTAP_1762 VGND VPWR sky130_fd_sc_hd__tapvpwrvgnd_1
X_11756_ _05014_ net1021 _05494_ VGND VGND VPWR VPWR _05499_ sky130_fd_sc_hd__mux2_1
X_14475_ _01600_ VGND VGND VPWR VPWR _01082_ sky130_fd_sc_hd__clkbuf_1
XTAP_1795 VGND VPWR sky130_fd_sc_hd__tapvpwrvgnd_1
XFILLER_0_71_706 VGND VGND VPWR VPWR sky130_fd_sc_hd__fill_1
X_10707_ net683 _03456_ _04907_ VGND VGND VPWR VPWR _04910_ sky130_fd_sc_hd__mux2_1
X_16214_ clknet_leaf_63_clk _00831_ VGND VGND VPWR VPWR net220 sky130_fd_sc_hd__dfxtp_4
XFILLER_0_83_588 VGND VGND VPWR VPWR sky130_fd_sc_hd__decap_6
X_13426_ _03322_ VGND VGND VPWR VPWR _06906_ sky130_fd_sc_hd__clkbuf_8
XFILLER_0_70_205 VGND VGND VPWR VPWR sky130_fd_sc_hd__decap_8
X_11687_ _05462_ VGND VGND VPWR VPWR _00529_ sky130_fd_sc_hd__clkbuf_1
XFILLER_0_36_471 VGND VGND VPWR VPWR sky130_fd_sc_hd__decap_4
X_10638_ cpuregs\[4\]\[29\] cpuregs\[5\]\[29\] cpuregs\[6\]\[29\] cpuregs\[7\]\[29\]
+ _03864_ _03820_ VGND VGND VPWR VPWR _04845_ sky130_fd_sc_hd__mux4_1
XFILLER_0_63_290 VPWR VGND VPWR VGND sky130_ef_sc_hd__decap_12
X_10569_ cpuregs\[28\]\[27\] cpuregs\[29\]\[27\] _03754_ VGND VGND VPWR VPWR _04778_
+ sky130_fd_sc_hd__mux2_1
X_16145_ clknet_leaf_40_clk _07633_ VGND VGND VPWR VPWR reg_out\[23\] sky130_fd_sc_hd__dfxtp_1
X_13357_ _06535_ _06834_ _06838_ _06542_ VGND VGND VPWR VPWR _06839_ sky130_fd_sc_hd__o211a_1
X_12308_ _05735_ _05922_ _05923_ _05768_ VGND VGND VPWR VPWR _00689_ sky130_fd_sc_hd__o211a_1
XFILLER_0_87_26 VGND VGND VPWR VPWR sky130_fd_sc_hd__fill_2
X_13288_ _06639_ _06771_ VGND VGND VPWR VPWR _06772_ sky130_fd_sc_hd__and2_1
X_16076_ clknet_leaf_150_clk _00726_ VGND VGND VPWR VPWR count_cycle\[19\] sky130_fd_sc_hd__dfxtp_1
X_15027_ _03610_ net964 _01887_ VGND VGND VPWR VPWR _01893_ sky130_fd_sc_hd__mux2_1
X_12239_ _05854_ _05856_ _05858_ _05859_ VGND VGND VPWR VPWR _05860_ sky130_fd_sc_hd__nand4_1
X_07780_ mem_do_prefetch _02150_ _02194_ VGND VGND VPWR VPWR _02195_ sky130_fd_sc_hd__o21a_1
X_15929_ clknet_leaf_55_clk _00579_ VGND VGND VPWR VPWR cpuregs\[17\]\[31\] sky130_fd_sc_hd__dfxtp_1
Xinput4 mem_rdata[12] VGND VGND VPWR VPWR net4 sky130_fd_sc_hd__clkbuf_2
XFILLER_0_78_305 VGND VGND VPWR VPWR sky130_fd_sc_hd__decap_3
X_09450_ _03677_ _03681_ _03683_ _03685_ VGND VGND VPWR VPWR _03686_ sky130_fd_sc_hd__o211a_1
X_08401_ _02263_ VGND VGND VPWR VPWR _02782_ sky130_fd_sc_hd__inv_2
X_09381_ _03621_ VGND VGND VPWR VPWR _03622_ sky130_fd_sc_hd__clkbuf_4
X_08332_ net179 net211 VGND VGND VPWR VPWR _02713_ sky130_fd_sc_hd__nand2_1
XFILLER_0_19_449 VGND VGND VPWR VPWR sky130_fd_sc_hd__decap_3
X_08263_ net194 VGND VGND VPWR VPWR _02646_ sky130_fd_sc_hd__clkbuf_4
XFILLER_0_116_178 VGND VGND VPWR VPWR sky130_fd_sc_hd__decap_3
X_08194_ _02286_ _02572_ _02581_ VGND VGND VPWR VPWR _07635_ sky130_fd_sc_hd__o21a_1
XFILLER_0_104_318 VGND VGND VPWR VPWR sky130_fd_sc_hd__decap_8
XFILLER_0_61_238 VGND VGND VPWR VPWR sky130_fd_sc_hd__fill_1
XFILLER_0_6_365 VGND VGND VPWR VPWR sky130_fd_sc_hd__fill_1
XFILLER_0_125_690 VGND VGND VPWR VPWR sky130_fd_sc_hd__fill_1
XFILLER_0_42_474 VGND VGND VPWR VPWR sky130_fd_sc_hd__fill_2
XFILLER_0_140_671 VGND VGND VPWR VPWR sky130_fd_sc_hd__fill_1
X_07978_ _02336_ _02379_ _02338_ VGND VGND VPWR VPWR _02380_ sky130_fd_sc_hd__a21o_1
X_09717_ _03948_ _02280_ _03715_ VGND VGND VPWR VPWR _03949_ sky130_fd_sc_hd__mux2_1
XFILLER_0_97_614 VGND VGND VPWR VPWR sky130_fd_sc_hd__fill_2
X_09648_ _03880_ VGND VGND VPWR VPWR _03881_ sky130_fd_sc_hd__buf_6
XTAP_1003 VGND VPWR sky130_fd_sc_hd__tapvpwrvgnd_1
XFILLER_0_84_319 VGND VGND VPWR VPWR sky130_fd_sc_hd__decap_3
XTAP_1047 VGND VPWR sky130_fd_sc_hd__tapvpwrvgnd_1
XTAP_1036 VGND VPWR sky130_fd_sc_hd__tapvpwrvgnd_1
XTAP_1025 VGND VPWR sky130_fd_sc_hd__tapvpwrvgnd_1
XTAP_1014 VGND VPWR sky130_fd_sc_hd__tapvpwrvgnd_1
X_09579_ _03811_ _03812_ VGND VGND VPWR VPWR _03813_ sky130_fd_sc_hd__nand2_1
XTAP_1058 VGND VPWR sky130_fd_sc_hd__tapvpwrvgnd_1
XTAP_1069 VGND VPWR sky130_fd_sc_hd__tapvpwrvgnd_1
X_12590_ _06161_ VGND VGND VPWR VPWR _00733_ sky130_fd_sc_hd__clkbuf_1
X_11610_ _05421_ VGND VGND VPWR VPWR _00493_ sky130_fd_sc_hd__clkbuf_1
X_11541_ _05003_ net1304 _05375_ VGND VGND VPWR VPWR _05385_ sky130_fd_sc_hd__mux2_1
XFILLER_0_46_780 VGND VGND VPWR VPWR sky130_fd_sc_hd__fill_1
XFILLER_0_37_279 VGND VGND VPWR VPWR sky130_fd_sc_hd__fill_1
X_14260_ net168 net131 _06291_ VGND VGND VPWR VPWR _07556_ sky130_fd_sc_hd__mux2_1
X_11472_ net815 _05179_ _05338_ VGND VGND VPWR VPWR _05348_ sky130_fd_sc_hd__mux2_1
X_10423_ cpuregs\[24\]\[23\] cpuregs\[25\]\[23\] cpuregs\[26\]\[23\] cpuregs\[27\]\[23\]
+ _03831_ _03832_ VGND VGND VPWR VPWR _04636_ sky130_fd_sc_hd__mux4_1
X_13211_ cpuregs\[12\]\[13\] cpuregs\[13\]\[13\] cpuregs\[14\]\[13\] cpuregs\[15\]\[13\]
+ _06696_ _06419_ VGND VGND VPWR VPWR _06697_ sky130_fd_sc_hd__mux4_1
X_14191_ net1575 _02751_ _07519_ VGND VGND VPWR VPWR _07520_ sky130_fd_sc_hd__mux2_1
X_10354_ cpuregs\[28\]\[21\] cpuregs\[29\]\[21\] _03754_ VGND VGND VPWR VPWR _04569_
+ sky130_fd_sc_hd__mux2_1
XFILLER_0_103_351 VGND VGND VPWR VPWR sky130_fd_sc_hd__fill_2
X_13142_ _06630_ VGND VGND VPWR VPWR _00816_ sky130_fd_sc_hd__clkbuf_1
XFILLER_0_0_508 VGND VGND VPWR VPWR sky130_fd_sc_hd__fill_2
XFILLER_0_131_671 VGND VGND VPWR VPWR sky130_fd_sc_hd__fill_1
X_10285_ _03868_ _04501_ _03675_ VGND VGND VPWR VPWR _04502_ sky130_fd_sc_hd__a21o_1
XFILLER_0_57_29 VGND VGND VPWR VPWR sky130_fd_sc_hd__fill_2
X_13073_ _06459_ _06560_ _06562_ _06563_ VGND VGND VPWR VPWR _06564_ sky130_fd_sc_hd__a211o_1
XTAP_809 VGND VPWR sky130_fd_sc_hd__tapvpwrvgnd_1
X_16901_ clknet_leaf_78_clk _01465_ VGND VGND VPWR VPWR cpuregs\[8\]\[20\] sky130_fd_sc_hd__dfxtp_1
X_12024_ net385 _05683_ _05533_ VGND VGND VPWR VPWR _05685_ sky130_fd_sc_hd__o21ai_1
X_16832_ clknet_leaf_88_clk _01396_ VGND VGND VPWR VPWR cpuregs\[7\]\[15\] sky130_fd_sc_hd__dfxtp_1
XFILLER_0_87_102 VGND VGND VPWR VPWR sky130_fd_sc_hd__fill_2
X_16763_ clknet_leaf_108_clk _01327_ VGND VGND VPWR VPWR cpuregs\[5\]\[10\] sky130_fd_sc_hd__dfxtp_1
X_13975_ _07396_ VGND VGND VPWR VPWR _00874_ sky130_fd_sc_hd__clkbuf_1
XFILLER_0_87_113 VGND VGND VPWR VPWR sky130_fd_sc_hd__decap_4
X_16694_ clknet_leaf_113_clk _01261_ VGND VGND VPWR VPWR cpuregs\[3\]\[8\] sky130_fd_sc_hd__dfxtp_1
X_15714_ clknet_leaf_141_clk _00364_ VGND VGND VPWR VPWR cpuregs\[21\]\[8\] sky130_fd_sc_hd__dfxtp_1
X_12926_ cpuregs\[12\]\[5\] cpuregs\[13\]\[5\] cpuregs\[14\]\[5\] cpuregs\[15\]\[5\]
+ _06418_ _06419_ VGND VGND VPWR VPWR _06420_ sky130_fd_sc_hd__mux4_1
XTAP_2271 VGND VPWR sky130_fd_sc_hd__tapvpwrvgnd_1
XTAP_2260 VGND VPWR sky130_fd_sc_hd__tapvpwrvgnd_1
X_12857_ cpuregs\[30\]\[0\] cpuregs\[31\]\[0\] _03336_ VGND VGND VPWR VPWR _06356_
+ sky130_fd_sc_hd__mux2_1
X_15645_ clknet_leaf_122_clk _00295_ VGND VGND VPWR VPWR cpuregs\[14\]\[3\] sky130_fd_sc_hd__dfxtp_1
XTAP_2293 VGND VPWR sky130_fd_sc_hd__tapvpwrvgnd_1
XTAP_2282 VGND VPWR sky130_fd_sc_hd__tapvpwrvgnd_1
X_11808_ count_instr\[3\] count_instr\[2\] _05525_ VGND VGND VPWR VPWR _05529_ sky130_fd_sc_hd__and3_1
X_12788_ _06308_ VGND VGND VPWR VPWR _00784_ sky130_fd_sc_hd__clkbuf_1
X_15576_ clknet_leaf_92_clk _00226_ VGND VGND VPWR VPWR cpuregs\[2\]\[30\] sky130_fd_sc_hd__dfxtp_1
XTAP_1592 VGND VPWR sky130_fd_sc_hd__tapvpwrvgnd_1
XTAP_1581 VGND VPWR sky130_fd_sc_hd__tapvpwrvgnd_1
XTAP_1570 VGND VPWR sky130_fd_sc_hd__tapvpwrvgnd_1
XFILLER_0_83_385 VGND VGND VPWR VPWR sky130_fd_sc_hd__fill_1
XFILLER_0_71_503 VGND VGND VPWR VPWR sky130_fd_sc_hd__fill_1
X_14527_ net737 _05190_ _01623_ VGND VGND VPWR VPWR _01628_ sky130_fd_sc_hd__mux2_1
X_11739_ _04997_ net1098 _05483_ VGND VGND VPWR VPWR _05490_ sky130_fd_sc_hd__mux2_1
XFILLER_0_22_65 VGND VGND VPWR VPWR sky130_fd_sc_hd__fill_2
XFILLER_0_118_3 VPWR VGND VPWR VGND sky130_ef_sc_hd__decap_12
X_14458_ _01591_ VGND VGND VPWR VPWR _01074_ sky130_fd_sc_hd__clkbuf_1
XFILLER_0_98_36 VGND VGND VPWR VPWR sky130_fd_sc_hd__decap_6
X_13409_ cpuregs\[24\]\[18\] cpuregs\[25\]\[18\] cpuregs\[26\]\[18\] cpuregs\[27\]\[18\]
+ _06856_ _06889_ VGND VGND VPWR VPWR _06890_ sky130_fd_sc_hd__mux4_1
X_14389_ _05012_ net1003 _01551_ VGND VGND VPWR VPWR _01555_ sky130_fd_sc_hd__mux2_1
X_16128_ clknet_leaf_12_clk _07646_ VGND VGND VPWR VPWR reg_out\[6\] sky130_fd_sc_hd__dfxtp_1
XFILLER_0_51_260 VGND VGND VPWR VPWR sky130_fd_sc_hd__fill_1
XFILLER_0_122_682 VGND VGND VPWR VPWR sky130_fd_sc_hd__fill_1
Xpicorv32_257 VGND VGND VPWR VPWR picorv32_257/HI eoi[4] sky130_fd_sc_hd__conb_1
Xpicorv32_268 VGND VGND VPWR VPWR picorv32_268/HI eoi[15] sky130_fd_sc_hd__conb_1
Xpicorv32_279 VGND VGND VPWR VPWR picorv32_279/HI eoi[26] sky130_fd_sc_hd__conb_1
X_08950_ _02445_ _03257_ _03246_ VGND VGND VPWR VPWR _03258_ sky130_fd_sc_hd__mux2_1
X_16059_ clknet_leaf_150_clk _00709_ VGND VGND VPWR VPWR count_cycle\[2\] sky130_fd_sc_hd__dfxtp_1
XFILLER_0_138_42 VPWR VGND VPWR VGND sky130_ef_sc_hd__decap_12
X_08881_ _02753_ net213 _02447_ VGND VGND VPWR VPWR _03216_ sky130_fd_sc_hd__mux2_1
X_07901_ _02304_ _02307_ VGND VGND VPWR VPWR _02308_ sky130_fd_sc_hd__xor2_1
XFILLER_0_44_6 VGND VGND VPWR VPWR sky130_fd_sc_hd__decap_4
X_07832_ net193 VGND VGND VPWR VPWR _02243_ sky130_fd_sc_hd__buf_2
XFILLER_0_47_73 VGND VGND VPWR VPWR sky130_fd_sc_hd__fill_2
XFILLER_0_138_97 VPWR VGND VPWR VGND sky130_ef_sc_hd__decap_12
XFILLER_0_79_614 VGND VGND VPWR VPWR sky130_fd_sc_hd__fill_2
X_09502_ cpuregs\[22\]\[1\] cpuregs\[23\]\[1\] _03680_ VGND VGND VPWR VPWR _03737_
+ sky130_fd_sc_hd__mux2_1
X_07763_ _02180_ VGND VGND VPWR VPWR _02181_ sky130_fd_sc_hd__clkbuf_8
X_07694_ net393 instr_slt instr_sltiu instr_slti VGND VGND VPWR VPWR _02120_ sky130_fd_sc_hd__or4_1
XFILLER_0_63_61 VGND VGND VPWR VPWR sky130_fd_sc_hd__fill_2
X_09433_ _03668_ VGND VGND VPWR VPWR _03669_ sky130_fd_sc_hd__buf_6
X_09364_ reg_pc\[25\] reg_pc\[24\] _03593_ VGND VGND VPWR VPWR _03607_ sky130_fd_sc_hd__and3_1
XPHY_119 VGND VGND VPWR VPWR sky130_fd_sc_hd__decap_3
XPHY_108 VGND VGND VPWR VPWR sky130_fd_sc_hd__decap_3
XFILLER_0_136_229 VGND VGND VPWR VPWR sky130_fd_sc_hd__fill_1
X_08315_ _02689_ _02692_ _02695_ VGND VGND VPWR VPWR _02696_ sky130_fd_sc_hd__and3_1
XFILLER_0_129_281 VGND VGND VPWR VPWR sky130_fd_sc_hd__fill_2
X_09295_ reg_out\[16\] alu_out_q\[16\] _03435_ VGND VGND VPWR VPWR _03547_ sky130_fd_sc_hd__mux2_1
XFILLER_0_74_363 VGND VGND VPWR VPWR sky130_fd_sc_hd__fill_1
XANTENNA_31 _06613_ VGND VGND VPWR VPWR sky130_fd_sc_hd__diode_2
XANTENNA_20 _03907_ VGND VGND VPWR VPWR sky130_fd_sc_hd__diode_2
X_08246_ _02627_ _02628_ _02629_ VGND VGND VPWR VPWR _02630_ sky130_fd_sc_hd__a21oi_1
XANTENNA_53 net56 VGND VGND VPWR VPWR sky130_fd_sc_hd__diode_2
XANTENNA_42 net21 VGND VGND VPWR VPWR sky130_fd_sc_hd__diode_2
XANTENNA_64 net78 VGND VGND VPWR VPWR sky130_fd_sc_hd__diode_2
XANTENNA_75 net101 VGND VGND VPWR VPWR sky130_fd_sc_hd__diode_2
XANTENNA_86 net117 VGND VGND VPWR VPWR sky130_fd_sc_hd__diode_2
X_08177_ net17 _02447_ _02428_ VGND VGND VPWR VPWR _02566_ sky130_fd_sc_hd__a21o_1
XFILLER_0_50_709 VGND VGND VPWR VPWR sky130_fd_sc_hd__fill_2
XANTENNA_97 net171 VGND VGND VPWR VPWR sky130_fd_sc_hd__diode_2
XFILLER_0_113_693 VGND VGND VPWR VPWR sky130_fd_sc_hd__fill_2
XFILLER_0_112_192 VGND VGND VPWR VPWR sky130_fd_sc_hd__fill_1
Xoutput160 net160 VGND VGND VPWR VPWR mem_wdata[3] sky130_fd_sc_hd__clkbuf_4
Xoutput193 net193 VGND VGND VPWR VPWR pcpi_rs1[2] sky130_fd_sc_hd__clkbuf_4
Xoutput182 net182 VGND VGND VPWR VPWR pcpi_rs1[1] sky130_fd_sc_hd__clkbuf_4
X_10070_ _04292_ _02403_ _04150_ VGND VGND VPWR VPWR _04293_ sky130_fd_sc_hd__mux2_1
Xoutput171 net171 VGND VGND VPWR VPWR pcpi_rs1[0] sky130_fd_sc_hd__clkbuf_4
XFILLER_0_100_398 VGND VGND VPWR VPWR sky130_fd_sc_hd__fill_1
X_13760_ _07229_ net224 _06960_ VGND VGND VPWR VPWR _07230_ sky130_fd_sc_hd__mux2_1
X_10972_ _05067_ VGND VGND VPWR VPWR _00209_ sky130_fd_sc_hd__clkbuf_1
X_13691_ _06348_ _07160_ _07162_ _06417_ VGND VGND VPWR VPWR _07163_ sky130_fd_sc_hd__a211o_1
XFILLER_0_97_477 VGND VGND VPWR VPWR sky130_fd_sc_hd__fill_1
X_12711_ count_cycle\[61\] _06245_ VGND VGND VPWR VPWR _06248_ sky130_fd_sc_hd__or2_1
XFILLER_0_97_499 VGND VGND VPWR VPWR sky130_fd_sc_hd__fill_2
X_15430_ clknet_leaf_19_clk _00080_ VGND VGND VPWR VPWR net173 sky130_fd_sc_hd__dfxtp_4
XFILLER_0_66_831 VGND VGND VPWR VPWR sky130_fd_sc_hd__fill_1
XFILLER_0_66_820 VGND VGND VPWR VPWR sky130_fd_sc_hd__fill_1
X_12642_ count_cycle\[41\] _06193_ count_cycle\[42\] VGND VGND VPWR VPWR _06198_ sky130_fd_sc_hd__a21o_1
X_15361_ _03603_ net1099 _02063_ VGND VGND VPWR VPWR _02068_ sky130_fd_sc_hd__mux2_1
XFILLER_0_81_823 VGND VGND VPWR VPWR sky130_fd_sc_hd__fill_1
X_12573_ _06148_ _06149_ VGND VGND VPWR VPWR _00728_ sky130_fd_sc_hd__nor2_1
X_15292_ _02031_ VGND VGND VPWR VPWR _01500_ sky130_fd_sc_hd__clkbuf_1
X_14312_ _07568_ _07572_ _07586_ _07359_ net1593 VGND VGND VPWR VPWR _01009_ sky130_fd_sc_hd__o32a_1
X_11524_ _05376_ VGND VGND VPWR VPWR _00452_ sky130_fd_sc_hd__clkbuf_1
XFILLER_0_19_780 VGND VGND VPWR VPWR sky130_fd_sc_hd__fill_1
X_14243_ net615 net114 _07541_ VGND VGND VPWR VPWR _07547_ sky130_fd_sc_hd__mux2_1
Xwire243 _07381_ VGND VGND VPWR VPWR net243 sky130_fd_sc_hd__buf_1
XFILLER_0_53_569 VGND VGND VPWR VPWR sky130_fd_sc_hd__decap_3
X_11455_ _05339_ VGND VGND VPWR VPWR _00420_ sky130_fd_sc_hd__clkbuf_1
XFILLER_0_123_446 VGND VGND VPWR VPWR sky130_fd_sc_hd__fill_2
X_10406_ cpuregs\[12\]\[23\] cpuregs\[13\]\[23\] _03749_ VGND VGND VPWR VPWR _04619_
+ sky130_fd_sc_hd__mux2_1
XFILLER_0_110_129 VGND VGND VPWR VPWR sky130_fd_sc_hd__fill_2
X_14174_ mem_do_wdata _03227_ VGND VGND VPWR VPWR _07506_ sky130_fd_sc_hd__and2b_1
X_11386_ net1352 _05159_ _05302_ VGND VGND VPWR VPWR _05303_ sky130_fd_sc_hd__mux2_1
X_10337_ _03766_ _04549_ _04551_ VGND VGND VPWR VPWR _04552_ sky130_fd_sc_hd__a21o_1
XFILLER_0_103_192 VGND VGND VPWR VPWR sky130_fd_sc_hd__decap_3
X_13125_ _03323_ VGND VGND VPWR VPWR _06614_ sky130_fd_sc_hd__clkbuf_8
XTAP_606 VGND VPWR sky130_fd_sc_hd__tapvpwrvgnd_1
X_10268_ _03732_ _04480_ _04484_ _03684_ VGND VGND VPWR VPWR _04485_ sky130_fd_sc_hd__o211a_1
XTAP_617 VGND VPWR sky130_fd_sc_hd__tapvpwrvgnd_1
XTAP_628 VGND VPWR sky130_fd_sc_hd__tapvpwrvgnd_1
XTAP_639 VGND VPWR sky130_fd_sc_hd__tapvpwrvgnd_1
X_13056_ _06434_ _06546_ VGND VGND VPWR VPWR _06547_ sky130_fd_sc_hd__and2_1
X_12007_ net637 _05671_ _05673_ VGND VGND VPWR VPWR _00638_ sky130_fd_sc_hd__o21a_1
X_10199_ _04045_ _04417_ _00014_ VGND VGND VPWR VPWR _04418_ sky130_fd_sc_hd__a21o_1
X_16815_ clknet_leaf_91_clk _01379_ VGND VGND VPWR VPWR cpuregs\[6\]\[30\] sky130_fd_sc_hd__dfxtp_1
X_16746_ clknet_leaf_73_clk _01310_ VGND VGND VPWR VPWR cpuregs\[4\]\[25\] sky130_fd_sc_hd__dfxtp_1
X_13958_ is_alu_reg_reg _07326_ net242 VGND VGND VPWR VPWR _07384_ sky130_fd_sc_hd__and3_2
X_12909_ _06406_ _02748_ _06375_ VGND VGND VPWR VPWR _06407_ sky130_fd_sc_hd__mux2_1
X_16677_ clknet_leaf_68_clk _01244_ VGND VGND VPWR VPWR cpuregs\[29\]\[23\] sky130_fd_sc_hd__dfxtp_1
X_13889_ _07326_ _07338_ VGND VGND VPWR VPWR _07339_ sky130_fd_sc_hd__and2_1
XFILLER_0_124_99 VGND VGND VPWR VPWR sky130_fd_sc_hd__fill_1
XTAP_2090 VGND VPWR sky130_fd_sc_hd__tapvpwrvgnd_1
X_15628_ clknet_leaf_59_clk _00278_ VGND VGND VPWR VPWR cpuregs\[31\]\[18\] sky130_fd_sc_hd__dfxtp_1
X_15559_ clknet_leaf_102_clk _00209_ VGND VGND VPWR VPWR cpuregs\[2\]\[13\] sky130_fd_sc_hd__dfxtp_1
XFILLER_0_16_205 VGND VGND VPWR VPWR sky130_fd_sc_hd__fill_1
XFILLER_0_127_785 VGND VGND VPWR VPWR sky130_fd_sc_hd__decap_6
X_08100_ _02221_ _02465_ _02492_ _02242_ _02493_ VGND VGND VPWR VPWR _02494_ sky130_fd_sc_hd__a32o_1
X_09080_ _03307_ _03334_ _03358_ _03360_ VGND VGND VPWR VPWR _03361_ sky130_fd_sc_hd__o211a_1
XFILLER_0_140_65 VGND VGND VPWR VPWR sky130_fd_sc_hd__fill_1
XFILLER_0_126_273 VGND VGND VPWR VPWR sky130_fd_sc_hd__decap_8
X_08031_ _02428_ VGND VGND VPWR VPWR _02429_ sky130_fd_sc_hd__clkbuf_4
XFILLER_0_4_622 VGND VGND VPWR VPWR sky130_fd_sc_hd__fill_1
XFILLER_0_25_772 VGND VGND VPWR VPWR sky130_fd_sc_hd__fill_1
XFILLER_0_102_619 VGND VGND VPWR VPWR sky130_fd_sc_hd__fill_2
Xhold802 cpuregs\[18\]\[31\] VGND VGND VPWR VPWR net1160 sky130_fd_sc_hd__dlygate4sd3_1
XFILLER_0_3_121 VGND VGND VPWR VPWR sky130_fd_sc_hd__decap_8
Xhold835 cpuregs\[2\]\[28\] VGND VGND VPWR VPWR net1193 sky130_fd_sc_hd__dlygate4sd3_1
Xhold846 cpuregs\[26\]\[29\] VGND VGND VPWR VPWR net1204 sky130_fd_sc_hd__dlygate4sd3_1
Xhold813 cpuregs\[10\]\[22\] VGND VGND VPWR VPWR net1171 sky130_fd_sc_hd__dlygate4sd3_1
Xhold824 cpuregs\[23\]\[21\] VGND VGND VPWR VPWR net1182 sky130_fd_sc_hd__dlygate4sd3_1
XFILLER_0_4_699 VGND VGND VPWR VPWR sky130_fd_sc_hd__fill_1
Xhold879 cpuregs\[29\]\[22\] VGND VGND VPWR VPWR net1237 sky130_fd_sc_hd__dlygate4sd3_1
Xhold857 cpuregs\[8\]\[29\] VGND VGND VPWR VPWR net1215 sky130_fd_sc_hd__dlygate4sd3_1
X_09982_ _03863_ _04199_ _04206_ VGND VGND VPWR VPWR _04207_ sky130_fd_sc_hd__or3_2
XFILLER_0_12_488 VGND VGND VPWR VPWR sky130_fd_sc_hd__decap_4
Xhold868 cpuregs\[18\]\[7\] VGND VGND VPWR VPWR net1226 sky130_fd_sc_hd__dlygate4sd3_1
X_08933_ _02111_ VGND VGND VPWR VPWR _03246_ sky130_fd_sc_hd__clkbuf_4
X_08864_ net247 _03204_ _03207_ VGND VGND VPWR VPWR net98 sky130_fd_sc_hd__a21o_2
X_08795_ _02578_ VGND VGND VPWR VPWR _03150_ sky130_fd_sc_hd__inv_2
X_07815_ net12 net130 _02226_ _02219_ VGND VGND VPWR VPWR _02227_ sky130_fd_sc_hd__a22o_1
X_07746_ instr_jal _02165_ VGND VGND VPWR VPWR _02166_ sky130_fd_sc_hd__nor2_4
X_09416_ _03651_ VGND VGND VPWR VPWR _03652_ sky130_fd_sc_hd__clkbuf_4
XFILLER_0_48_831 VGND VGND VPWR VPWR sky130_fd_sc_hd__fill_1
X_07677_ instr_lw _02096_ _02099_ instr_sw VGND VGND VPWR VPWR _02107_ sky130_fd_sc_hd__a22o_1
X_09347_ _03592_ VGND VGND VPWR VPWR _00059_ sky130_fd_sc_hd__clkbuf_1
XFILLER_0_133_700 VGND VGND VPWR VPWR sky130_fd_sc_hd__fill_1
X_09278_ net1410 _03532_ _03512_ VGND VGND VPWR VPWR _03533_ sky130_fd_sc_hd__mux2_1
XFILLER_0_117_295 VGND VGND VPWR VPWR sky130_fd_sc_hd__decap_6
XFILLER_0_117_262 VGND VGND VPWR VPWR sky130_fd_sc_hd__decap_8
X_08229_ _02565_ _02575_ _02611_ _02613_ VGND VGND VPWR VPWR _02614_ sky130_fd_sc_hd__o31a_1
XFILLER_0_90_653 VGND VGND VPWR VPWR sky130_fd_sc_hd__fill_1
XFILLER_0_35_558 VGND VGND VPWR VPWR sky130_fd_sc_hd__fill_2
XFILLER_0_35_569 VGND VGND VPWR VPWR sky130_fd_sc_hd__fill_2
XFILLER_0_132_243 VGND VGND VPWR VPWR sky130_fd_sc_hd__fill_2
XFILLER_0_99_90 VGND VGND VPWR VPWR sky130_fd_sc_hd__fill_2
XFILLER_0_62_399 VGND VGND VPWR VPWR sky130_fd_sc_hd__fill_1
XFILLER_0_15_271 VGND VGND VPWR VPWR sky130_fd_sc_hd__decap_8
XFILLER_0_132_287 VGND VGND VPWR VPWR sky130_fd_sc_hd__fill_2
X_11240_ _03640_ VGND VGND VPWR VPWR _05223_ sky130_fd_sc_hd__clkbuf_4
X_11171_ _05176_ VGND VGND VPWR VPWR _00299_ sky130_fd_sc_hd__clkbuf_1
X_10122_ _03795_ _04336_ _04342_ VGND VGND VPWR VPWR _04343_ sky130_fd_sc_hd__or3_2
XFILLER_0_30_296 VGND VGND VPWR VPWR sky130_fd_sc_hd__decap_3
X_10053_ _03795_ _04269_ _04275_ VGND VGND VPWR VPWR _04276_ sky130_fd_sc_hd__or3_2
X_14930_ _03519_ net1578 _01840_ VGND VGND VPWR VPWR _01842_ sky130_fd_sc_hd__mux2_1
X_14861_ _01805_ VGND VGND VPWR VPWR _01295_ sky130_fd_sc_hd__clkbuf_1
X_13812_ cpuregs\[24\]\[31\] cpuregs\[25\]\[31\] cpuregs\[26\]\[31\] cpuregs\[27\]\[31\]
+ _06443_ _06444_ VGND VGND VPWR VPWR _07280_ sky130_fd_sc_hd__mux4_1
X_16600_ clknet_leaf_106_clk _01167_ VGND VGND VPWR VPWR cpuregs\[9\]\[10\] sky130_fd_sc_hd__dfxtp_1
XFILLER_0_98_753 VGND VGND VPWR VPWR sky130_fd_sc_hd__decap_3
XFILLER_0_97_230 VGND VGND VPWR VPWR sky130_fd_sc_hd__decap_3
X_16531_ clknet_leaf_27_clk _01108_ VGND VGND VPWR VPWR mem_rdata_q\[15\] sky130_fd_sc_hd__dfxtp_1
X_14792_ _01768_ VGND VGND VPWR VPWR _01263_ sky130_fd_sc_hd__clkbuf_1
X_13743_ _06911_ _07212_ VGND VGND VPWR VPWR _07213_ sky130_fd_sc_hd__or2_1
X_10955_ _05058_ VGND VGND VPWR VPWR _00201_ sky130_fd_sc_hd__clkbuf_1
X_13674_ cpuregs\[10\]\[27\] cpuregs\[11\]\[27\] _03347_ VGND VGND VPWR VPWR _07146_
+ sky130_fd_sc_hd__mux2_1
X_16462_ clknet_leaf_54_clk _01044_ VGND VGND VPWR VPWR cpuregs\[18\]\[15\] sky130_fd_sc_hd__dfxtp_1
X_10886_ _05013_ VGND VGND VPWR VPWR _00177_ sky130_fd_sc_hd__clkbuf_1
X_15413_ clknet_leaf_103_clk _00068_ VGND VGND VPWR VPWR cpuregs\[11\]\[31\] sky130_fd_sc_hd__dfxtp_1
XFILLER_0_53_300 VGND VGND VPWR VPWR sky130_fd_sc_hd__decap_8
X_16393_ clknet_leaf_117_clk _00975_ VGND VGND VPWR VPWR net147 sky130_fd_sc_hd__dfxtp_1
X_12625_ count_cycle\[35\] count_cycle\[36\] count_cycle\[37\] _06178_ VGND VGND VPWR
+ VPWR _06186_ sky130_fd_sc_hd__and4_1
XFILLER_0_109_774 VGND VGND VPWR VPWR sky130_fd_sc_hd__fill_2
X_15344_ _03552_ net1209 _02052_ VGND VGND VPWR VPWR _02059_ sky130_fd_sc_hd__mux2_1
X_12556_ _06137_ VGND VGND VPWR VPWR _00723_ sky130_fd_sc_hd__clkbuf_1
X_11507_ _05366_ VGND VGND VPWR VPWR _00445_ sky130_fd_sc_hd__clkbuf_1
XFILLER_0_124_733 VGND VGND VPWR VPWR sky130_fd_sc_hd__fill_2
XFILLER_0_80_152 VGND VGND VPWR VPWR sky130_fd_sc_hd__fill_1
X_12487_ _06005_ _05759_ VGND VGND VPWR VPWR _06087_ sky130_fd_sc_hd__nand2_1
XFILLER_0_124_755 VGND VGND VPWR VPWR sky130_fd_sc_hd__fill_1
X_15275_ net504 VGND VGND VPWR VPWR _02023_ sky130_fd_sc_hd__clkbuf_1
XFILLER_0_81_697 VGND VGND VPWR VPWR sky130_fd_sc_hd__fill_1
XFILLER_0_80_185 VGND VGND VPWR VPWR sky130_fd_sc_hd__decap_8
XFILLER_0_41_528 VGND VGND VPWR VPWR sky130_fd_sc_hd__fill_2
XFILLER_0_123_287 VGND VGND VPWR VPWR sky130_fd_sc_hd__decap_3
X_11438_ net1085 _05213_ _05324_ VGND VGND VPWR VPWR _05330_ sky130_fd_sc_hd__mux2_1
X_14226_ net1624 net105 _07530_ VGND VGND VPWR VPWR _07538_ sky130_fd_sc_hd__mux2_1
Xhold109 cpuregs\[0\]\[13\] VGND VGND VPWR VPWR net467 sky130_fd_sc_hd__dlygate4sd3_1
X_14157_ _05037_ net1379 _07493_ VGND VGND VPWR VPWR _07499_ sky130_fd_sc_hd__mux2_1
X_11369_ _05293_ VGND VGND VPWR VPWR _00380_ sky130_fd_sc_hd__clkbuf_1
XFILLER_0_0_113 VGND VGND VPWR VPWR sky130_fd_sc_hd__decap_3
XFILLER_0_95_15 VGND VGND VPWR VPWR sky130_fd_sc_hd__decap_4
XTAP_414 VGND VPWR sky130_fd_sc_hd__tapvpwrvgnd_1
XTAP_403 VGND VPWR sky130_fd_sc_hd__tapvpwrvgnd_1
X_13108_ _06416_ _06584_ _06597_ _06470_ decoded_imm\[9\] VGND VGND VPWR VPWR _06598_
+ sky130_fd_sc_hd__a32o_1
XFILLER_0_119_33 VGND VGND VPWR VPWR sky130_fd_sc_hd__decap_3
X_14088_ decoded_imm\[0\] _07459_ _07461_ VGND VGND VPWR VPWR _00910_ sky130_fd_sc_hd__o21a_1
XTAP_447 VGND VPWR sky130_fd_sc_hd__tapvpwrvgnd_1
XTAP_436 VGND VPWR sky130_fd_sc_hd__tapvpwrvgnd_1
XTAP_425 VGND VPWR sky130_fd_sc_hd__tapvpwrvgnd_1
XTAP_458 VGND VPWR sky130_fd_sc_hd__tapvpwrvgnd_1
XTAP_469 VGND VPWR sky130_fd_sc_hd__tapvpwrvgnd_1
X_13039_ _06455_ _06526_ _06530_ _06466_ VGND VGND VPWR VPWR _06531_ sky130_fd_sc_hd__o211a_1
X_08580_ _02678_ _02944_ _02951_ _02849_ VGND VGND VPWR VPWR alu_out\[9\] sky130_fd_sc_hd__a22o_1
XFILLER_0_135_54 VGND VGND VPWR VPWR sky130_fd_sc_hd__fill_2
XFILLER_0_44_63 VGND VGND VPWR VPWR sky130_fd_sc_hd__decap_4
X_16729_ clknet_leaf_114_clk _01293_ VGND VGND VPWR VPWR cpuregs\[4\]\[8\] sky130_fd_sc_hd__dfxtp_1
XFILLER_0_8_235 VGND VGND VPWR VPWR sky130_fd_sc_hd__fill_2
X_09201_ _03465_ VGND VGND VPWR VPWR _00040_ sky130_fd_sc_hd__clkbuf_1
XFILLER_0_29_374 VGND VGND VPWR VPWR sky130_fd_sc_hd__fill_2
XFILLER_0_84_491 VGND VGND VPWR VPWR sky130_fd_sc_hd__fill_1
XFILLER_0_60_73 VGND VGND VPWR VPWR sky130_fd_sc_hd__decap_3
XFILLER_0_56_160 VGND VGND VPWR VPWR sky130_fd_sc_hd__decap_8
X_09132_ _03341_ _03408_ _03410_ VGND VGND VPWR VPWR _03411_ sky130_fd_sc_hd__a21o_1
XFILLER_0_56_193 VGND VGND VPWR VPWR sky130_fd_sc_hd__decap_3
XFILLER_0_71_185 VGND VGND VPWR VPWR sky130_fd_sc_hd__fill_2
X_09063_ cpuregs\[30\]\[2\] cpuregs\[31\]\[2\] _03343_ VGND VGND VPWR VPWR _03344_
+ sky130_fd_sc_hd__mux2_1
X_08014_ _02409_ _02412_ VGND VGND VPWR VPWR _02413_ sky130_fd_sc_hd__xnor2_1
Xhold621 cpuregs\[18\]\[3\] VGND VGND VPWR VPWR net979 sky130_fd_sc_hd__dlygate4sd3_1
Xhold610 cpuregs\[22\]\[5\] VGND VGND VPWR VPWR net968 sky130_fd_sc_hd__dlygate4sd3_1
Xhold654 cpuregs\[16\]\[20\] VGND VGND VPWR VPWR net1012 sky130_fd_sc_hd__dlygate4sd3_1
Xhold632 cpuregs\[10\]\[18\] VGND VGND VPWR VPWR net990 sky130_fd_sc_hd__dlygate4sd3_1
Xhold643 cpuregs\[6\]\[19\] VGND VGND VPWR VPWR net1001 sky130_fd_sc_hd__dlygate4sd3_1
Xhold665 cpuregs\[20\]\[27\] VGND VGND VPWR VPWR net1023 sky130_fd_sc_hd__dlygate4sd3_1
Xhold687 cpuregs\[22\]\[25\] VGND VGND VPWR VPWR net1045 sky130_fd_sc_hd__dlygate4sd3_1
Xhold676 cpuregs\[13\]\[21\] VGND VGND VPWR VPWR net1034 sky130_fd_sc_hd__dlygate4sd3_1
XFILLER_0_13_797 VPWR VGND VPWR VGND sky130_ef_sc_hd__decap_12
X_09965_ _04153_ _04158_ _04188_ _02152_ VGND VGND VPWR VPWR _04190_ sky130_fd_sc_hd__a31o_1
Xhold698 cpuregs\[2\]\[4\] VGND VGND VPWR VPWR net1056 sky130_fd_sc_hd__dlygate4sd3_1
X_08916_ _03234_ VGND VGND VPWR VPWR net91 sky130_fd_sc_hd__buf_4
X_09896_ _03766_ _04118_ _04122_ VGND VGND VPWR VPWR _04123_ sky130_fd_sc_hd__a21o_1
XTAP_970 VGND VPWR sky130_fd_sc_hd__tapvpwrvgnd_1
X_08847_ _02742_ _02986_ _03196_ VGND VGND VPWR VPWR _03197_ sky130_fd_sc_hd__a21o_1
XTAP_992 VGND VPWR sky130_fd_sc_hd__tapvpwrvgnd_1
XTAP_981 VGND VPWR sky130_fd_sc_hd__tapvpwrvgnd_1
X_08778_ _02723_ _03109_ _03133_ _03134_ VGND VGND VPWR VPWR alu_out\[24\] sky130_fd_sc_hd__a22o_1
XFILLER_0_79_285 VGND VGND VPWR VPWR sky130_fd_sc_hd__fill_1
XFILLER_0_79_263 VGND VGND VPWR VPWR sky130_fd_sc_hd__decap_3
X_07729_ _02149_ _02150_ VGND VGND VPWR VPWR _02151_ sky130_fd_sc_hd__nand2_1
XFILLER_0_137_302 VGND VGND VPWR VPWR sky130_fd_sc_hd__fill_2
X_10740_ net880 _03564_ _04918_ VGND VGND VPWR VPWR _04927_ sky130_fd_sc_hd__mux2_1
XFILLER_0_67_447 VGND VGND VPWR VPWR sky130_fd_sc_hd__fill_1
X_10671_ _02081_ _04872_ _04873_ _04876_ _02241_ VGND VGND VPWR VPWR _04877_ sky130_fd_sc_hd__a32o_1
XFILLER_0_118_560 VGND VGND VPWR VPWR sky130_fd_sc_hd__fill_1
X_12410_ _05739_ _06016_ _06004_ VGND VGND VPWR VPWR _06017_ sky130_fd_sc_hd__o21a_1
X_13390_ _06699_ _06870_ _06667_ VGND VGND VPWR VPWR _06871_ sky130_fd_sc_hd__a21o_1
X_12341_ _05947_ _05948_ _05950_ _05952_ VGND VGND VPWR VPWR _05954_ sky130_fd_sc_hd__a31oi_2
XFILLER_0_90_483 VGND VGND VPWR VPWR sky130_fd_sc_hd__fill_1
X_12272_ _05878_ _05881_ _05889_ VGND VGND VPWR VPWR _05890_ sky130_fd_sc_hd__or3_1
X_15060_ _01910_ VGND VGND VPWR VPWR _01389_ sky130_fd_sc_hd__clkbuf_1
X_11223_ net1212 _05211_ _05203_ VGND VGND VPWR VPWR _05212_ sky130_fd_sc_hd__mux2_1
X_14011_ _07421_ VGND VGND VPWR VPWR _00885_ sky130_fd_sc_hd__clkbuf_1
XFILLER_0_31_550 VGND VGND VPWR VPWR sky130_fd_sc_hd__fill_1
XFILLER_0_31_561 VGND VGND VPWR VPWR sky130_fd_sc_hd__fill_2
X_11154_ _03455_ VGND VGND VPWR VPWR _05165_ sky130_fd_sc_hd__buf_2
X_10105_ decoded_imm\[15\] net177 VGND VGND VPWR VPWR _04326_ sky130_fd_sc_hd__nand2_1
X_15962_ clknet_leaf_1_clk _00612_ VGND VGND VPWR VPWR count_instr\[31\] sky130_fd_sc_hd__dfxtp_1
X_11085_ _05127_ VGND VGND VPWR VPWR _00262_ sky130_fd_sc_hd__clkbuf_1
X_10036_ _04258_ VGND VGND VPWR VPWR _04259_ sky130_fd_sc_hd__inv_2
X_14913_ _03464_ net1121 _01829_ VGND VGND VPWR VPWR _01833_ sky130_fd_sc_hd__mux2_1
X_15893_ clknet_leaf_64_clk _00543_ VGND VGND VPWR VPWR cpuregs\[20\]\[27\] sky130_fd_sc_hd__dfxtp_1
X_14844_ _01796_ VGND VGND VPWR VPWR _01287_ sky130_fd_sc_hd__clkbuf_1
X_11987_ _05659_ VGND VGND VPWR VPWR _00632_ sky130_fd_sc_hd__clkbuf_1
X_14775_ _01759_ VGND VGND VPWR VPWR _01255_ sky130_fd_sc_hd__clkbuf_1
X_13726_ _06421_ _07194_ _07196_ _06343_ VGND VGND VPWR VPWR _07197_ sky130_fd_sc_hd__a211o_1
XFILLER_0_129_814 VGND VGND VPWR VPWR sky130_fd_sc_hd__decap_3
XFILLER_0_105_57 VGND VGND VPWR VPWR sky130_fd_sc_hd__decap_8
X_10938_ _05048_ VGND VGND VPWR VPWR _00194_ sky130_fd_sc_hd__clkbuf_1
X_16514_ clknet_leaf_93_clk _00035_ VGND VGND VPWR VPWR _00015_ sky130_fd_sc_hd__dfxtp_4
XFILLER_0_85_222 VGND VGND VPWR VPWR sky130_fd_sc_hd__fill_2
X_16445_ clknet_leaf_14_clk _01027_ VGND VGND VPWR VPWR decoded_imm\[2\] sky130_fd_sc_hd__dfxtp_2
X_13657_ _06849_ _07129_ VGND VGND VPWR VPWR _07130_ sky130_fd_sc_hd__or2_1
X_10869_ _05001_ net1406 _04985_ VGND VGND VPWR VPWR _05002_ sky130_fd_sc_hd__mux2_1
XPHY_280 VGND VGND VPWR VPWR sky130_fd_sc_hd__decap_3
XFILLER_0_121_34 VGND VGND VPWR VPWR sky130_fd_sc_hd__fill_1
XFILLER_0_121_23 VGND VGND VPWR VPWR sky130_fd_sc_hd__fill_1
X_13588_ cpuregs\[0\]\[24\] cpuregs\[1\]\[24\] cpuregs\[2\]\[24\] cpuregs\[3\]\[24\]
+ _06456_ _06457_ VGND VGND VPWR VPWR _07063_ sky130_fd_sc_hd__mux4_1
X_16376_ clknet_leaf_26_clk _00958_ VGND VGND VPWR VPWR net160 sky130_fd_sc_hd__dfxtp_1
X_12608_ count_cycle\[32\] _06171_ _05640_ VGND VGND VPWR VPWR _06174_ sky130_fd_sc_hd__a21oi_1
XFILLER_0_124_541 VGND VGND VPWR VPWR sky130_fd_sc_hd__fill_2
XFILLER_0_124_530 VGND VGND VPWR VPWR sky130_fd_sc_hd__fill_2
XFILLER_0_53_163 VGND VGND VPWR VPWR sky130_fd_sc_hd__decap_4
X_12539_ count_cycle\[12\] _06122_ VGND VGND VPWR VPWR _06125_ sky130_fd_sc_hd__or2_1
X_15327_ _03498_ net822 _02041_ VGND VGND VPWR VPWR _02050_ sky130_fd_sc_hd__mux2_1
XFILLER_0_124_585 VGND VGND VPWR VPWR sky130_fd_sc_hd__decap_3
XFILLER_0_111_202 VGND VGND VPWR VPWR sky130_fd_sc_hd__decap_3
X_15258_ _02014_ VGND VGND VPWR VPWR _01483_ sky130_fd_sc_hd__clkbuf_1
X_14209_ net166 net128 _07519_ VGND VGND VPWR VPWR _07529_ sky130_fd_sc_hd__mux2_1
XFILLER_0_22_572 VGND VGND VPWR VPWR sky130_fd_sc_hd__fill_2
XFILLER_0_22_583 VGND VGND VPWR VPWR sky130_fd_sc_hd__decap_4
X_15189_ _03478_ net1174 _01973_ VGND VGND VPWR VPWR _01979_ sky130_fd_sc_hd__mux2_1
X_09750_ cpuregs\[28\]\[5\] cpuregs\[29\]\[5\] _03980_ VGND VGND VPWR VPWR _03981_
+ sky130_fd_sc_hd__mux2_1
X_08701_ _02857_ _03061_ VGND VGND VPWR VPWR _03062_ sky130_fd_sc_hd__or2_1
X_09681_ _03856_ _03857_ _03858_ VGND VGND VPWR VPWR _03913_ sky130_fd_sc_hd__o21ai_2
XTAP_288 VGND VPWR sky130_fd_sc_hd__tapvpwrvgnd_1
XTAP_299 VGND VPWR sky130_fd_sc_hd__tapvpwrvgnd_1
X_08632_ _02922_ _02998_ VGND VGND VPWR VPWR _02999_ sky130_fd_sc_hd__and2_1
X_08563_ _02934_ _02935_ VGND VGND VPWR VPWR _02936_ sky130_fd_sc_hd__nand2_1
X_08494_ _02753_ _02871_ VGND VGND VPWR VPWR _02872_ sky130_fd_sc_hd__xnor2_1
XFILLER_0_18_801 VGND VGND VPWR VPWR sky130_fd_sc_hd__fill_1
XFILLER_0_91_225 VGND VGND VPWR VPWR sky130_fd_sc_hd__fill_1
XFILLER_0_44_130 VGND VGND VPWR VPWR sky130_fd_sc_hd__decap_8
XFILLER_0_17_333 VGND VGND VPWR VPWR sky130_fd_sc_hd__decap_3
X_09115_ _02508_ _03392_ _03394_ _02179_ VGND VGND VPWR VPWR _00005_ sky130_fd_sc_hd__o22a_1
XFILLER_0_5_783 VGND VGND VPWR VPWR sky130_fd_sc_hd__fill_1
XFILLER_0_5_761 VGND VGND VPWR VPWR sky130_fd_sc_hd__fill_1
X_09046_ _03321_ _03326_ VGND VGND VPWR VPWR _03327_ sky130_fd_sc_hd__or2_1
Xhold451 cpuregs\[17\]\[24\] VGND VGND VPWR VPWR net809 sky130_fd_sc_hd__dlygate4sd3_1
Xhold440 cpuregs\[5\]\[19\] VGND VGND VPWR VPWR net798 sky130_fd_sc_hd__dlygate4sd3_1
Xhold462 cpuregs\[24\]\[11\] VGND VGND VPWR VPWR net820 sky130_fd_sc_hd__dlygate4sd3_1
Xhold495 cpuregs\[30\]\[26\] VGND VGND VPWR VPWR net853 sky130_fd_sc_hd__dlygate4sd3_1
Xhold484 cpuregs\[20\]\[24\] VGND VGND VPWR VPWR net842 sky130_fd_sc_hd__dlygate4sd3_1
XFILLER_0_96_80 VGND VGND VPWR VPWR sky130_fd_sc_hd__decap_4
Xhold473 cpuregs\[4\]\[14\] VGND VGND VPWR VPWR net831 sky130_fd_sc_hd__dlygate4sd3_1
X_09948_ _03720_ _04171_ _04173_ VGND VGND VPWR VPWR _04174_ sky130_fd_sc_hd__a21o_1
Xhold1140 cpuregs\[13\]\[28\] VGND VGND VPWR VPWR net1498 sky130_fd_sc_hd__dlygate4sd3_1
X_09879_ _03862_ _04083_ _04106_ VGND VGND VPWR VPWR _04107_ sky130_fd_sc_hd__o21a_1
Xhold1151 cpuregs\[21\]\[4\] VGND VGND VPWR VPWR net1509 sky130_fd_sc_hd__dlygate4sd3_1
Xhold1162 reg_pc\[23\] VGND VGND VPWR VPWR net1520 sky130_fd_sc_hd__dlygate4sd3_1
Xhold1173 cpuregs\[5\]\[15\] VGND VGND VPWR VPWR net1531 sky130_fd_sc_hd__dlygate4sd3_1
Xhold1184 cpuregs\[16\]\[14\] VGND VGND VPWR VPWR net1542 sky130_fd_sc_hd__dlygate4sd3_1
X_12890_ cpuregs\[12\]\[1\] cpuregs\[13\]\[1\] cpuregs\[14\]\[1\] cpuregs\[15\]\[1\]
+ _06386_ _06387_ VGND VGND VPWR VPWR _06388_ sky130_fd_sc_hd__mux4_1
X_11910_ _05602_ _05576_ _05603_ VGND VGND VPWR VPWR _05604_ sky130_fd_sc_hd__and3b_1
XTAP_1900 VGND VPWR sky130_fd_sc_hd__tapvpwrvgnd_1
X_11841_ _05552_ _05530_ _05553_ VGND VGND VPWR VPWR _05554_ sky130_fd_sc_hd__and3b_1
Xhold1195 cpuregs\[9\]\[9\] VGND VGND VPWR VPWR net1553 sky130_fd_sc_hd__dlygate4sd3_1
X_11772_ _05507_ VGND VGND VPWR VPWR _00569_ sky130_fd_sc_hd__clkbuf_1
XTAP_1933 VGND VPWR sky130_fd_sc_hd__tapvpwrvgnd_1
XTAP_1922 VGND VPWR sky130_fd_sc_hd__tapvpwrvgnd_1
XTAP_1911 VGND VPWR sky130_fd_sc_hd__tapvpwrvgnd_1
X_14560_ net1073 _05223_ _01611_ VGND VGND VPWR VPWR _01645_ sky130_fd_sc_hd__mux2_1
XTAP_1977 VGND VPWR sky130_fd_sc_hd__tapvpwrvgnd_1
XTAP_1966 VGND VPWR sky130_fd_sc_hd__tapvpwrvgnd_1
XTAP_1955 VGND VPWR sky130_fd_sc_hd__tapvpwrvgnd_1
XTAP_1944 VGND VPWR sky130_fd_sc_hd__tapvpwrvgnd_1
X_13511_ _06794_ _06988_ VGND VGND VPWR VPWR _06989_ sky130_fd_sc_hd__and2_1
X_10723_ _04906_ VGND VGND VPWR VPWR _04918_ sky130_fd_sc_hd__buf_4
XFILLER_0_67_244 VGND VGND VPWR VPWR sky130_fd_sc_hd__decap_3
X_14491_ _01608_ VGND VGND VPWR VPWR _01090_ sky130_fd_sc_hd__clkbuf_1
XTAP_1999 VGND VPWR sky130_fd_sc_hd__tapvpwrvgnd_1
XTAP_1988 VGND VPWR sky130_fd_sc_hd__tapvpwrvgnd_1
X_10654_ _03837_ _04860_ _03826_ VGND VGND VPWR VPWR _04861_ sky130_fd_sc_hd__a21o_1
X_13442_ cpuregs\[24\]\[19\] cpuregs\[25\]\[19\] cpuregs\[26\]\[19\] cpuregs\[27\]\[19\]
+ _06856_ _06889_ VGND VGND VPWR VPWR _06922_ sky130_fd_sc_hd__mux4_1
X_16230_ clknet_leaf_13_clk alu_out\[3\] VGND VGND VPWR VPWR alu_out_q\[3\] sky130_fd_sc_hd__dfxtp_1
X_16161_ clknet_leaf_36_clk _00779_ VGND VGND VPWR VPWR net64 sky130_fd_sc_hd__dfxtp_1
X_10585_ _04669_ _04685_ _04686_ VGND VGND VPWR VPWR _04793_ sky130_fd_sc_hd__a21bo_1
X_13373_ _06783_ _06852_ _06854_ _06789_ VGND VGND VPWR VPWR _06855_ sky130_fd_sc_hd__a211o_1
X_12324_ _05936_ _05937_ VGND VGND VPWR VPWR _05938_ sky130_fd_sc_hd__nand2_1
X_15112_ _01938_ VGND VGND VPWR VPWR _01413_ sky130_fd_sc_hd__clkbuf_1
X_16092_ clknet_leaf_148_clk _00742_ VGND VGND VPWR VPWR count_cycle\[35\] sky130_fd_sc_hd__dfxtp_1
X_12255_ _05520_ _05874_ VGND VGND VPWR VPWR _05875_ sky130_fd_sc_hd__nand2_1
X_15043_ net923 _05159_ _01901_ VGND VGND VPWR VPWR _01902_ sky130_fd_sc_hd__mux2_1
X_12186_ instr_jal VGND VGND VPWR VPWR _05811_ sky130_fd_sc_hd__buf_4
X_11206_ _03570_ VGND VGND VPWR VPWR _05200_ sky130_fd_sc_hd__buf_2
X_11137_ _05154_ VGND VGND VPWR VPWR _00287_ sky130_fd_sc_hd__clkbuf_1
X_11068_ net650 _03622_ _05110_ VGND VGND VPWR VPWR _05118_ sky130_fd_sc_hd__mux2_1
X_15945_ clknet_leaf_147_clk _00595_ VGND VGND VPWR VPWR count_instr\[14\] sky130_fd_sc_hd__dfxtp_1
X_15876_ clknet_leaf_137_clk _00526_ VGND VGND VPWR VPWR cpuregs\[20\]\[10\] sky130_fd_sc_hd__dfxtp_1
X_10019_ cpuregs\[0\]\[12\] cpuregs\[1\]\[12\] _03980_ VGND VGND VPWR VPWR _04243_
+ sky130_fd_sc_hd__mux2_1
X_14827_ _01786_ VGND VGND VPWR VPWR _01280_ sky130_fd_sc_hd__clkbuf_1
XFILLER_0_116_45 VGND VGND VPWR VPWR sky130_fd_sc_hd__decap_3
XFILLER_0_59_701 VGND VGND VPWR VPWR sky130_fd_sc_hd__fill_1
XFILLER_0_25_54 VGND VGND VPWR VPWR sky130_fd_sc_hd__fill_2
XFILLER_0_86_531 VGND VGND VPWR VPWR sky130_fd_sc_hd__fill_1
XFILLER_0_59_745 VGND VGND VPWR VPWR sky130_fd_sc_hd__decap_3
X_14758_ _05041_ net1638 _01742_ VGND VGND VPWR VPWR _01750_ sky130_fd_sc_hd__mux2_1
X_13709_ _06970_ _07179_ VGND VGND VPWR VPWR _07180_ sky130_fd_sc_hd__and2_1
X_14689_ _01713_ VGND VGND VPWR VPWR _01215_ sky130_fd_sc_hd__clkbuf_1
XFILLER_0_73_225 VGND VGND VPWR VPWR sky130_fd_sc_hd__fill_1
XFILLER_0_27_620 VGND VGND VPWR VPWR sky130_fd_sc_hd__fill_2
XFILLER_0_128_165 VPWR VGND VPWR VGND sky130_ef_sc_hd__decap_12
X_16428_ clknet_leaf_30_clk net1620 VGND VGND VPWR VPWR decoded_imm\[19\] sky130_fd_sc_hd__dfxtp_2
XFILLER_0_132_809 VGND VGND VPWR VPWR sky130_fd_sc_hd__decap_3
XFILLER_0_132_99 VGND VGND VPWR VPWR sky130_fd_sc_hd__fill_1
XFILLER_0_116_349 VGND VGND VPWR VPWR sky130_fd_sc_hd__fill_1
X_16359_ clknet_leaf_59_clk _00941_ VGND VGND VPWR VPWR cpuregs\[1\]\[24\] sky130_fd_sc_hd__dfxtp_1
XFILLER_0_26_141 VGND VGND VPWR VPWR sky130_fd_sc_hd__decap_6
XFILLER_0_2_742 VPWR VGND VPWR VGND sky130_ef_sc_hd__decap_12
XFILLER_0_1_252 VGND VGND VPWR VPWR sky130_fd_sc_hd__fill_2
XFILLER_0_10_531 VGND VGND VPWR VPWR sky130_fd_sc_hd__fill_1
XFILLER_0_22_391 VGND VGND VPWR VPWR sky130_fd_sc_hd__decap_6
X_09802_ _03690_ _04031_ _03657_ VGND VGND VPWR VPWR _04032_ sky130_fd_sc_hd__o21a_1
X_07994_ _02197_ _02388_ _02390_ _02222_ _02394_ VGND VGND VPWR VPWR _07621_ sky130_fd_sc_hd__a221o_1
XFILLER_0_5_64 VGND VGND VPWR VPWR sky130_fd_sc_hd__decap_8
Xfanout249 net126 VGND VGND VPWR VPWR net249 sky130_fd_sc_hd__buf_4
X_09733_ _03834_ _03961_ _03963_ VGND VGND VPWR VPWR _03964_ sky130_fd_sc_hd__a21o_1
X_09664_ _03719_ VGND VGND VPWR VPWR _03897_ sky130_fd_sc_hd__clkbuf_8
X_08615_ _02977_ _02983_ VGND VGND VPWR VPWR _02984_ sky130_fd_sc_hd__or2_1
XFILLER_0_96_306 VGND VGND VPWR VPWR sky130_fd_sc_hd__fill_2
X_09595_ _03658_ VGND VGND VPWR VPWR _03829_ sky130_fd_sc_hd__clkbuf_8
XTAP_1229 VGND VPWR sky130_fd_sc_hd__tapvpwrvgnd_1
XTAP_1218 VGND VPWR sky130_fd_sc_hd__tapvpwrvgnd_1
XTAP_1207 VGND VPWR sky130_fd_sc_hd__tapvpwrvgnd_1
X_08546_ _02662_ _02895_ _02919_ VGND VGND VPWR VPWR _02920_ sky130_fd_sc_hd__a21o_1
XFILLER_0_49_266 VPWR VGND VPWR VGND sky130_ef_sc_hd__decap_12
XFILLER_0_49_255 VGND VGND VPWR VPWR sky130_fd_sc_hd__fill_1
X_08477_ _02840_ VGND VGND VPWR VPWR _02857_ sky130_fd_sc_hd__clkbuf_4
XFILLER_0_80_707 VGND VGND VPWR VPWR sky130_fd_sc_hd__fill_1
XFILLER_0_64_247 VGND VGND VPWR VPWR sky130_fd_sc_hd__fill_2
XFILLER_0_107_349 VGND VGND VPWR VPWR sky130_fd_sc_hd__fill_2
XFILLER_0_92_589 VGND VGND VPWR VPWR sky130_fd_sc_hd__decap_3
XFILLER_0_17_163 VGND VGND VPWR VPWR sky130_fd_sc_hd__fill_1
XFILLER_0_134_179 VGND VGND VPWR VPWR sky130_fd_sc_hd__fill_2
XFILLER_0_134_168 VGND VGND VPWR VPWR sky130_fd_sc_hd__decap_3
XFILLER_0_45_483 VGND VGND VPWR VPWR sky130_fd_sc_hd__fill_1
XFILLER_0_17_185 VGND VGND VPWR VPWR sky130_fd_sc_hd__decap_8
XFILLER_0_115_382 VGND VGND VPWR VPWR sky130_fd_sc_hd__fill_1
XFILLER_0_103_533 VGND VGND VPWR VPWR sky130_fd_sc_hd__fill_2
XFILLER_0_103_522 VGND VGND VPWR VPWR sky130_fd_sc_hd__fill_2
X_10370_ _02522_ _02548_ _03997_ VGND VGND VPWR VPWR _04584_ sky130_fd_sc_hd__mux2_1
XFILLER_0_21_807 VGND VGND VPWR VPWR sky130_fd_sc_hd__fill_2
XFILLER_0_21_818 VGND VGND VPWR VPWR sky130_fd_sc_hd__fill_1
XFILLER_0_33_667 VGND VGND VPWR VPWR sky130_fd_sc_hd__fill_2
X_09029_ _00009_ VGND VGND VPWR VPWR _03310_ sky130_fd_sc_hd__clkinv_4
XFILLER_0_130_374 VGND VGND VPWR VPWR sky130_fd_sc_hd__fill_1
Xhold270 cpuregs\[17\]\[17\] VGND VGND VPWR VPWR net628 sky130_fd_sc_hd__dlygate4sd3_1
X_12040_ _03458_ reg_next_pc\[3\] _03221_ VGND VGND VPWR VPWR _05698_ sky130_fd_sc_hd__mux2_1
Xhold292 cpuregs\[28\]\[27\] VGND VGND VPWR VPWR net650 sky130_fd_sc_hd__dlygate4sd3_1
Xhold281 cpuregs\[24\]\[24\] VGND VGND VPWR VPWR net639 sky130_fd_sc_hd__dlygate4sd3_1
X_13991_ is_alu_reg_imm _07359_ _07342_ VGND VGND VPWR VPWR _07407_ sky130_fd_sc_hd__and3_1
X_15730_ clknet_leaf_58_clk _00380_ VGND VGND VPWR VPWR cpuregs\[21\]\[24\] sky130_fd_sc_hd__dfxtp_1
XFILLER_0_99_133 VGND VGND VPWR VPWR sky130_fd_sc_hd__fill_2
X_12942_ _06434_ _06435_ VGND VGND VPWR VPWR _06436_ sky130_fd_sc_hd__and2_1
XFILLER_0_87_328 VGND VGND VPWR VPWR sky130_fd_sc_hd__decap_8
XFILLER_0_87_306 VGND VGND VPWR VPWR sky130_fd_sc_hd__decap_8
X_15661_ clknet_leaf_94_clk _00311_ VGND VGND VPWR VPWR cpuregs\[14\]\[19\] sky130_fd_sc_hd__dfxtp_1
X_14612_ _05031_ net1461 _01670_ VGND VGND VPWR VPWR _01673_ sky130_fd_sc_hd__mux2_1
XANTENNA_132 net22 VGND VGND VPWR VPWR sky130_fd_sc_hd__diode_2
XANTENNA_143 net126 VGND VGND VPWR VPWR sky130_fd_sc_hd__diode_2
XANTENNA_110 net218 VGND VGND VPWR VPWR sky130_fd_sc_hd__diode_2
X_12873_ _06341_ _06361_ _06371_ _03360_ VGND VGND VPWR VPWR _06372_ sky130_fd_sc_hd__o211a_1
XANTENNA_121 _02751_ VGND VGND VPWR VPWR sky130_fd_sc_hd__diode_2
XTAP_1741 VGND VPWR sky130_fd_sc_hd__tapvpwrvgnd_1
XTAP_1752 VGND VPWR sky130_fd_sc_hd__tapvpwrvgnd_1
XTAP_1730 VGND VPWR sky130_fd_sc_hd__tapvpwrvgnd_1
XANTENNA_154 reg_next_pc\[15\] VGND VGND VPWR VPWR sky130_fd_sc_hd__diode_2
X_15592_ clknet_leaf_97_clk _00242_ VGND VGND VPWR VPWR cpuregs\[28\]\[14\] sky130_fd_sc_hd__dfxtp_1
X_11824_ net452 _05536_ _05541_ VGND VGND VPWR VPWR _00587_ sky130_fd_sc_hd__o21a_1
XANTENNA_165 net120 VGND VGND VPWR VPWR sky130_fd_sc_hd__diode_2
XFILLER_0_138_430 VGND VGND VPWR VPWR sky130_fd_sc_hd__fill_2
X_14543_ _01636_ VGND VGND VPWR VPWR _01146_ sky130_fd_sc_hd__clkbuf_1
XTAP_1785 VGND VPWR sky130_fd_sc_hd__tapvpwrvgnd_1
XTAP_1774 VGND VPWR sky130_fd_sc_hd__tapvpwrvgnd_1
XTAP_1763 VGND VPWR sky130_fd_sc_hd__tapvpwrvgnd_1
X_11755_ _05498_ VGND VGND VPWR VPWR _00561_ sky130_fd_sc_hd__clkbuf_1
XFILLER_0_55_225 VGND VGND VPWR VPWR sky130_fd_sc_hd__decap_8
XFILLER_0_55_203 VGND VGND VPWR VPWR sky130_fd_sc_hd__decap_6
X_14474_ net756 _05205_ _01598_ VGND VGND VPWR VPWR _01600_ sky130_fd_sc_hd__mux2_1
XFILLER_0_126_636 VGND VGND VPWR VPWR sky130_fd_sc_hd__fill_1
XTAP_1796 VGND VPWR sky130_fd_sc_hd__tapvpwrvgnd_1
X_10706_ _04909_ VGND VGND VPWR VPWR _00101_ sky130_fd_sc_hd__clkbuf_1
X_16213_ clknet_leaf_52_clk _00830_ VGND VGND VPWR VPWR net219 sky130_fd_sc_hd__dfxtp_4
X_13425_ _06866_ _06900_ _06904_ _06873_ VGND VGND VPWR VPWR _06905_ sky130_fd_sc_hd__o211a_1
X_11686_ net636 _05188_ _05458_ VGND VGND VPWR VPWR _05462_ sky130_fd_sc_hd__mux2_1
X_10637_ _04116_ _04839_ _04843_ _04063_ VGND VGND VPWR VPWR _04844_ sky130_fd_sc_hd__o211a_1
XFILLER_0_106_360 VGND VGND VPWR VPWR sky130_fd_sc_hd__fill_1
XFILLER_0_24_645 VGND VGND VPWR VPWR sky130_fd_sc_hd__fill_2
X_10568_ cpuregs\[30\]\[27\] cpuregs\[31\]\[27\] _03835_ VGND VGND VPWR VPWR _04777_
+ sky130_fd_sc_hd__mux2_1
X_16144_ clknet_leaf_30_clk _07632_ VGND VGND VPWR VPWR reg_out\[22\] sky130_fd_sc_hd__dfxtp_1
X_13356_ _06537_ _06835_ _06837_ VGND VGND VPWR VPWR _06838_ sky130_fd_sc_hd__a21o_1
XFILLER_0_11_306 VGND VGND VPWR VPWR sky130_fd_sc_hd__fill_1
X_10499_ cpuregs\[24\]\[25\] cpuregs\[25\]\[25\] cpuregs\[26\]\[25\] cpuregs\[27\]\[25\]
+ _03666_ _03669_ VGND VGND VPWR VPWR _04710_ sky130_fd_sc_hd__mux4_1
X_12307_ _05737_ net1655 VGND VGND VPWR VPWR _05923_ sky130_fd_sc_hd__or2_1
XFILLER_0_87_38 VGND VGND VPWR VPWR sky130_fd_sc_hd__decap_4
X_13287_ cpuregs\[4\]\[15\] cpuregs\[5\]\[15\] _06575_ VGND VGND VPWR VPWR _06771_
+ sky130_fd_sc_hd__mux2_1
X_16075_ clknet_leaf_150_clk _00725_ VGND VGND VPWR VPWR count_cycle\[18\] sky130_fd_sc_hd__dfxtp_1
X_15026_ _01892_ VGND VGND VPWR VPWR _01373_ sky130_fd_sc_hd__clkbuf_1
X_12238_ decoded_imm_j\[9\] _05710_ VGND VGND VPWR VPWR _05859_ sky130_fd_sc_hd__xnor2_1
X_12169_ _05793_ _05794_ VGND VGND VPWR VPWR _05795_ sky130_fd_sc_hd__and2_1
X_16977_ clknet_leaf_6_clk _01541_ VGND VGND VPWR VPWR net134 sky130_fd_sc_hd__dfxtp_2
Xinput5 mem_rdata[13] VGND VGND VPWR VPWR net5 sky130_fd_sc_hd__buf_2
X_15928_ clknet_leaf_53_clk _00578_ VGND VGND VPWR VPWR cpuregs\[17\]\[30\] sky130_fd_sc_hd__dfxtp_1
X_15859_ clknet_leaf_65_clk _00509_ VGND VGND VPWR VPWR cpuregs\[25\]\[25\] sky130_fd_sc_hd__dfxtp_1
XFILLER_0_78_339 VGND VGND VPWR VPWR sky130_fd_sc_hd__fill_1
X_08400_ net249 VGND VGND VPWR VPWR _02781_ sky130_fd_sc_hd__inv_2
X_09380_ _03546_ _03618_ _03619_ _03620_ VGND VGND VPWR VPWR _03621_ sky130_fd_sc_hd__a22o_2
X_08331_ net181 net213 VGND VGND VPWR VPWR _02712_ sky130_fd_sc_hd__or2_1
XFILLER_0_117_625 VGND VGND VPWR VPWR sky130_fd_sc_hd__fill_2
XFILLER_0_117_614 VGND VGND VPWR VPWR sky130_fd_sc_hd__fill_2
X_08262_ _02148_ _02644_ VGND VGND VPWR VPWR _02645_ sky130_fd_sc_hd__nand2_1
XFILLER_0_52_85 VGND VGND VPWR VPWR sky130_fd_sc_hd__decap_3
XFILLER_0_6_300 VGND VGND VPWR VPWR sky130_fd_sc_hd__fill_1
X_08193_ _02576_ _02577_ _02580_ _02268_ VGND VGND VPWR VPWR _02581_ sky130_fd_sc_hd__o211ai_1
XFILLER_0_14_100 VGND VGND VPWR VPWR sky130_fd_sc_hd__decap_4
XFILLER_0_113_831 VGND VGND VPWR VPWR sky130_fd_sc_hd__fill_1
XFILLER_0_70_751 VGND VGND VPWR VPWR sky130_fd_sc_hd__decap_4
XFILLER_0_100_547 VGND VGND VPWR VPWR sky130_fd_sc_hd__fill_1
XFILLER_0_77_60 VGND VGND VPWR VPWR sky130_fd_sc_hd__fill_1
X_07977_ _02224_ _02133_ net20 net3 _02210_ VGND VGND VPWR VPWR _02379_ sky130_fd_sc_hd__a32o_1
X_09716_ _03862_ _03918_ _03947_ VGND VGND VPWR VPWR _03948_ sky130_fd_sc_hd__o21a_1
X_09647_ _00012_ VGND VGND VPWR VPWR _03880_ sky130_fd_sc_hd__buf_6
XTAP_1004 VGND VPWR sky130_fd_sc_hd__tapvpwrvgnd_1
XFILLER_0_84_309 VGND VGND VPWR VPWR sky130_fd_sc_hd__decap_4
XTAP_1037 VGND VPWR sky130_fd_sc_hd__tapvpwrvgnd_1
XTAP_1026 VGND VPWR sky130_fd_sc_hd__tapvpwrvgnd_1
XTAP_1015 VGND VPWR sky130_fd_sc_hd__tapvpwrvgnd_1
X_09578_ cpuregs\[6\]\[2\] cpuregs\[7\]\[2\] _03797_ VGND VGND VPWR VPWR _03812_ sky130_fd_sc_hd__mux2_1
X_08529_ _02903_ _02904_ VGND VGND VPWR VPWR _02905_ sky130_fd_sc_hd__xnor2_1
XTAP_1059 VGND VPWR sky130_fd_sc_hd__tapvpwrvgnd_1
XTAP_1048 VGND VPWR sky130_fd_sc_hd__tapvpwrvgnd_1
X_11540_ _05384_ VGND VGND VPWR VPWR _00460_ sky130_fd_sc_hd__clkbuf_1
XFILLER_0_25_409 VGND VGND VPWR VPWR sky130_fd_sc_hd__fill_1
XFILLER_0_123_617 VGND VGND VPWR VPWR sky130_fd_sc_hd__fill_2
X_11471_ _05347_ VGND VGND VPWR VPWR _00428_ sky130_fd_sc_hd__clkbuf_1
X_10422_ _03818_ _04630_ _04634_ _03829_ VGND VGND VPWR VPWR _04635_ sky130_fd_sc_hd__o211a_1
X_14190_ _07518_ VGND VGND VPWR VPWR _07519_ sky130_fd_sc_hd__buf_12
X_13210_ _03313_ VGND VGND VPWR VPWR _06696_ sky130_fd_sc_hd__buf_4
X_10353_ cpuregs\[30\]\[21\] cpuregs\[31\]\[21\] _03835_ VGND VGND VPWR VPWR _04568_
+ sky130_fd_sc_hd__mux2_1
X_13141_ _06628_ net247 _06629_ VGND VGND VPWR VPWR _06630_ sky130_fd_sc_hd__mux2_1
XFILLER_0_21_615 VGND VGND VPWR VPWR sky130_fd_sc_hd__fill_1
X_13072_ _03310_ VGND VGND VPWR VPWR _06563_ sky130_fd_sc_hd__buf_4
X_16900_ clknet_leaf_91_clk _01464_ VGND VGND VPWR VPWR cpuregs\[8\]\[19\] sky130_fd_sc_hd__dfxtp_1
X_10284_ cpuregs\[28\]\[19\] cpuregs\[29\]\[19\] _03768_ VGND VGND VPWR VPWR _04501_
+ sky130_fd_sc_hd__mux2_1
X_12023_ net402 _05680_ _05684_ VGND VGND VPWR VPWR _00643_ sky130_fd_sc_hd__o21a_1
X_16831_ clknet_leaf_105_clk _01395_ VGND VGND VPWR VPWR cpuregs\[7\]\[14\] sky130_fd_sc_hd__dfxtp_1
X_16762_ clknet_leaf_110_clk _01326_ VGND VGND VPWR VPWR cpuregs\[5\]\[9\] sky130_fd_sc_hd__dfxtp_1
X_13974_ _07377_ _07395_ VGND VGND VPWR VPWR _07396_ sky130_fd_sc_hd__and2_1
X_15713_ clknet_leaf_129_clk _00363_ VGND VGND VPWR VPWR cpuregs\[21\]\[7\] sky130_fd_sc_hd__dfxtp_1
XFILLER_0_87_125 VGND VGND VPWR VPWR sky130_fd_sc_hd__fill_2
X_12925_ _06345_ VGND VGND VPWR VPWR _06419_ sky130_fd_sc_hd__buf_4
X_16693_ clknet_leaf_112_clk _01260_ VGND VGND VPWR VPWR cpuregs\[3\]\[7\] sky130_fd_sc_hd__dfxtp_1
XTAP_2261 VGND VPWR sky130_fd_sc_hd__tapvpwrvgnd_1
XTAP_2250 VGND VPWR sky130_fd_sc_hd__tapvpwrvgnd_1
X_12856_ cpuregs\[24\]\[0\] cpuregs\[25\]\[0\] cpuregs\[26\]\[0\] cpuregs\[27\]\[0\]
+ _03323_ _03325_ VGND VGND VPWR VPWR _06355_ sky130_fd_sc_hd__mux4_1
X_15644_ clknet_leaf_131_clk _00294_ VGND VGND VPWR VPWR cpuregs\[14\]\[2\] sky130_fd_sc_hd__dfxtp_1
XTAP_2294 VGND VPWR sky130_fd_sc_hd__tapvpwrvgnd_1
XTAP_2283 VGND VPWR sky130_fd_sc_hd__tapvpwrvgnd_1
X_15575_ clknet_leaf_67_clk _00225_ VGND VGND VPWR VPWR cpuregs\[2\]\[29\] sky130_fd_sc_hd__dfxtp_1
XTAP_2272 VGND VPWR sky130_fd_sc_hd__tapvpwrvgnd_1
XFILLER_0_96_681 VGND VGND VPWR VPWR sky130_fd_sc_hd__fill_1
XTAP_1560 VGND VPWR sky130_fd_sc_hd__tapvpwrvgnd_1
X_11807_ net1606 _05525_ _05528_ VGND VGND VPWR VPWR _00583_ sky130_fd_sc_hd__o21a_1
X_12787_ net39 net70 _06302_ VGND VGND VPWR VPWR _06308_ sky130_fd_sc_hd__mux2_1
XFILLER_0_95_191 VGND VGND VPWR VPWR sky130_fd_sc_hd__decap_4
XTAP_1593 VGND VPWR sky130_fd_sc_hd__tapvpwrvgnd_1
XTAP_1582 VGND VPWR sky130_fd_sc_hd__tapvpwrvgnd_1
XTAP_1571 VGND VPWR sky130_fd_sc_hd__tapvpwrvgnd_1
X_14526_ _01627_ VGND VGND VPWR VPWR _01138_ sky130_fd_sc_hd__clkbuf_1
X_11738_ _05489_ VGND VGND VPWR VPWR _00553_ sky130_fd_sc_hd__clkbuf_1
X_14457_ net1043 _05188_ _01587_ VGND VGND VPWR VPWR _01591_ sky130_fd_sc_hd__mux2_1
X_11669_ net1154 _05171_ _05447_ VGND VGND VPWR VPWR _05453_ sky130_fd_sc_hd__mux2_1
XFILLER_0_43_228 VGND VGND VPWR VPWR sky130_fd_sc_hd__decap_8
XFILLER_0_113_116 VGND VGND VPWR VPWR sky130_fd_sc_hd__decap_6
X_13408_ _03330_ VGND VGND VPWR VPWR _06889_ sky130_fd_sc_hd__buf_4
X_14388_ _01554_ VGND VGND VPWR VPWR _01041_ sky130_fd_sc_hd__clkbuf_1
XFILLER_0_106_190 VGND VGND VPWR VPWR sky130_fd_sc_hd__decap_6
X_13339_ cpuregs\[22\]\[16\] cpuregs\[23\]\[16\] _06786_ VGND VGND VPWR VPWR _06822_
+ sky130_fd_sc_hd__mux2_1
X_16127_ clknet_leaf_11_clk _07645_ VGND VGND VPWR VPWR reg_out\[5\] sky130_fd_sc_hd__dfxtp_1
Xpicorv32_269 VGND VGND VPWR VPWR picorv32_269/HI eoi[16] sky130_fd_sc_hd__conb_1
XFILLER_0_122_672 VGND VGND VPWR VPWR sky130_fd_sc_hd__fill_1
Xpicorv32_258 VGND VGND VPWR VPWR picorv32_258/HI eoi[5] sky130_fd_sc_hd__conb_1
X_16058_ clknet_leaf_150_clk _00708_ VGND VGND VPWR VPWR count_cycle\[1\] sky130_fd_sc_hd__dfxtp_1
X_15009_ _01883_ VGND VGND VPWR VPWR _01365_ sky130_fd_sc_hd__clkbuf_1
X_08880_ _03215_ VGND VGND VPWR VPWR net106 sky130_fd_sc_hd__buf_2
X_07900_ _02305_ _02306_ VGND VGND VPWR VPWR _02307_ sky130_fd_sc_hd__nor2_1
XFILLER_0_138_54 VPWR VGND VPWR VGND sky130_ef_sc_hd__decap_12
X_07831_ _02241_ VGND VGND VPWR VPWR _02242_ sky130_fd_sc_hd__buf_4
X_09501_ _03720_ _03735_ VGND VGND VPWR VPWR _03736_ sky130_fd_sc_hd__nor2_1
XFILLER_0_2_21 VGND VGND VPWR VPWR sky130_fd_sc_hd__decap_6
X_07762_ is_jalr_addi_slti_sltiu_xori_ori_andi is_lui_auipc_jal VGND VGND VPWR VPWR
+ _02180_ sky130_fd_sc_hd__or2_1
X_07693_ _02119_ VGND VGND VPWR VPWR _00001_ sky130_fd_sc_hd__buf_1
XFILLER_0_66_309 VGND VGND VPWR VPWR sky130_fd_sc_hd__fill_1
X_09432_ _00013_ VGND VGND VPWR VPWR _03668_ sky130_fd_sc_hd__buf_4
X_09363_ reg_pc\[24\] reg_pc\[23\] _03588_ reg_pc\[25\] VGND VGND VPWR VPWR _03606_
+ sky130_fd_sc_hd__a31o_1
XPHY_109 VGND VGND VPWR VPWR sky130_fd_sc_hd__decap_3
X_08314_ _02693_ _02694_ VGND VGND VPWR VPWR _02695_ sky130_fd_sc_hd__nand2_1
XFILLER_0_19_225 VGND VGND VPWR VPWR sky130_fd_sc_hd__fill_2
X_09294_ _03433_ VGND VGND VPWR VPWR _03546_ sky130_fd_sc_hd__clkbuf_4
XANTENNA_32 _06833_ VGND VGND VPWR VPWR sky130_fd_sc_hd__diode_2
XANTENNA_21 _03929_ VGND VGND VPWR VPWR sky130_fd_sc_hd__diode_2
XANTENNA_10 _03648_ VGND VGND VPWR VPWR sky130_fd_sc_hd__diode_2
X_08245_ _02614_ _02617_ _02616_ VGND VGND VPWR VPWR _02629_ sky130_fd_sc_hd__o21ai_1
XANTENNA_54 net56 VGND VGND VPWR VPWR sky130_fd_sc_hd__diode_2
XANTENNA_65 net79 VGND VGND VPWR VPWR sky130_fd_sc_hd__diode_2
XANTENNA_43 net28 VGND VGND VPWR VPWR sky130_fd_sc_hd__diode_2
XANTENNA_87 net119 VGND VGND VPWR VPWR sky130_fd_sc_hd__diode_2
XANTENNA_98 net174 VGND VGND VPWR VPWR sky130_fd_sc_hd__diode_2
XFILLER_0_132_425 VGND VGND VPWR VPWR sky130_fd_sc_hd__fill_1
X_08176_ _02558_ net239 _02560_ _02561_ _02562_ VGND VGND VPWR VPWR _02565_ sky130_fd_sc_hd__o311ai_4
XANTENNA_76 net101 VGND VGND VPWR VPWR sky130_fd_sc_hd__diode_2
Xoutput150 net150 VGND VGND VPWR VPWR mem_wdata[23] sky130_fd_sc_hd__clkbuf_4
XFILLER_0_2_380 VGND VGND VPWR VPWR sky130_fd_sc_hd__fill_1
Xoutput161 net161 VGND VGND VPWR VPWR mem_wdata[4] sky130_fd_sc_hd__clkbuf_4
Xoutput172 net172 VGND VGND VPWR VPWR pcpi_rs1[10] sky130_fd_sc_hd__clkbuf_4
XFILLER_0_100_377 VGND VGND VPWR VPWR sky130_fd_sc_hd__fill_1
Xoutput194 net194 VGND VGND VPWR VPWR pcpi_rs1[30] sky130_fd_sc_hd__clkbuf_4
Xoutput183 net183 VGND VGND VPWR VPWR pcpi_rs1[20] sky130_fd_sc_hd__clkbuf_4
X_10971_ _05012_ net1317 _05063_ VGND VGND VPWR VPWR _05067_ sky130_fd_sc_hd__mux2_1
X_13690_ _07013_ _07161_ VGND VGND VPWR VPWR _07162_ sky130_fd_sc_hd__and2_1
XFILLER_0_69_169 VGND VGND VPWR VPWR sky130_fd_sc_hd__decap_6
X_12710_ count_cycle\[61\] _06245_ VGND VGND VPWR VPWR _06247_ sky130_fd_sc_hd__and2_1
X_12641_ count_cycle\[41\] count_cycle\[42\] _06193_ VGND VGND VPWR VPWR _06197_ sky130_fd_sc_hd__and3_1
XFILLER_0_127_219 VGND VGND VPWR VPWR sky130_fd_sc_hd__decap_4
X_15360_ _02067_ VGND VGND VPWR VPWR _01532_ sky130_fd_sc_hd__clkbuf_1
XFILLER_0_81_813 VGND VGND VPWR VPWR sky130_fd_sc_hd__fill_1
X_12572_ net502 _06145_ _05526_ VGND VGND VPWR VPWR _06149_ sky130_fd_sc_hd__o21ai_1
XFILLER_0_26_718 VGND VGND VPWR VPWR sky130_fd_sc_hd__fill_2
XFILLER_0_38_589 VGND VGND VPWR VPWR sky130_fd_sc_hd__fill_1
X_15291_ net450 VGND VGND VPWR VPWR _02031_ sky130_fd_sc_hd__clkbuf_1
XFILLER_0_135_241 VGND VGND VPWR VPWR sky130_fd_sc_hd__fill_1
XFILLER_0_123_403 VPWR VGND VPWR VGND sky130_ef_sc_hd__decap_12
XFILLER_0_108_466 VGND VGND VPWR VPWR sky130_fd_sc_hd__fill_1
XFILLER_0_92_172 VGND VGND VPWR VPWR sky130_fd_sc_hd__fill_1
X_14311_ net827 _07576_ VGND VGND VPWR VPWR _07586_ sky130_fd_sc_hd__and2_1
XFILLER_0_65_386 VGND VGND VPWR VPWR sky130_fd_sc_hd__decap_6
X_11523_ _04981_ net1494 _05375_ VGND VGND VPWR VPWR _05376_ sky130_fd_sc_hd__mux2_1
XFILLER_0_18_280 VGND VGND VPWR VPWR sky130_fd_sc_hd__fill_1
XFILLER_0_25_228 VGND VGND VPWR VPWR sky130_fd_sc_hd__decap_4
XFILLER_0_135_263 VGND VGND VPWR VPWR sky130_fd_sc_hd__fill_1
XFILLER_0_108_499 VGND VGND VPWR VPWR sky130_fd_sc_hd__fill_1
X_14242_ _07546_ VGND VGND VPWR VPWR _00979_ sky130_fd_sc_hd__clkbuf_1
X_11454_ net1106 _05159_ _05338_ VGND VGND VPWR VPWR _05339_ sky130_fd_sc_hd__mux2_1
XFILLER_0_123_458 VGND VGND VPWR VPWR sky130_fd_sc_hd__decap_8
X_10405_ cpuregs\[14\]\[23\] cpuregs\[15\]\[23\] _03801_ VGND VGND VPWR VPWR _04618_
+ sky130_fd_sc_hd__mux2_1
XFILLER_0_21_401 VGND VGND VPWR VPWR sky130_fd_sc_hd__fill_2
X_14173_ _02149_ _02120_ _07358_ _05768_ VGND VGND VPWR VPWR _00951_ sky130_fd_sc_hd__o211a_1
X_11385_ _05301_ VGND VGND VPWR VPWR _05302_ sky130_fd_sc_hd__clkbuf_8
X_10336_ _04045_ _04550_ _04121_ VGND VGND VPWR VPWR _04551_ sky130_fd_sc_hd__a21o_1
X_13124_ _03307_ _06605_ _06612_ VGND VGND VPWR VPWR _06613_ sky130_fd_sc_hd__or3_2
XTAP_607 VGND VPWR sky130_fd_sc_hd__tapvpwrvgnd_1
X_10267_ _03670_ _04481_ _04483_ VGND VGND VPWR VPWR _04484_ sky130_fd_sc_hd__a21o_1
XTAP_618 VGND VPWR sky130_fd_sc_hd__tapvpwrvgnd_1
XTAP_629 VGND VPWR sky130_fd_sc_hd__tapvpwrvgnd_1
X_13055_ cpuregs\[6\]\[8\] cpuregs\[7\]\[8\] _06511_ VGND VGND VPWR VPWR _06546_ sky130_fd_sc_hd__mux2_1
Xclkbuf_4_9_0_clk clknet_0_clk VGND VGND VPWR VPWR clknet_4_9_0_clk sky130_fd_sc_hd__clkbuf_8
X_12006_ count_instr\[57\] _05671_ _05640_ VGND VGND VPWR VPWR _05673_ sky130_fd_sc_hd__a21oi_1
X_10198_ cpuregs\[0\]\[17\] cpuregs\[1\]\[17\] _03664_ VGND VGND VPWR VPWR _04417_
+ sky130_fd_sc_hd__mux2_1
XFILLER_0_17_11 VGND VGND VPWR VPWR sky130_fd_sc_hd__decap_3
X_16814_ clknet_leaf_70_clk _01378_ VGND VGND VPWR VPWR cpuregs\[6\]\[29\] sky130_fd_sc_hd__dfxtp_1
X_16745_ clknet_leaf_92_clk _01309_ VGND VGND VPWR VPWR cpuregs\[4\]\[24\] sky130_fd_sc_hd__dfxtp_1
X_13957_ net473 _07359_ _07342_ net242 _07383_ VGND VGND VPWR VPWR _00869_ sky130_fd_sc_hd__a41o_1
X_16676_ clknet_leaf_60_clk _01243_ VGND VGND VPWR VPWR cpuregs\[29\]\[22\] sky130_fd_sc_hd__dfxtp_1
X_12908_ decoded_imm\[1\] _06405_ _02171_ VGND VGND VPWR VPWR _06406_ sky130_fd_sc_hd__mux2_1
XFILLER_0_69_670 VGND VGND VPWR VPWR sky130_fd_sc_hd__fill_2
X_15627_ clknet_leaf_99_clk _00277_ VGND VGND VPWR VPWR cpuregs\[31\]\[17\] sky130_fd_sc_hd__dfxtp_1
X_13888_ mem_rdata_q\[13\] mem_rdata_q\[12\] _07327_ VGND VGND VPWR VPWR _07338_ sky130_fd_sc_hd__nor3b_1
XFILLER_0_130_3 VGND VGND VPWR VPWR sky130_fd_sc_hd__decap_8
XFILLER_0_124_89 VGND VGND VPWR VPWR sky130_fd_sc_hd__fill_1
XTAP_2091 VGND VPWR sky130_fd_sc_hd__tapvpwrvgnd_1
XTAP_2080 VGND VPWR sky130_fd_sc_hd__tapvpwrvgnd_1
XFILLER_0_33_54 VGND VGND VPWR VPWR sky130_fd_sc_hd__fill_2
XFILLER_0_33_65 VGND VGND VPWR VPWR sky130_fd_sc_hd__fill_2
X_12839_ _02104_ _02096_ _02092_ net1658 VGND VGND VPWR VPWR _00804_ sky130_fd_sc_hd__a22o_1
XTAP_1390 VGND VPWR sky130_fd_sc_hd__tapvpwrvgnd_1
X_15558_ clknet_leaf_109_clk _00208_ VGND VGND VPWR VPWR cpuregs\[2\]\[12\] sky130_fd_sc_hd__dfxtp_1
XFILLER_0_44_504 VGND VGND VPWR VPWR sky130_fd_sc_hd__decap_3
XFILLER_0_71_323 VGND VGND VPWR VPWR sky130_fd_sc_hd__decap_6
X_14509_ _01618_ VGND VGND VPWR VPWR _01130_ sky130_fd_sc_hd__clkbuf_1
X_15489_ clknet_leaf_129_clk _00139_ VGND VGND VPWR VPWR cpuregs\[30\]\[7\] sky130_fd_sc_hd__dfxtp_1
XFILLER_0_140_77 VGND VGND VPWR VPWR sky130_fd_sc_hd__fill_1
XFILLER_0_114_436 VGND VGND VPWR VPWR sky130_fd_sc_hd__fill_1
X_08030_ _02427_ VGND VGND VPWR VPWR _02428_ sky130_fd_sc_hd__clkbuf_4
XFILLER_0_71_356 VGND VGND VPWR VPWR sky130_fd_sc_hd__decap_4
Xinput30 mem_rdata[7] VGND VGND VPWR VPWR net30 sky130_fd_sc_hd__clkbuf_4
Xhold803 cpuregs\[13\]\[24\] VGND VGND VPWR VPWR net1161 sky130_fd_sc_hd__dlygate4sd3_1
XFILLER_0_4_645 VGND VGND VPWR VPWR sky130_fd_sc_hd__fill_1
XFILLER_0_3_144 VGND VGND VPWR VPWR sky130_fd_sc_hd__fill_1
Xhold814 cpuregs\[17\]\[18\] VGND VGND VPWR VPWR net1172 sky130_fd_sc_hd__dlygate4sd3_1
Xhold836 cpuregs\[15\]\[19\] VGND VGND VPWR VPWR net1194 sky130_fd_sc_hd__dlygate4sd3_1
Xhold825 count_cycle\[32\] VGND VGND VPWR VPWR net1183 sky130_fd_sc_hd__dlygate4sd3_1
XFILLER_0_110_642 VGND VGND VPWR VPWR sky130_fd_sc_hd__fill_2
X_09981_ _04030_ _04201_ _04205_ _03659_ VGND VGND VPWR VPWR _04206_ sky130_fd_sc_hd__o211a_1
XFILLER_0_3_199 VGND VGND VPWR VPWR sky130_fd_sc_hd__fill_2
Xhold869 cpuregs\[13\]\[2\] VGND VGND VPWR VPWR net1227 sky130_fd_sc_hd__dlygate4sd3_1
Xhold858 cpuregs\[9\]\[7\] VGND VGND VPWR VPWR net1216 sky130_fd_sc_hd__dlygate4sd3_1
Xhold847 cpuregs\[1\]\[10\] VGND VGND VPWR VPWR net1205 sky130_fd_sc_hd__dlygate4sd3_1
X_08932_ reg_out\[11\] reg_next_pc\[11\] _03225_ VGND VGND VPWR VPWR _03245_ sky130_fd_sc_hd__mux2_1
X_08863_ _02143_ net252 net247 _02187_ VGND VGND VPWR VPWR _03207_ sky130_fd_sc_hd__a22o_1
X_08794_ _03132_ _03139_ VGND VGND VPWR VPWR _03149_ sky130_fd_sc_hd__or2b_1
X_07814_ net9 _02216_ _02225_ _02212_ VGND VGND VPWR VPWR _02226_ sky130_fd_sc_hd__a22o_1
XFILLER_0_74_83 VGND VGND VPWR VPWR sky130_fd_sc_hd__fill_1
X_07745_ decoder_trigger VGND VGND VPWR VPWR _02165_ sky130_fd_sc_hd__inv_2
X_09415_ _03650_ VGND VGND VPWR VPWR _03651_ sky130_fd_sc_hd__clkbuf_4
X_07676_ mem_do_prefetch _02083_ _02092_ _02103_ _02105_ VGND VGND VPWR VPWR _02106_
+ sky130_fd_sc_hd__a311o_1
X_09346_ net1374 _03591_ _03578_ VGND VGND VPWR VPWR _03592_ sky130_fd_sc_hd__mux2_1
XFILLER_0_117_252 VGND VGND VPWR VPWR sky130_fd_sc_hd__decap_4
XFILLER_0_90_621 VGND VGND VPWR VPWR sky130_fd_sc_hd__fill_2
XFILLER_0_74_161 VGND VGND VPWR VPWR sky130_fd_sc_hd__fill_2
X_09277_ _03531_ VGND VGND VPWR VPWR _03532_ sky130_fd_sc_hd__buf_2
X_08228_ _02573_ _02588_ _02611_ _02612_ _02600_ VGND VGND VPWR VPWR _02613_ sky130_fd_sc_hd__o311a_1
XFILLER_0_133_756 VGND VGND VPWR VPWR sky130_fd_sc_hd__fill_1
XFILLER_0_16_784 VGND VGND VPWR VPWR sky130_fd_sc_hd__fill_1
X_08159_ _02222_ _02465_ _02547_ _02508_ _02548_ VGND VGND VPWR VPWR _02549_ sky130_fd_sc_hd__a32o_1
XFILLER_0_30_253 VGND VGND VPWR VPWR sky130_fd_sc_hd__decap_6
X_11170_ net1062 _05175_ _05161_ VGND VGND VPWR VPWR _05176_ sky130_fd_sc_hd__mux2_1
X_10121_ _04125_ _04337_ _04341_ _03971_ VGND VGND VPWR VPWR _04342_ sky130_fd_sc_hd__o211a_1
XFILLER_0_100_185 VGND VGND VPWR VPWR sky130_fd_sc_hd__fill_2
X_10052_ _04125_ _04270_ _04274_ _03971_ VGND VGND VPWR VPWR _04275_ sky130_fd_sc_hd__o211a_1
X_14860_ _03511_ net874 _01804_ VGND VGND VPWR VPWR _01805_ sky130_fd_sc_hd__mux2_1
X_13811_ _06348_ _07276_ _07278_ _06417_ VGND VGND VPWR VPWR _07279_ sky130_fd_sc_hd__a211o_1
X_14791_ net863 _05181_ _01767_ VGND VGND VPWR VPWR _01768_ sky130_fd_sc_hd__mux2_1
X_13742_ cpuregs\[0\]\[29\] cpuregs\[1\]\[29\] cpuregs\[2\]\[29\] cpuregs\[3\]\[29\]
+ _06344_ _06345_ VGND VGND VPWR VPWR _07212_ sky130_fd_sc_hd__mux4_1
X_16530_ clknet_leaf_25_clk _01107_ VGND VGND VPWR VPWR mem_rdata_q\[14\] sky130_fd_sc_hd__dfxtp_1
X_10954_ _04995_ net1236 _05052_ VGND VGND VPWR VPWR _05058_ sky130_fd_sc_hd__mux2_1
XFILLER_0_128_528 VGND VGND VPWR VPWR sky130_fd_sc_hd__decap_4
X_13673_ cpuregs\[8\]\[27\] cpuregs\[9\]\[27\] _03343_ VGND VGND VPWR VPWR _07145_
+ sky130_fd_sc_hd__mux2_1
X_16461_ clknet_leaf_18_clk _01043_ VGND VGND VPWR VPWR cpuregs\[18\]\[14\] sky130_fd_sc_hd__dfxtp_1
X_10885_ _05012_ net1016 _05006_ VGND VGND VPWR VPWR _05013_ sky130_fd_sc_hd__mux2_1
XFILLER_0_57_128 VGND VGND VPWR VPWR sky130_fd_sc_hd__fill_1
X_16392_ clknet_leaf_33_clk _00974_ VGND VGND VPWR VPWR net145 sky130_fd_sc_hd__dfxtp_1
X_15412_ clknet_leaf_82_clk _00067_ VGND VGND VPWR VPWR cpuregs\[11\]\[30\] sky130_fd_sc_hd__dfxtp_1
XFILLER_0_72_109 VGND VGND VPWR VPWR sky130_fd_sc_hd__decap_4
X_12624_ _06185_ VGND VGND VPWR VPWR _00743_ sky130_fd_sc_hd__clkbuf_1
XFILLER_0_38_342 VGND VGND VPWR VPWR sky130_fd_sc_hd__fill_1
X_15343_ _02058_ VGND VGND VPWR VPWR _01524_ sky130_fd_sc_hd__clkbuf_1
X_12555_ _06135_ _06128_ _06136_ VGND VGND VPWR VPWR _06137_ sky130_fd_sc_hd__and3b_1
XFILLER_0_38_386 VGND VGND VPWR VPWR sky130_fd_sc_hd__decap_4
X_11506_ net1210 _05213_ _05360_ VGND VGND VPWR VPWR _05366_ sky130_fd_sc_hd__mux2_1
X_12486_ _06005_ _05759_ VGND VGND VPWR VPWR _06086_ sky130_fd_sc_hd__nor2_1
X_15274_ _02022_ VGND VGND VPWR VPWR _01491_ sky130_fd_sc_hd__clkbuf_1
XFILLER_0_124_789 VGND VGND VPWR VPWR sky130_fd_sc_hd__fill_1
XFILLER_0_123_277 VGND VGND VPWR VPWR sky130_fd_sc_hd__decap_3
XFILLER_0_123_255 VGND VGND VPWR VPWR sky130_fd_sc_hd__fill_1
X_11437_ _05329_ VGND VGND VPWR VPWR _00412_ sky130_fd_sc_hd__clkbuf_1
XFILLER_0_80_197 VGND VGND VPWR VPWR sky130_fd_sc_hd__fill_1
X_14225_ _07537_ VGND VGND VPWR VPWR _00971_ sky130_fd_sc_hd__clkbuf_1
X_11368_ _05035_ net1474 _05288_ VGND VGND VPWR VPWR _05293_ sky130_fd_sc_hd__mux2_1
X_14156_ _07498_ VGND VGND VPWR VPWR _00941_ sky130_fd_sc_hd__clkbuf_1
X_10319_ cpuregs\[16\]\[20\] cpuregs\[17\]\[20\] cpuregs\[18\]\[20\] cpuregs\[19\]\[20\]
+ _03938_ _04028_ VGND VGND VPWR VPWR _04535_ sky130_fd_sc_hd__mux4_1
XTAP_415 VGND VPWR sky130_fd_sc_hd__tapvpwrvgnd_1
XTAP_404 VGND VPWR sky130_fd_sc_hd__tapvpwrvgnd_1
X_13107_ _06441_ _06586_ _06590_ _06596_ _06468_ VGND VGND VPWR VPWR _06597_ sky130_fd_sc_hd__a311o_1
X_11299_ net656 _05211_ _05251_ VGND VGND VPWR VPWR _05256_ sky130_fd_sc_hd__mux2_1
XFILLER_0_95_49 VGND VGND VPWR VPWR sky130_fd_sc_hd__fill_1
X_14087_ _02189_ net566 _07460_ net827 _07382_ VGND VGND VPWR VPWR _07461_ sky130_fd_sc_hd__a221o_1
XTAP_448 VGND VPWR sky130_fd_sc_hd__tapvpwrvgnd_1
XTAP_437 VGND VPWR sky130_fd_sc_hd__tapvpwrvgnd_1
XTAP_426 VGND VPWR sky130_fd_sc_hd__tapvpwrvgnd_1
XTAP_459 VGND VPWR sky130_fd_sc_hd__tapvpwrvgnd_1
X_13038_ _06459_ _06527_ _06529_ _03328_ VGND VGND VPWR VPWR _06530_ sky130_fd_sc_hd__a211o_1
XFILLER_0_28_76 VGND VGND VPWR VPWR sky130_fd_sc_hd__fill_1
XFILLER_0_21_9 VGND VGND VPWR VPWR sky130_fd_sc_hd__fill_2
X_14989_ _03491_ net1320 _01865_ VGND VGND VPWR VPWR _01873_ sky130_fd_sc_hd__mux2_1
X_16728_ clknet_leaf_112_clk _01292_ VGND VGND VPWR VPWR cpuregs\[4\]\[7\] sky130_fd_sc_hd__dfxtp_1
XFILLER_0_48_139 VGND VGND VPWR VPWR sky130_fd_sc_hd__fill_1
X_16659_ clknet_leaf_130_clk _01226_ VGND VGND VPWR VPWR cpuregs\[29\]\[5\] sky130_fd_sc_hd__dfxtp_1
XFILLER_0_63_109 VGND VGND VPWR VPWR sky130_fd_sc_hd__decap_3
X_09200_ net664 _03464_ _03446_ VGND VGND VPWR VPWR _03465_ sky130_fd_sc_hd__mux2_1
XFILLER_0_29_353 VGND VGND VPWR VPWR sky130_fd_sc_hd__decap_4
XFILLER_0_29_364 VGND VGND VPWR VPWR sky130_fd_sc_hd__fill_2
X_09131_ _03346_ _03409_ _03310_ VGND VGND VPWR VPWR _03410_ sky130_fd_sc_hd__a21o_1
XFILLER_0_115_712 VGND VGND VPWR VPWR sky130_fd_sc_hd__decap_4
XFILLER_0_17_548 VGND VGND VPWR VPWR sky130_fd_sc_hd__decap_3
X_09062_ _03342_ VGND VGND VPWR VPWR _03343_ sky130_fd_sc_hd__clkbuf_8
XFILLER_0_72_698 VGND VGND VPWR VPWR sky130_fd_sc_hd__fill_2
XFILLER_0_71_153 VGND VGND VPWR VPWR sky130_fd_sc_hd__decap_8
XFILLER_0_25_570 VGND VGND VPWR VPWR sky130_fd_sc_hd__decap_8
X_08013_ _02410_ _02411_ VGND VGND VPWR VPWR _02412_ sky130_fd_sc_hd__nand2_1
Xhold611 cpuregs\[6\]\[12\] VGND VGND VPWR VPWR net969 sky130_fd_sc_hd__dlygate4sd3_1
Xhold600 cpuregs\[22\]\[9\] VGND VGND VPWR VPWR net958 sky130_fd_sc_hd__dlygate4sd3_1
Xhold633 cpuregs\[26\]\[23\] VGND VGND VPWR VPWR net991 sky130_fd_sc_hd__dlygate4sd3_1
Xhold622 reg_pc\[11\] VGND VGND VPWR VPWR net980 sky130_fd_sc_hd__dlygate4sd3_1
Xhold644 cpuregs\[27\]\[15\] VGND VGND VPWR VPWR net1002 sky130_fd_sc_hd__dlygate4sd3_1
XFILLER_0_69_61 VGND VGND VPWR VPWR sky130_fd_sc_hd__fill_1
XFILLER_0_12_253 VGND VGND VPWR VPWR sky130_fd_sc_hd__decap_6
XFILLER_0_100_80 VGND VGND VPWR VPWR sky130_fd_sc_hd__decap_4
Xhold666 cpuregs\[12\]\[3\] VGND VGND VPWR VPWR net1024 sky130_fd_sc_hd__dlygate4sd3_1
Xhold655 cpuregs\[12\]\[8\] VGND VGND VPWR VPWR net1013 sky130_fd_sc_hd__dlygate4sd3_1
Xhold677 cpuregs\[1\]\[6\] VGND VGND VPWR VPWR net1035 sky130_fd_sc_hd__dlygate4sd3_1
Xhold688 cpuregs\[18\]\[9\] VGND VGND VPWR VPWR net1046 sky130_fd_sc_hd__dlygate4sd3_1
Xhold699 cpuregs\[30\]\[19\] VGND VGND VPWR VPWR net1057 sky130_fd_sc_hd__dlygate4sd3_1
X_09964_ _04153_ _04158_ _04188_ VGND VGND VPWR VPWR _04189_ sky130_fd_sc_hd__a21oi_1
X_08915_ _02294_ _03233_ _03227_ VGND VGND VPWR VPWR _03234_ sky130_fd_sc_hd__mux2_1
X_09895_ _04119_ _04120_ _04121_ VGND VGND VPWR VPWR _04122_ sky130_fd_sc_hd__a21o_1
XTAP_971 VGND VPWR sky130_fd_sc_hd__tapvpwrvgnd_1
XTAP_960 VGND VPWR sky130_fd_sc_hd__tapvpwrvgnd_1
Xhold1300 mem_do_rdata VGND VGND VPWR VPWR net1658 sky130_fd_sc_hd__dlygate4sd3_1
X_08846_ _02653_ net227 _02915_ _03031_ VGND VGND VPWR VPWR _03196_ sky130_fd_sc_hd__a31o_1
XTAP_993 VGND VPWR sky130_fd_sc_hd__tapvpwrvgnd_1
XTAP_982 VGND VPWR sky130_fd_sc_hd__tapvpwrvgnd_1
X_08777_ _03126_ _03132_ net240 VGND VGND VPWR VPWR _03134_ sky130_fd_sc_hd__o21a_1
XFILLER_0_79_220 VGND VGND VPWR VPWR sky130_fd_sc_hd__decap_4
X_07728_ mem_do_rinst _02086_ _02090_ VGND VGND VPWR VPWR _02150_ sky130_fd_sc_hd__a21oi_1
X_07659_ _02088_ VGND VGND VPWR VPWR _02089_ sky130_fd_sc_hd__buf_2
X_10670_ _04874_ _04875_ _03365_ VGND VGND VPWR VPWR _04876_ sky130_fd_sc_hd__mux2_1
XFILLER_0_94_267 VGND VGND VPWR VPWR sky130_fd_sc_hd__decap_4
XFILLER_0_82_418 VGND VGND VPWR VPWR sky130_fd_sc_hd__fill_2
XFILLER_0_36_813 VGND VGND VPWR VPWR sky130_fd_sc_hd__fill_1
X_09329_ _03576_ VGND VGND VPWR VPWR _03577_ sky130_fd_sc_hd__clkbuf_4
XFILLER_0_8_781 VPWR VGND VPWR VGND sky130_ef_sc_hd__decap_12
X_12340_ _05947_ _05948_ _05950_ _05952_ VGND VGND VPWR VPWR _05953_ sky130_fd_sc_hd__and4_1
XFILLER_0_35_389 VGND VGND VPWR VPWR sky130_fd_sc_hd__decap_3
X_12271_ _05887_ _05888_ VGND VGND VPWR VPWR _05889_ sky130_fd_sc_hd__and2b_1
XFILLER_0_62_197 VGND VGND VPWR VPWR sky130_fd_sc_hd__decap_3
XFILLER_0_121_748 VGND VGND VPWR VPWR sky130_fd_sc_hd__fill_2
X_11222_ _03602_ VGND VGND VPWR VPWR _05211_ sky130_fd_sc_hd__buf_2
XFILLER_0_105_299 VGND VGND VPWR VPWR sky130_fd_sc_hd__decap_4
X_14010_ decoded_imm_j\[4\] _01117_ _07420_ VGND VGND VPWR VPWR _07421_ sky130_fd_sc_hd__mux2_1
XFILLER_0_101_483 VGND VGND VPWR VPWR sky130_fd_sc_hd__fill_2
X_11153_ _05164_ VGND VGND VPWR VPWR _00293_ sky130_fd_sc_hd__clkbuf_1
XFILLER_0_101_494 VGND VGND VPWR VPWR sky130_fd_sc_hd__fill_1
X_10104_ decoded_imm\[15\] net177 VGND VGND VPWR VPWR _04325_ sky130_fd_sc_hd__nor2_1
X_15961_ clknet_leaf_0_clk _00611_ VGND VGND VPWR VPWR count_instr\[30\] sky130_fd_sc_hd__dfxtp_1
X_11084_ net847 _03456_ _05124_ VGND VGND VPWR VPWR _05127_ sky130_fd_sc_hd__mux2_1
X_15892_ clknet_leaf_62_clk _00542_ VGND VGND VPWR VPWR cpuregs\[20\]\[26\] sky130_fd_sc_hd__dfxtp_1
X_10035_ decoded_imm\[13\] net175 VGND VGND VPWR VPWR _04258_ sky130_fd_sc_hd__nor2_1
X_14912_ _01832_ VGND VGND VPWR VPWR _01319_ sky130_fd_sc_hd__clkbuf_1
X_14843_ _03456_ net1185 _01793_ VGND VGND VPWR VPWR _01796_ sky130_fd_sc_hd__mux2_1
X_11986_ _05657_ _05620_ _05658_ VGND VGND VPWR VPWR _05659_ sky130_fd_sc_hd__and3b_1
X_14774_ net871 _05165_ _01756_ VGND VGND VPWR VPWR _01759_ sky130_fd_sc_hd__mux2_1
X_13725_ _06387_ _07195_ VGND VGND VPWR VPWR _07196_ sky130_fd_sc_hd__and2_1
X_10937_ _05047_ net1223 _04984_ VGND VGND VPWR VPWR _05048_ sky130_fd_sc_hd__mux2_1
XFILLER_0_86_757 VGND VGND VPWR VPWR sky130_fd_sc_hd__decap_4
X_16513_ clknet_leaf_93_clk _00034_ VGND VGND VPWR VPWR _00014_ sky130_fd_sc_hd__dfxtp_4
X_13656_ cpuregs\[16\]\[26\] cpuregs\[17\]\[26\] cpuregs\[18\]\[26\] cpuregs\[19\]\[26\]
+ _06945_ _06979_ VGND VGND VPWR VPWR _07129_ sky130_fd_sc_hd__mux4_1
X_16444_ clknet_leaf_14_clk _01026_ VGND VGND VPWR VPWR decoded_imm\[3\] sky130_fd_sc_hd__dfxtp_2
XPHY_270 VGND VGND VPWR VPWR sky130_fd_sc_hd__decap_3
XFILLER_0_54_632 VGND VGND VPWR VPWR sky130_fd_sc_hd__fill_1
X_12607_ _06173_ VGND VGND VPWR VPWR _00738_ sky130_fd_sc_hd__clkbuf_1
X_10868_ _03497_ VGND VGND VPWR VPWR _05001_ sky130_fd_sc_hd__clkbuf_4
XFILLER_0_39_673 VGND VGND VPWR VPWR sky130_fd_sc_hd__fill_2
XPHY_281 VGND VGND VPWR VPWR sky130_fd_sc_hd__decap_3
X_16375_ clknet_leaf_36_clk _00957_ VGND VGND VPWR VPWR net157 sky130_fd_sc_hd__dfxtp_1
X_13587_ _06866_ _07057_ _07061_ _06873_ VGND VGND VPWR VPWR _07062_ sky130_fd_sc_hd__o211a_1
X_10799_ net728 _03525_ _04957_ VGND VGND VPWR VPWR _04960_ sky130_fd_sc_hd__mux2_1
XFILLER_0_121_57 VGND VGND VPWR VPWR sky130_fd_sc_hd__decap_3
XFILLER_0_54_698 VGND VGND VPWR VPWR sky130_fd_sc_hd__fill_2
X_12538_ count_cycle\[11\] count_cycle\[12\] _06119_ VGND VGND VPWR VPWR _06124_ sky130_fd_sc_hd__and3_1
XFILLER_0_14_507 VGND VGND VPWR VPWR sky130_fd_sc_hd__fill_2
XFILLER_0_30_55 VGND VGND VPWR VPWR sky130_fd_sc_hd__fill_1
X_15326_ _02049_ VGND VGND VPWR VPWR _01516_ sky130_fd_sc_hd__clkbuf_1
X_12469_ _06066_ _06067_ _05811_ _06070_ VGND VGND VPWR VPWR _06071_ sky130_fd_sc_hd__a2bb2o_1
XFILLER_0_112_704 VGND VGND VPWR VPWR sky130_fd_sc_hd__decap_4
XFILLER_0_81_495 VGND VGND VPWR VPWR sky130_fd_sc_hd__decap_8
X_15257_ net460 VGND VGND VPWR VPWR _02014_ sky130_fd_sc_hd__clkbuf_1
XFILLER_0_30_77 VGND VGND VPWR VPWR sky130_fd_sc_hd__fill_1
X_14208_ _07528_ VGND VGND VPWR VPWR _00963_ sky130_fd_sc_hd__clkbuf_1
X_15188_ _01978_ VGND VGND VPWR VPWR _01449_ sky130_fd_sc_hd__clkbuf_1
XFILLER_0_22_595 VGND VGND VPWR VPWR sky130_fd_sc_hd__fill_1
X_14139_ _07489_ VGND VGND VPWR VPWR _00933_ sky130_fd_sc_hd__clkbuf_1
XFILLER_0_10_757 VPWR VGND VPWR VGND sky130_ef_sc_hd__decap_12
X_08700_ _02915_ _02846_ _02702_ VGND VGND VPWR VPWR _03061_ sky130_fd_sc_hd__mux2_1
X_09680_ decoded_imm\[4\] net197 VGND VGND VPWR VPWR _03912_ sky130_fd_sc_hd__or2_1
XTAP_289 VGND VPWR sky130_fd_sc_hd__tapvpwrvgnd_1
X_08631_ net207 net206 _02935_ _02971_ VGND VGND VPWR VPWR _02998_ sky130_fd_sc_hd__or4_2
XFILLER_0_55_85 VGND VGND VPWR VPWR sky130_fd_sc_hd__decap_3
X_08562_ net249 net125 _02884_ _02907_ VGND VGND VPWR VPWR _02935_ sky130_fd_sc_hd__or4_4
XFILLER_0_76_201 VGND VGND VPWR VPWR sky130_fd_sc_hd__decap_8
XFILLER_0_119_303 VGND VGND VPWR VPWR sky130_fd_sc_hd__decap_4
X_08493_ net97 _02748_ net252 _02850_ VGND VGND VPWR VPWR _02871_ sky130_fd_sc_hd__o31a_1
XFILLER_0_119_314 VGND VGND VPWR VPWR sky130_fd_sc_hd__decap_8
XFILLER_0_36_109 VGND VGND VPWR VPWR sky130_fd_sc_hd__fill_1
XFILLER_0_91_237 VGND VGND VPWR VPWR sky130_fd_sc_hd__fill_1
XFILLER_0_91_204 VGND VGND VPWR VPWR sky130_fd_sc_hd__fill_2
XFILLER_0_91_259 VGND VGND VPWR VPWR sky130_fd_sc_hd__fill_2
XFILLER_0_115_542 VGND VGND VPWR VPWR sky130_fd_sc_hd__fill_1
XFILLER_0_17_389 VGND VGND VPWR VPWR sky130_fd_sc_hd__decap_3
XFILLER_0_32_304 VGND VGND VPWR VPWR sky130_fd_sc_hd__decap_4
X_09114_ reg_sh\[3\] reg_sh\[2\] _03393_ VGND VGND VPWR VPWR _03394_ sky130_fd_sc_hd__a21bo_1
X_09045_ cpuregs\[8\]\[2\] cpuregs\[9\]\[2\] cpuregs\[10\]\[2\] cpuregs\[11\]\[2\]
+ _03323_ _03325_ VGND VGND VPWR VPWR _03326_ sky130_fd_sc_hd__mux4_1
XFILLER_0_44_197 VGND VGND VPWR VPWR sky130_fd_sc_hd__fill_1
XFILLER_0_32_326 VGND VGND VPWR VPWR sky130_fd_sc_hd__decap_6
XFILLER_0_4_294 VGND VGND VPWR VPWR sky130_fd_sc_hd__fill_2
Xhold452 cpuregs\[27\]\[29\] VGND VGND VPWR VPWR net810 sky130_fd_sc_hd__dlygate4sd3_1
Xhold441 cpuregs\[30\]\[22\] VGND VGND VPWR VPWR net799 sky130_fd_sc_hd__dlygate4sd3_1
XFILLER_0_102_269 VGND VGND VPWR VPWR sky130_fd_sc_hd__decap_6
Xhold463 reg_pc\[7\] VGND VGND VPWR VPWR net821 sky130_fd_sc_hd__dlygate4sd3_1
Xhold430 count_cycle\[17\] VGND VGND VPWR VPWR net788 sky130_fd_sc_hd__dlygate4sd3_1
Xhold496 cpuregs\[3\]\[26\] VGND VGND VPWR VPWR net854 sky130_fd_sc_hd__dlygate4sd3_1
Xhold485 cpuregs\[12\]\[19\] VGND VGND VPWR VPWR net843 sky130_fd_sc_hd__dlygate4sd3_1
Xhold474 cpuregs\[28\]\[16\] VGND VGND VPWR VPWR net832 sky130_fd_sc_hd__dlygate4sd3_1
X_09947_ _03979_ _04172_ _04020_ VGND VGND VPWR VPWR _04173_ sky130_fd_sc_hd__a21o_1
XFILLER_0_99_337 VGND VGND VPWR VPWR sky130_fd_sc_hd__decap_3
XFILLER_0_99_326 VGND VGND VPWR VPWR sky130_fd_sc_hd__decap_8
X_09878_ reg_pc\[8\] _03776_ _04097_ _04105_ _03946_ VGND VGND VPWR VPWR _04106_ sky130_fd_sc_hd__a221o_1
Xhold1130 count_cycle\[44\] VGND VGND VPWR VPWR net1488 sky130_fd_sc_hd__dlygate4sd3_1
Xhold1141 cpuregs\[13\]\[3\] VGND VGND VPWR VPWR net1499 sky130_fd_sc_hd__dlygate4sd3_1
XTAP_790 VGND VPWR sky130_fd_sc_hd__tapvpwrvgnd_1
Xhold1185 cpuregs\[16\]\[21\] VGND VGND VPWR VPWR net1543 sky130_fd_sc_hd__dlygate4sd3_1
X_08829_ _02632_ _03179_ VGND VGND VPWR VPWR _03181_ sky130_fd_sc_hd__nor2_1
Xhold1152 cpuregs\[26\]\[14\] VGND VGND VPWR VPWR net1510 sky130_fd_sc_hd__dlygate4sd3_1
Xhold1174 cpuregs\[29\]\[4\] VGND VGND VPWR VPWR net1532 sky130_fd_sc_hd__dlygate4sd3_1
Xhold1163 cpuregs\[4\]\[5\] VGND VGND VPWR VPWR net1521 sky130_fd_sc_hd__dlygate4sd3_1
XTAP_1901 VGND VPWR sky130_fd_sc_hd__tapvpwrvgnd_1
Xhold1196 cpuregs\[23\]\[15\] VGND VGND VPWR VPWR net1554 sky130_fd_sc_hd__dlygate4sd3_1
X_11840_ count_instr\[11\] _05550_ VGND VGND VPWR VPWR _05553_ sky130_fd_sc_hd__or2_1
X_11771_ _05029_ net913 _05505_ VGND VGND VPWR VPWR _05507_ sky130_fd_sc_hd__mux2_1
XTAP_1934 VGND VPWR sky130_fd_sc_hd__tapvpwrvgnd_1
XTAP_1923 VGND VPWR sky130_fd_sc_hd__tapvpwrvgnd_1
XTAP_1912 VGND VPWR sky130_fd_sc_hd__tapvpwrvgnd_1
XFILLER_0_67_223 VGND VGND VPWR VPWR sky130_fd_sc_hd__fill_1
Xclkbuf_leaf_146_clk clknet_4_2_0_clk VGND VGND VPWR VPWR clknet_leaf_146_clk sky130_fd_sc_hd__clkbuf_16
XFILLER_0_137_111 VGND VGND VPWR VPWR sky130_fd_sc_hd__fill_1
XTAP_1967 VGND VPWR sky130_fd_sc_hd__tapvpwrvgnd_1
XTAP_1956 VGND VPWR sky130_fd_sc_hd__tapvpwrvgnd_1
XTAP_1945 VGND VPWR sky130_fd_sc_hd__tapvpwrvgnd_1
X_13510_ cpuregs\[30\]\[21\] cpuregs\[31\]\[21\] _06754_ VGND VGND VPWR VPWR _06988_
+ sky130_fd_sc_hd__mux2_1
XFILLER_0_83_716 VGND VGND VPWR VPWR sky130_fd_sc_hd__fill_2
X_10722_ _04917_ VGND VGND VPWR VPWR _00109_ sky130_fd_sc_hd__clkbuf_1
X_14490_ net574 _05221_ _01598_ VGND VGND VPWR VPWR _01608_ sky130_fd_sc_hd__mux2_1
XTAP_1989 VGND VPWR sky130_fd_sc_hd__tapvpwrvgnd_1
XTAP_1978 VGND VPWR sky130_fd_sc_hd__tapvpwrvgnd_1
XFILLER_0_82_226 VPWR VGND VPWR VGND sky130_ef_sc_hd__decap_12
XFILLER_0_67_278 VGND VGND VPWR VPWR sky130_fd_sc_hd__fill_2
XFILLER_0_137_177 VPWR VGND VPWR VGND sky130_ef_sc_hd__decap_12
X_10653_ cpuregs\[28\]\[29\] cpuregs\[29\]\[29\] _03754_ VGND VGND VPWR VPWR _04860_
+ sky130_fd_sc_hd__mux2_1
X_13441_ _06783_ _06918_ _06920_ _06789_ VGND VGND VPWR VPWR _06921_ sky130_fd_sc_hd__a211o_1
X_10584_ _04723_ _04791_ _04752_ VGND VGND VPWR VPWR _04792_ sky130_fd_sc_hd__or3b_1
X_13372_ _06682_ _06853_ VGND VGND VPWR VPWR _06854_ sky130_fd_sc_hd__and2_1
X_16160_ clknet_leaf_146_clk _00778_ VGND VGND VPWR VPWR net63 sky130_fd_sc_hd__dfxtp_1
XFILLER_0_36_698 VGND VGND VPWR VPWR sky130_fd_sc_hd__fill_2
XFILLER_0_140_309 VGND VGND VPWR VPWR sky130_fd_sc_hd__decap_3
X_12323_ decoded_imm_j\[16\] _05726_ VGND VGND VPWR VPWR _05937_ sky130_fd_sc_hd__nand2_1
XFILLER_0_50_112 VGND VGND VPWR VPWR sky130_fd_sc_hd__decap_8
X_15111_ net1345 _03439_ _01937_ VGND VGND VPWR VPWR _01938_ sky130_fd_sc_hd__mux2_1
X_16091_ clknet_leaf_150_clk _00741_ VGND VGND VPWR VPWR count_cycle\[34\] sky130_fd_sc_hd__dfxtp_1
XFILLER_0_133_383 VGND VGND VPWR VPWR sky130_fd_sc_hd__decap_8
X_15042_ _01900_ VGND VGND VPWR VPWR _01901_ sky130_fd_sc_hd__clkbuf_8
X_12254_ _05868_ _05873_ _05791_ VGND VGND VPWR VPWR _05874_ sky130_fd_sc_hd__mux2_1
XFILLER_0_121_589 VGND VGND VPWR VPWR sky130_fd_sc_hd__fill_2
X_11205_ _05199_ VGND VGND VPWR VPWR _00310_ sky130_fd_sc_hd__clkbuf_1
XFILLER_0_76_29 VPWR VGND VPWR VGND sky130_ef_sc_hd__decap_12
X_12185_ _05793_ _05798_ _05808_ VGND VGND VPWR VPWR _05810_ sky130_fd_sc_hd__a21o_1
X_11136_ net1471 _03622_ _05146_ VGND VGND VPWR VPWR _05154_ sky130_fd_sc_hd__mux2_1
X_11067_ _05117_ VGND VGND VPWR VPWR _00254_ sky130_fd_sc_hd__clkbuf_1
X_15944_ clknet_leaf_146_clk _00594_ VGND VGND VPWR VPWR count_instr\[13\] sky130_fd_sc_hd__dfxtp_1
X_10018_ cpuregs\[2\]\[12\] cpuregs\[3\]\[12\] _03977_ VGND VGND VPWR VPWR _04242_
+ sky130_fd_sc_hd__mux2_1
X_15875_ clknet_leaf_138_clk _00525_ VGND VGND VPWR VPWR cpuregs\[20\]\[9\] sky130_fd_sc_hd__dfxtp_1
X_14826_ net1037 _05217_ _01778_ VGND VGND VPWR VPWR _01786_ sky130_fd_sc_hd__mux2_1
XFILLER_0_116_57 VGND VGND VPWR VPWR sky130_fd_sc_hd__fill_1
X_14757_ _01749_ VGND VGND VPWR VPWR _01247_ sky130_fd_sc_hd__clkbuf_1
XFILLER_0_58_223 VGND VGND VPWR VPWR sky130_fd_sc_hd__fill_1
X_13708_ cpuregs\[4\]\[28\] cpuregs\[5\]\[28\] _06906_ VGND VGND VPWR VPWR _07179_
+ sky130_fd_sc_hd__mux2_1
XFILLER_0_74_716 VGND VGND VPWR VPWR sky130_fd_sc_hd__decap_4
Xclkbuf_leaf_137_clk clknet_4_3_0_clk VGND VGND VPWR VPWR clknet_leaf_137_clk sky130_fd_sc_hd__clkbuf_16
X_11969_ _05645_ _05620_ _05646_ VGND VGND VPWR VPWR _05647_ sky130_fd_sc_hd__and3b_1
X_14688_ net803 _05215_ _01706_ VGND VGND VPWR VPWR _01713_ sky130_fd_sc_hd__mux2_1
XFILLER_0_86_587 VGND VGND VPWR VPWR sky130_fd_sc_hd__fill_1
XFILLER_0_73_215 VGND VGND VPWR VPWR sky130_fd_sc_hd__fill_2
XFILLER_0_39_470 VGND VGND VPWR VPWR sky130_fd_sc_hd__fill_1
XFILLER_0_129_689 VGND VGND VPWR VPWR sky130_fd_sc_hd__fill_1
XFILLER_0_128_177 VPWR VGND VPWR VGND sky130_ef_sc_hd__decap_12
X_13639_ _06415_ _07099_ _07112_ _02181_ decoded_imm\[25\] VGND VGND VPWR VPWR _07113_
+ sky130_fd_sc_hd__a32o_1
X_16427_ clknet_leaf_25_clk _01009_ VGND VGND VPWR VPWR decoded_imm\[20\] sky130_fd_sc_hd__dfxtp_4
X_16358_ clknet_leaf_75_clk _00940_ VGND VGND VPWR VPWR cpuregs\[1\]\[23\] sky130_fd_sc_hd__dfxtp_1
XFILLER_0_81_281 VGND VGND VPWR VPWR sky130_fd_sc_hd__fill_1
X_15309_ _03441_ _04944_ VGND VGND VPWR VPWR _02040_ sky130_fd_sc_hd__or2_4
XFILLER_0_26_197 VGND VGND VPWR VPWR sky130_fd_sc_hd__decap_3
X_16289_ clknet_leaf_149_clk _00874_ VGND VGND VPWR VPWR instr_sltu sky130_fd_sc_hd__dfxtp_1
XFILLER_0_2_754 VGND VGND VPWR VPWR sky130_fd_sc_hd__fill_2
XFILLER_0_112_589 VGND VGND VPWR VPWR sky130_fd_sc_hd__fill_1
XFILLER_0_5_54 VGND VGND VPWR VPWR sky130_fd_sc_hd__fill_2
X_09801_ _04025_ _04026_ _04027_ _04029_ _04030_ _03885_ VGND VGND VPWR VPWR _04031_
+ sky130_fd_sc_hd__mux4_2
X_07993_ _02207_ _02391_ _02284_ _02393_ VGND VGND VPWR VPWR _02394_ sky130_fd_sc_hd__a22o_1
X_09732_ _03900_ _03962_ _03839_ VGND VGND VPWR VPWR _03963_ sky130_fd_sc_hd__a21o_1
X_09663_ cpuregs\[24\]\[3\] cpuregs\[25\]\[3\] cpuregs\[26\]\[3\] cpuregs\[27\]\[3\]
+ _03894_ _03895_ VGND VGND VPWR VPWR _03896_ sky130_fd_sc_hd__mux4_1
X_08614_ _02933_ _02979_ _02982_ VGND VGND VPWR VPWR _02983_ sky130_fd_sc_hd__a21o_1
X_09594_ _03695_ _03822_ _03827_ VGND VGND VPWR VPWR _03828_ sky130_fd_sc_hd__a21o_1
X_08545_ _02325_ net249 _02839_ _02841_ VGND VGND VPWR VPWR _02919_ sky130_fd_sc_hd__a31o_1
XTAP_1219 VGND VPWR sky130_fd_sc_hd__tapvpwrvgnd_1
XTAP_1208 VGND VPWR sky130_fd_sc_hd__tapvpwrvgnd_1
XFILLER_0_82_94 VGND VGND VPWR VPWR sky130_fd_sc_hd__fill_1
XFILLER_0_65_705 VGND VGND VPWR VPWR sky130_fd_sc_hd__fill_1
Xclkbuf_leaf_128_clk clknet_4_8_0_clk VGND VGND VPWR VPWR clknet_leaf_128_clk sky130_fd_sc_hd__clkbuf_16
X_08476_ _02755_ _02855_ VGND VGND VPWR VPWR _02856_ sky130_fd_sc_hd__xor2_1
XFILLER_0_49_278 VGND VGND VPWR VPWR sky130_fd_sc_hd__fill_2
XFILLER_0_119_155 VGND VGND VPWR VPWR sky130_fd_sc_hd__decap_6
XFILLER_0_64_259 VGND VGND VPWR VPWR sky130_fd_sc_hd__fill_1
XFILLER_0_18_643 VGND VGND VPWR VPWR sky130_fd_sc_hd__fill_1
XFILLER_0_72_281 VGND VGND VPWR VPWR sky130_fd_sc_hd__fill_2
X_09028_ _03308_ VGND VGND VPWR VPWR _03309_ sky130_fd_sc_hd__clkbuf_8
XFILLER_0_20_307 VGND VGND VPWR VPWR sky130_fd_sc_hd__fill_1
Xhold271 cpuregs\[20\]\[28\] VGND VGND VPWR VPWR net629 sky130_fd_sc_hd__dlygate4sd3_1
XFILLER_0_103_578 VGND VGND VPWR VPWR sky130_fd_sc_hd__fill_1
Xhold260 _07445_ VGND VGND VPWR VPWR net618 sky130_fd_sc_hd__dlygate4sd3_1
Xhold282 cpuregs\[27\]\[16\] VGND VGND VPWR VPWR net640 sky130_fd_sc_hd__dlygate4sd3_1
Xhold293 cpuregs\[27\]\[10\] VGND VGND VPWR VPWR net651 sky130_fd_sc_hd__dlygate4sd3_1
X_13990_ _07406_ VGND VGND VPWR VPWR _00879_ sky130_fd_sc_hd__clkbuf_1
X_12941_ cpuregs\[6\]\[5\] cpuregs\[7\]\[5\] _06386_ VGND VGND VPWR VPWR _06435_ sky130_fd_sc_hd__mux2_1
XFILLER_0_99_178 VGND VGND VPWR VPWR sky130_fd_sc_hd__decap_4
X_15660_ clknet_leaf_82_clk _00310_ VGND VGND VPWR VPWR cpuregs\[14\]\[18\] sky130_fd_sc_hd__dfxtp_1
XANTENNA_100 net182 VGND VGND VPWR VPWR sky130_fd_sc_hd__diode_2
X_12872_ _06363_ _06366_ _06368_ _06370_ _00011_ VGND VGND VPWR VPWR _06371_ sky130_fd_sc_hd__a221o_1
XANTENNA_111 net220 VGND VGND VPWR VPWR sky130_fd_sc_hd__diode_2
X_14611_ _01672_ VGND VGND VPWR VPWR _01178_ sky130_fd_sc_hd__clkbuf_1
XANTENNA_133 net22 VGND VGND VPWR VPWR sky130_fd_sc_hd__diode_2
XANTENNA_122 _03318_ VGND VGND VPWR VPWR sky130_fd_sc_hd__diode_2
X_11823_ _05539_ _05540_ VGND VGND VPWR VPWR _05541_ sky130_fd_sc_hd__nor2_1
XANTENNA_144 net126 VGND VGND VPWR VPWR sky130_fd_sc_hd__diode_2
XTAP_1742 VGND VPWR sky130_fd_sc_hd__tapvpwrvgnd_1
XTAP_1731 VGND VPWR sky130_fd_sc_hd__tapvpwrvgnd_1
XTAP_1720 VGND VPWR sky130_fd_sc_hd__tapvpwrvgnd_1
XANTENNA_166 net221 VGND VGND VPWR VPWR sky130_fd_sc_hd__diode_2
X_15591_ clknet_leaf_100_clk _00241_ VGND VGND VPWR VPWR cpuregs\[28\]\[13\] sky130_fd_sc_hd__dfxtp_1
Xclkbuf_leaf_119_clk clknet_4_10_0_clk VGND VGND VPWR VPWR clknet_leaf_119_clk sky130_fd_sc_hd__clkbuf_16
XANTENNA_155 net71 VGND VGND VPWR VPWR sky130_fd_sc_hd__diode_2
X_14542_ net931 _05205_ _01634_ VGND VGND VPWR VPWR _01636_ sky130_fd_sc_hd__mux2_1
XTAP_1775 VGND VPWR sky130_fd_sc_hd__tapvpwrvgnd_1
XTAP_1764 VGND VPWR sky130_fd_sc_hd__tapvpwrvgnd_1
XTAP_1753 VGND VPWR sky130_fd_sc_hd__tapvpwrvgnd_1
XFILLER_0_83_502 VGND VGND VPWR VPWR sky130_fd_sc_hd__fill_2
X_11754_ _05012_ net965 _05494_ VGND VGND VPWR VPWR _05498_ sky130_fd_sc_hd__mux2_1
XFILLER_0_126_604 VGND VGND VPWR VPWR sky130_fd_sc_hd__decap_3
XTAP_1797 VGND VPWR sky130_fd_sc_hd__tapvpwrvgnd_1
XTAP_1786 VGND VPWR sky130_fd_sc_hd__tapvpwrvgnd_1
X_14473_ _01599_ VGND VGND VPWR VPWR _01081_ sky130_fd_sc_hd__clkbuf_1
XFILLER_0_55_248 VGND VGND VPWR VPWR sky130_fd_sc_hd__fill_1
X_11685_ _05461_ VGND VGND VPWR VPWR _00528_ sky130_fd_sc_hd__clkbuf_1
X_10705_ net1097 _03451_ _04907_ VGND VGND VPWR VPWR _04909_ sky130_fd_sc_hd__mux2_1
XFILLER_0_138_497 VGND VGND VPWR VPWR sky130_fd_sc_hd__fill_1
XFILLER_0_125_125 VGND VGND VPWR VPWR sky130_fd_sc_hd__decap_8
X_16212_ clknet_leaf_49_clk _00829_ VGND VGND VPWR VPWR net218 sky130_fd_sc_hd__dfxtp_4
X_10636_ _03766_ _04840_ _04842_ VGND VGND VPWR VPWR _04843_ sky130_fd_sc_hd__a21o_1
X_13424_ _06868_ _06901_ _06903_ VGND VGND VPWR VPWR _06904_ sky130_fd_sc_hd__a21o_1
XFILLER_0_125_169 VGND VGND VPWR VPWR sky130_fd_sc_hd__fill_2
X_16143_ clknet_leaf_32_clk _07631_ VGND VGND VPWR VPWR reg_out\[21\] sky130_fd_sc_hd__dfxtp_1
XFILLER_0_70_229 VPWR VGND VPWR VGND sky130_ef_sc_hd__decap_12
XFILLER_0_63_281 VGND VGND VPWR VPWR sky130_fd_sc_hd__fill_1
XFILLER_0_63_270 VGND VGND VPWR VPWR sky130_fd_sc_hd__fill_1
XFILLER_0_11_35 VGND VGND VPWR VPWR sky130_fd_sc_hd__fill_1
XFILLER_0_140_128 VGND VGND VPWR VPWR sky130_fd_sc_hd__fill_1
X_10567_ cpuregs\[24\]\[27\] cpuregs\[25\]\[27\] cpuregs\[26\]\[27\] cpuregs\[27\]\[27\]
+ _03831_ _03832_ VGND VGND VPWR VPWR _04776_ sky130_fd_sc_hd__mux4_1
X_13355_ _06699_ _06836_ _06667_ VGND VGND VPWR VPWR _06837_ sky130_fd_sc_hd__a21o_1
X_10498_ _03662_ _04704_ _04708_ _03971_ VGND VGND VPWR VPWR _04709_ sky130_fd_sc_hd__o211a_1
X_12306_ _05832_ _05919_ _05920_ _02154_ _05921_ VGND VGND VPWR VPWR _05922_ sky130_fd_sc_hd__o221a_1
X_13286_ _06535_ _06763_ _06769_ _06542_ VGND VGND VPWR VPWR _06770_ sky130_fd_sc_hd__o211a_1
XFILLER_0_11_329 VGND VGND VPWR VPWR sky130_fd_sc_hd__fill_1
X_16074_ clknet_leaf_150_clk _00724_ VGND VGND VPWR VPWR count_cycle\[17\] sky130_fd_sc_hd__dfxtp_1
XFILLER_0_23_167 VGND VGND VPWR VPWR sky130_fd_sc_hd__fill_1
X_15025_ _03603_ net1103 _01887_ VGND VGND VPWR VPWR _01892_ sky130_fd_sc_hd__mux2_1
X_12237_ _05829_ _05842_ _05857_ VGND VGND VPWR VPWR _05858_ sky130_fd_sc_hd__nand3_1
X_12168_ decoded_imm_j\[4\] _05700_ VGND VGND VPWR VPWR _05794_ sky130_fd_sc_hd__or2_1
XFILLER_0_127_34 VGND VGND VPWR VPWR sky130_fd_sc_hd__decap_8
X_12099_ _03580_ reg_next_pc\[21\] _03223_ VGND VGND VPWR VPWR _05739_ sky130_fd_sc_hd__mux2_2
X_11119_ net1480 _03571_ _05135_ VGND VGND VPWR VPWR _05145_ sky130_fd_sc_hd__mux2_1
X_16976_ clknet_leaf_99_clk _01540_ VGND VGND VPWR VPWR cpuregs\[10\]\[31\] sky130_fd_sc_hd__dfxtp_1
XFILLER_0_36_21 VGND VGND VPWR VPWR sky130_fd_sc_hd__fill_1
X_15927_ clknet_leaf_44_clk _00577_ VGND VGND VPWR VPWR cpuregs\[17\]\[29\] sky130_fd_sc_hd__dfxtp_1
Xinput6 mem_rdata[14] VGND VGND VPWR VPWR net6 sky130_fd_sc_hd__clkbuf_4
XFILLER_0_36_54 VGND VGND VPWR VPWR sky130_fd_sc_hd__fill_1
X_15858_ clknet_leaf_61_clk _00508_ VGND VGND VPWR VPWR cpuregs\[25\]\[24\] sky130_fd_sc_hd__dfxtp_1
X_14809_ net1267 _05200_ _01767_ VGND VGND VPWR VPWR _01777_ sky130_fd_sc_hd__mux2_1
X_15789_ clknet_leaf_95_clk _00439_ VGND VGND VPWR VPWR cpuregs\[26\]\[19\] sky130_fd_sc_hd__dfxtp_1
X_08330_ net181 net213 VGND VGND VPWR VPWR _02711_ sky130_fd_sc_hd__nand2_1
XFILLER_0_47_727 VGND VGND VPWR VPWR sky130_fd_sc_hd__fill_1
XFILLER_0_129_486 VGND VGND VPWR VPWR sky130_fd_sc_hd__decap_8
X_08261_ _02628_ _02642_ _02641_ VGND VGND VPWR VPWR _02644_ sky130_fd_sc_hd__a21o_1
X_08192_ _02309_ _02578_ _02446_ _02579_ VGND VGND VPWR VPWR _02580_ sky130_fd_sc_hd__o2bb2a_1
XFILLER_0_125_670 VGND VGND VPWR VPWR sky130_fd_sc_hd__fill_2
XFILLER_0_140_684 VGND VGND VPWR VPWR sky130_fd_sc_hd__fill_2
XFILLER_0_112_386 VGND VGND VPWR VPWR sky130_fd_sc_hd__fill_2
XFILLER_0_100_504 VGND VGND VPWR VPWR sky130_fd_sc_hd__fill_1
X_07976_ net173 VGND VGND VPWR VPWR _02378_ sky130_fd_sc_hd__clkbuf_4
X_09715_ reg_pc\[4\] _03776_ _03933_ _03945_ _03946_ VGND VGND VPWR VPWR _03947_ sky130_fd_sc_hd__a221o_1
X_09646_ cpuregs\[2\]\[3\] cpuregs\[3\]\[3\] _03756_ VGND VGND VPWR VPWR _03879_ sky130_fd_sc_hd__mux2_1
XFILLER_0_139_217 VGND VGND VPWR VPWR sky130_fd_sc_hd__fill_1
X_09577_ _00013_ VGND VGND VPWR VPWR _03811_ sky130_fd_sc_hd__buf_6
XTAP_1038 VGND VPWR sky130_fd_sc_hd__tapvpwrvgnd_1
XTAP_1027 VGND VPWR sky130_fd_sc_hd__tapvpwrvgnd_1
XTAP_1016 VGND VPWR sky130_fd_sc_hd__tapvpwrvgnd_1
XTAP_1005 VGND VPWR sky130_fd_sc_hd__tapvpwrvgnd_1
X_08528_ _02888_ _02890_ VGND VGND VPWR VPWR _02904_ sky130_fd_sc_hd__or2_1
XTAP_1049 VGND VPWR sky130_fd_sc_hd__tapvpwrvgnd_1
XFILLER_0_108_626 VGND VGND VPWR VPWR sky130_fd_sc_hd__fill_2
XFILLER_0_108_615 VGND VGND VPWR VPWR sky130_fd_sc_hd__fill_2
X_08459_ instr_or instr_ori VGND VGND VPWR VPWR _02840_ sky130_fd_sc_hd__or2_4
XFILLER_0_108_637 VGND VGND VPWR VPWR sky130_fd_sc_hd__decap_6
XFILLER_0_107_136 VGND VGND VPWR VPWR sky130_fd_sc_hd__fill_1
XFILLER_0_37_259 VGND VGND VPWR VPWR sky130_fd_sc_hd__fill_1
XFILLER_0_107_169 VGND VGND VPWR VPWR sky130_fd_sc_hd__decap_4
XFILLER_0_107_147 VGND VGND VPWR VPWR sky130_fd_sc_hd__fill_1
X_11470_ net849 _05177_ _05338_ VGND VGND VPWR VPWR _05347_ sky130_fd_sc_hd__mux2_1
X_10421_ _03695_ _04631_ _04633_ VGND VGND VPWR VPWR _04634_ sky130_fd_sc_hd__a21o_1
X_10352_ cpuregs\[24\]\[21\] cpuregs\[25\]\[21\] cpuregs\[26\]\[21\] cpuregs\[27\]\[21\]
+ _03831_ _03832_ VGND VGND VPWR VPWR _04567_ sky130_fd_sc_hd__mux4_1
X_13140_ _06374_ VGND VGND VPWR VPWR _06629_ sky130_fd_sc_hd__buf_4
XFILLER_0_60_251 VGND VGND VPWR VPWR sky130_fd_sc_hd__fill_1
XFILLER_0_131_673 VGND VGND VPWR VPWR sky130_fd_sc_hd__fill_2
XFILLER_0_20_126 VGND VGND VPWR VPWR sky130_fd_sc_hd__decap_6
XFILLER_0_20_137 VGND VGND VPWR VPWR sky130_fd_sc_hd__decap_3
X_13071_ _06461_ _06561_ VGND VGND VPWR VPWR _06562_ sky130_fd_sc_hd__and2_1
XFILLER_0_130_194 VGND VGND VPWR VPWR sky130_fd_sc_hd__fill_2
XFILLER_0_103_386 VGND VGND VPWR VPWR sky130_fd_sc_hd__decap_6
X_10283_ cpuregs\[30\]\[19\] cpuregs\[31\]\[19\] _04194_ VGND VGND VPWR VPWR _04500_
+ sky130_fd_sc_hd__mux2_1
X_12022_ _05631_ _05683_ VGND VGND VPWR VPWR _05684_ sky130_fd_sc_hd__nor2_1
X_16830_ clknet_leaf_102_clk _01394_ VGND VGND VPWR VPWR cpuregs\[7\]\[13\] sky130_fd_sc_hd__dfxtp_1
X_13973_ instr_sltu _07367_ _07370_ _07384_ VGND VGND VPWR VPWR _07395_ sky130_fd_sc_hd__a22o_1
X_16761_ clknet_leaf_114_clk _01325_ VGND VGND VPWR VPWR cpuregs\[5\]\[8\] sky130_fd_sc_hd__dfxtp_1
X_12924_ _03313_ VGND VGND VPWR VPWR _06418_ sky130_fd_sc_hd__buf_6
XFILLER_0_88_627 VGND VGND VPWR VPWR sky130_fd_sc_hd__fill_1
XFILLER_0_88_616 VGND VGND VPWR VPWR sky130_fd_sc_hd__fill_2
X_15712_ clknet_leaf_141_clk _00362_ VGND VGND VPWR VPWR cpuregs\[21\]\[6\] sky130_fd_sc_hd__dfxtp_1
XFILLER_0_69_830 VGND VGND VPWR VPWR sky130_fd_sc_hd__fill_2
X_16692_ clknet_leaf_113_clk _01259_ VGND VGND VPWR VPWR cpuregs\[3\]\[6\] sky130_fd_sc_hd__dfxtp_1
XTAP_2262 VGND VPWR sky130_fd_sc_hd__tapvpwrvgnd_1
XTAP_2251 VGND VPWR sky130_fd_sc_hd__tapvpwrvgnd_1
XTAP_2240 VGND VPWR sky130_fd_sc_hd__tapvpwrvgnd_1
X_15643_ clknet_leaf_124_clk _00293_ VGND VGND VPWR VPWR cpuregs\[14\]\[1\] sky130_fd_sc_hd__dfxtp_1
X_12855_ _06348_ _06350_ _06353_ VGND VGND VPWR VPWR _06354_ sky130_fd_sc_hd__a21o_1
X_15574_ clknet_leaf_67_clk _00224_ VGND VGND VPWR VPWR cpuregs\[2\]\[28\] sky130_fd_sc_hd__dfxtp_1
XTAP_2295 VGND VPWR sky130_fd_sc_hd__tapvpwrvgnd_1
XTAP_2284 VGND VPWR sky130_fd_sc_hd__tapvpwrvgnd_1
XTAP_2273 VGND VPWR sky130_fd_sc_hd__tapvpwrvgnd_1
X_12786_ _06307_ VGND VGND VPWR VPWR _00783_ sky130_fd_sc_hd__clkbuf_1
XTAP_1550 VGND VPWR sky130_fd_sc_hd__tapvpwrvgnd_1
X_11806_ count_instr\[2\] _05525_ _02164_ VGND VGND VPWR VPWR _05528_ sky130_fd_sc_hd__a21oi_1
XTAP_1594 VGND VPWR sky130_fd_sc_hd__tapvpwrvgnd_1
XTAP_1583 VGND VPWR sky130_fd_sc_hd__tapvpwrvgnd_1
XTAP_1572 VGND VPWR sky130_fd_sc_hd__tapvpwrvgnd_1
XTAP_1561 VGND VPWR sky130_fd_sc_hd__tapvpwrvgnd_1
X_14525_ net715 _05188_ _01623_ VGND VGND VPWR VPWR _01627_ sky130_fd_sc_hd__mux2_1
XPHY_90 VGND VGND VPWR VPWR sky130_fd_sc_hd__decap_3
X_11737_ _04995_ net1381 _05483_ VGND VGND VPWR VPWR _05489_ sky130_fd_sc_hd__mux2_1
XFILLER_0_22_45 VPWR VGND VPWR VGND sky130_ef_sc_hd__decap_12
X_14456_ _01590_ VGND VGND VPWR VPWR _01073_ sky130_fd_sc_hd__clkbuf_1
XFILLER_0_4_805 VGND VGND VPWR VPWR sky130_fd_sc_hd__decap_6
X_11668_ _05452_ VGND VGND VPWR VPWR _00520_ sky130_fd_sc_hd__clkbuf_1
XFILLER_0_22_78 VGND VGND VPWR VPWR sky130_fd_sc_hd__fill_2
XFILLER_0_24_421 VGND VGND VPWR VPWR sky130_fd_sc_hd__decap_4
XFILLER_0_36_270 VGND VGND VPWR VPWR sky130_fd_sc_hd__fill_2
X_10619_ _02082_ _04799_ _04826_ _03717_ VGND VGND VPWR VPWR _04827_ sky130_fd_sc_hd__a22o_1
X_13407_ _06783_ _06885_ _06887_ _06789_ VGND VGND VPWR VPWR _06888_ sky130_fd_sc_hd__a211o_1
X_14387_ _05010_ net1032 _01551_ VGND VGND VPWR VPWR _01554_ sky130_fd_sc_hd__mux2_1
X_11599_ _04993_ net1644 _05411_ VGND VGND VPWR VPWR _05416_ sky130_fd_sc_hd__mux2_1
XFILLER_0_122_640 VGND VGND VPWR VPWR sky130_fd_sc_hd__fill_1
X_13338_ cpuregs\[20\]\[16\] cpuregs\[21\]\[16\] _06784_ VGND VGND VPWR VPWR _06821_
+ sky130_fd_sc_hd__mux2_1
X_16126_ clknet_leaf_13_clk _07644_ VGND VGND VPWR VPWR reg_out\[4\] sky130_fd_sc_hd__dfxtp_1
XFILLER_0_3_348 VGND VGND VPWR VPWR sky130_fd_sc_hd__fill_2
XFILLER_0_3_337 VGND VGND VPWR VPWR sky130_fd_sc_hd__fill_2
Xpicorv32_259 VGND VGND VPWR VPWR picorv32_259/HI eoi[6] sky130_fd_sc_hd__conb_1
X_16057_ clknet_leaf_3_clk _00707_ VGND VGND VPWR VPWR count_cycle\[0\] sky130_fd_sc_hd__dfxtp_1
X_15008_ _03552_ net757 _01876_ VGND VGND VPWR VPWR _01883_ sky130_fd_sc_hd__mux2_1
X_13269_ _00007_ VGND VGND VPWR VPWR _06754_ sky130_fd_sc_hd__buf_4
XFILLER_0_20_682 VGND VGND VPWR VPWR sky130_fd_sc_hd__fill_1
XFILLER_0_138_66 VGND VGND VPWR VPWR sky130_fd_sc_hd__decap_8
X_07830_ _02159_ VGND VGND VPWR VPWR _02241_ sky130_fd_sc_hd__clkbuf_4
XFILLER_0_47_53 VGND VGND VPWR VPWR sky130_fd_sc_hd__decap_3
XFILLER_0_47_42 VGND VGND VPWR VPWR sky130_fd_sc_hd__fill_2
X_07761_ _02156_ _02157_ _02159_ VGND VGND VPWR VPWR _02179_ sky130_fd_sc_hd__o21ai_4
X_16959_ clknet_leaf_106_clk _01523_ VGND VGND VPWR VPWR cpuregs\[10\]\[14\] sky130_fd_sc_hd__dfxtp_1
X_09500_ cpuregs\[20\]\[1\] cpuregs\[21\]\[1\] _03680_ VGND VGND VPWR VPWR _03735_
+ sky130_fd_sc_hd__mux2_1
XFILLER_0_2_33 VGND VGND VPWR VPWR sky130_fd_sc_hd__fill_2
XFILLER_0_79_638 VGND VGND VPWR VPWR sky130_fd_sc_hd__fill_1
XFILLER_0_2_44 VGND VGND VPWR VPWR sky130_fd_sc_hd__fill_2
X_07692_ instr_jal _02118_ VGND VGND VPWR VPWR _02119_ sky130_fd_sc_hd__or2_1
X_09431_ _03666_ VGND VGND VPWR VPWR _03667_ sky130_fd_sc_hd__clkbuf_8
X_09362_ reg_out\[25\] alu_out_q\[25\] _03437_ VGND VGND VPWR VPWR _03605_ sky130_fd_sc_hd__mux2_1
XFILLER_0_93_129 VGND VGND VPWR VPWR sky130_fd_sc_hd__fill_1
X_08313_ net177 net209 VGND VGND VPWR VPWR _02694_ sky130_fd_sc_hd__or2_1
XFILLER_0_74_321 VGND VGND VPWR VPWR sky130_fd_sc_hd__decap_3
XANTENNA_11 _03648_ VGND VGND VPWR VPWR sky130_fd_sc_hd__diode_2
XFILLER_0_90_825 VGND VGND VPWR VPWR sky130_fd_sc_hd__fill_1
X_09293_ _03545_ VGND VGND VPWR VPWR _00052_ sky130_fd_sc_hd__clkbuf_1
XANTENNA_22 _03973_ VGND VGND VPWR VPWR sky130_fd_sc_hd__diode_2
XANTENNA_33 _07052_ VGND VGND VPWR VPWR sky130_fd_sc_hd__diode_2
X_08244_ reg_pc\[29\] decoded_imm\[29\] VGND VGND VPWR VPWR _02628_ sky130_fd_sc_hd__nand2_1
XANTENNA_55 net72 VGND VGND VPWR VPWR sky130_fd_sc_hd__diode_2
XFILLER_0_62_549 VGND VGND VPWR VPWR sky130_fd_sc_hd__fill_1
XFILLER_0_7_665 VGND VGND VPWR VPWR sky130_fd_sc_hd__decap_6
XANTENNA_66 net83 VGND VGND VPWR VPWR sky130_fd_sc_hd__diode_2
XANTENNA_44 net28 VGND VGND VPWR VPWR sky130_fd_sc_hd__diode_2
XANTENNA_88 net119 VGND VGND VPWR VPWR sky130_fd_sc_hd__diode_2
X_08175_ _02558_ _02559_ _02560_ _02563_ VGND VGND VPWR VPWR _02564_ sky130_fd_sc_hd__or4_1
XANTENNA_99 net178 VGND VGND VPWR VPWR sky130_fd_sc_hd__diode_2
XANTENNA_77 net103 VGND VGND VPWR VPWR sky130_fd_sc_hd__diode_2
XFILLER_0_104_139 VGND VGND VPWR VPWR sky130_fd_sc_hd__fill_1
XFILLER_0_6_197 VGND VGND VPWR VPWR sky130_fd_sc_hd__fill_2
XFILLER_0_15_476 VGND VGND VPWR VPWR sky130_fd_sc_hd__decap_4
XFILLER_0_43_785 VGND VGND VPWR VPWR sky130_fd_sc_hd__fill_1
XFILLER_0_113_673 VPWR VGND VPWR VGND sky130_ef_sc_hd__decap_12
XFILLER_0_113_651 VGND VGND VPWR VPWR sky130_fd_sc_hd__fill_1
Xoutput140 net140 VGND VGND VPWR VPWR mem_wdata[14] sky130_fd_sc_hd__buf_2
XFILLER_0_100_323 VGND VGND VPWR VPWR sky130_fd_sc_hd__fill_2
Xoutput151 net151 VGND VGND VPWR VPWR mem_wdata[24] sky130_fd_sc_hd__clkbuf_4
Xoutput195 net195 VGND VGND VPWR VPWR pcpi_rs1[31] sky130_fd_sc_hd__buf_2
Xoutput162 net162 VGND VGND VPWR VPWR mem_wdata[5] sky130_fd_sc_hd__clkbuf_4
Xoutput184 net184 VGND VGND VPWR VPWR pcpi_rs1[21] sky130_fd_sc_hd__clkbuf_4
Xoutput173 net173 VGND VGND VPWR VPWR pcpi_rs1[11] sky130_fd_sc_hd__clkbuf_4
XFILLER_0_97_402 VGND VGND VPWR VPWR sky130_fd_sc_hd__fill_2
X_07959_ _02360_ _02361_ VGND VGND VPWR VPWR _02362_ sky130_fd_sc_hd__nand2_1
X_10970_ _05066_ VGND VGND VPWR VPWR _00208_ sky130_fd_sc_hd__clkbuf_1
X_09629_ _03717_ VGND VGND VPWR VPWR _03862_ sky130_fd_sc_hd__clkbuf_4
XFILLER_0_97_457 VGND VGND VPWR VPWR sky130_fd_sc_hd__fill_1
X_12640_ net443 _06193_ _06196_ VGND VGND VPWR VPWR _00748_ sky130_fd_sc_hd__a21oi_1
Xclkbuf_leaf_50_clk clknet_4_7_0_clk VGND VGND VPWR VPWR clknet_leaf_50_clk sky130_fd_sc_hd__clkbuf_16
X_14310_ _07568_ _07573_ _07585_ _07359_ net1354 VGND VGND VPWR VPWR _01008_ sky130_fd_sc_hd__o32a_1
XFILLER_0_65_354 VGND VGND VPWR VPWR sky130_fd_sc_hd__decap_6
X_12571_ count_cycle\[20\] count_cycle\[21\] _06142_ VGND VGND VPWR VPWR _06148_ sky130_fd_sc_hd__and3_1
XFILLER_0_136_776 VGND VGND VPWR VPWR sky130_fd_sc_hd__decap_8
X_15290_ _02030_ VGND VGND VPWR VPWR _01499_ sky130_fd_sc_hd__clkbuf_1
XFILLER_0_108_445 VGND VGND VPWR VPWR sky130_fd_sc_hd__decap_4
X_11522_ _05374_ VGND VGND VPWR VPWR _05375_ sky130_fd_sc_hd__buf_4
XFILLER_0_123_415 VGND VGND VPWR VPWR sky130_fd_sc_hd__fill_2
X_14241_ net560 net113 _07541_ VGND VGND VPWR VPWR _07546_ sky130_fd_sc_hd__mux2_1
Xwire245 _03363_ VGND VGND VPWR VPWR net245 sky130_fd_sc_hd__buf_1
XFILLER_0_34_763 VGND VGND VPWR VPWR sky130_fd_sc_hd__fill_1
X_11453_ _05337_ VGND VGND VPWR VPWR _05338_ sky130_fd_sc_hd__buf_4
X_10404_ cpuregs\[8\]\[23\] cpuregs\[9\]\[23\] cpuregs\[10\]\[23\] cpuregs\[11\]\[23\]
+ _03798_ _03811_ VGND VGND VPWR VPWR _04617_ sky130_fd_sc_hd__mux4_1
X_14172_ net1646 _07306_ _07317_ net236 VGND VGND VPWR VPWR _00950_ sky130_fd_sc_hd__a22o_1
X_11384_ _03444_ _04903_ VGND VGND VPWR VPWR _05301_ sky130_fd_sc_hd__nor2_4
X_13123_ _06430_ _06607_ _06609_ _06342_ _06611_ VGND VGND VPWR VPWR _06612_ sky130_fd_sc_hd__o311a_1
XFILLER_0_131_481 VGND VGND VPWR VPWR sky130_fd_sc_hd__fill_2
X_10335_ cpuregs\[12\]\[21\] cpuregs\[13\]\[21\] _03749_ VGND VGND VPWR VPWR _04550_
+ sky130_fd_sc_hd__mux2_1
X_10266_ _03723_ _04482_ _03675_ VGND VGND VPWR VPWR _04483_ sky130_fd_sc_hd__a21o_1
XTAP_608 VGND VPWR sky130_fd_sc_hd__tapvpwrvgnd_1
XTAP_619 VGND VPWR sky130_fd_sc_hd__tapvpwrvgnd_1
X_13054_ _06431_ _06544_ VGND VGND VPWR VPWR _06545_ sky130_fd_sc_hd__and2_1
XFILLER_0_84_29 VGND VGND VPWR VPWR sky130_fd_sc_hd__decap_4
X_12005_ net406 _05668_ _05672_ VGND VGND VPWR VPWR _00637_ sky130_fd_sc_hd__o21a_1
X_16813_ clknet_leaf_68_clk _01377_ VGND VGND VPWR VPWR cpuregs\[6\]\[28\] sky130_fd_sc_hd__dfxtp_1
XFILLER_0_108_36 VGND VGND VPWR VPWR sky130_fd_sc_hd__fill_1
X_10197_ cpuregs\[2\]\[17\] cpuregs\[3\]\[17\] _04058_ VGND VGND VPWR VPWR _04416_
+ sky130_fd_sc_hd__mux2_1
X_16744_ clknet_leaf_76_clk _01308_ VGND VGND VPWR VPWR cpuregs\[4\]\[23\] sky130_fd_sc_hd__dfxtp_1
XFILLER_0_17_67 VGND VGND VPWR VPWR sky130_fd_sc_hd__decap_8
X_13956_ instr_srli _07357_ VGND VGND VPWR VPWR _07383_ sky130_fd_sc_hd__and2_1
X_16675_ clknet_leaf_60_clk _01242_ VGND VGND VPWR VPWR cpuregs\[29\]\[21\] sky130_fd_sc_hd__dfxtp_1
X_12907_ _03307_ _06390_ _06404_ VGND VGND VPWR VPWR _06405_ sky130_fd_sc_hd__o21a_1
X_13887_ _07337_ VGND VGND VPWR VPWR _00848_ sky130_fd_sc_hd__clkbuf_1
XTAP_2070 VGND VPWR sky130_fd_sc_hd__tapvpwrvgnd_1
X_15626_ clknet_leaf_95_clk _00276_ VGND VGND VPWR VPWR cpuregs\[31\]\[16\] sky130_fd_sc_hd__dfxtp_1
XFILLER_0_75_118 VPWR VGND VPWR VGND sky130_ef_sc_hd__decap_12
XFILLER_0_29_502 VGND VGND VPWR VPWR sky130_fd_sc_hd__fill_2
X_12838_ _06337_ _06339_ _02164_ VGND VGND VPWR VPWR _00803_ sky130_fd_sc_hd__a21oi_1
XTAP_2092 VGND VPWR sky130_fd_sc_hd__tapvpwrvgnd_1
XTAP_2081 VGND VPWR sky130_fd_sc_hd__tapvpwrvgnd_1
XFILLER_0_68_181 VGND VGND VPWR VPWR sky130_fd_sc_hd__decap_6
XFILLER_0_56_321 VGND VGND VPWR VPWR sky130_fd_sc_hd__decap_4
X_12769_ _06298_ VGND VGND VPWR VPWR _00775_ sky130_fd_sc_hd__clkbuf_1
Xclkbuf_leaf_41_clk clknet_4_7_0_clk VGND VGND VPWR VPWR clknet_leaf_41_clk sky130_fd_sc_hd__clkbuf_16
XTAP_1391 VGND VPWR sky130_fd_sc_hd__tapvpwrvgnd_1
XTAP_1380 VGND VPWR sky130_fd_sc_hd__tapvpwrvgnd_1
X_15557_ clknet_leaf_100_clk _00207_ VGND VGND VPWR VPWR cpuregs\[2\]\[11\] sky130_fd_sc_hd__dfxtp_1
XFILLER_0_126_253 VGND VGND VPWR VPWR sky130_fd_sc_hd__decap_3
XFILLER_0_123_3 VGND VGND VPWR VPWR sky130_fd_sc_hd__decap_8
X_15488_ clknet_leaf_143_clk _00138_ VGND VGND VPWR VPWR cpuregs\[30\]\[6\] sky130_fd_sc_hd__dfxtp_1
X_14508_ net936 _05171_ _01612_ VGND VGND VPWR VPWR _01618_ sky130_fd_sc_hd__mux2_1
Xinput20 mem_rdata[27] VGND VGND VPWR VPWR net20 sky130_fd_sc_hd__buf_4
Xinput31 mem_rdata[8] VGND VGND VPWR VPWR net31 sky130_fd_sc_hd__buf_2
X_14439_ _01581_ VGND VGND VPWR VPWR _01065_ sky130_fd_sc_hd__clkbuf_1
XFILLER_0_24_240 VPWR VGND VPWR VGND sky130_ef_sc_hd__decap_12
Xhold804 cpuregs\[3\]\[28\] VGND VGND VPWR VPWR net1162 sky130_fd_sc_hd__dlygate4sd3_1
Xhold826 cpuregs\[18\]\[28\] VGND VGND VPWR VPWR net1184 sky130_fd_sc_hd__dlygate4sd3_1
Xhold837 cpuregs\[18\]\[18\] VGND VGND VPWR VPWR net1195 sky130_fd_sc_hd__dlygate4sd3_1
Xhold815 cpuregs\[16\]\[7\] VGND VGND VPWR VPWR net1173 sky130_fd_sc_hd__dlygate4sd3_1
XFILLER_0_40_755 VGND VGND VPWR VPWR sky130_fd_sc_hd__fill_1
XFILLER_0_110_610 VGND VGND VPWR VPWR sky130_fd_sc_hd__fill_2
Xhold848 cpuregs\[25\]\[13\] VGND VGND VPWR VPWR net1206 sky130_fd_sc_hd__dlygate4sd3_1
X_09980_ _03696_ _04202_ _04204_ VGND VGND VPWR VPWR _04205_ sky130_fd_sc_hd__a21o_1
X_16109_ clknet_leaf_152_clk _00759_ VGND VGND VPWR VPWR count_cycle\[52\] sky130_fd_sc_hd__dfxtp_1
Xhold859 cpuregs\[24\]\[3\] VGND VGND VPWR VPWR net1217 sky130_fd_sc_hd__dlygate4sd3_1
X_17089_ net124 VGND VGND VPWR VPWR net230 sky130_fd_sc_hd__clkbuf_1
X_08931_ _03244_ VGND VGND VPWR VPWR net66 sky130_fd_sc_hd__clkbuf_1
XFILLER_0_58_52 VGND VGND VPWR VPWR sky130_fd_sc_hd__fill_2
XFILLER_0_110_698 VGND VGND VPWR VPWR sky130_fd_sc_hd__fill_2
X_08862_ net234 _03204_ _03206_ VGND VGND VPWR VPWR net128 sky130_fd_sc_hd__a21o_2
XFILLER_0_58_85 VGND VGND VPWR VPWR sky130_fd_sc_hd__decap_4
X_07813_ net32 net18 _02213_ VGND VGND VPWR VPWR _02225_ sky130_fd_sc_hd__mux2_1
X_08793_ _03146_ _03147_ VGND VGND VPWR VPWR _03148_ sky130_fd_sc_hd__or2_1
X_07744_ _02138_ _02163_ _02164_ VGND VGND VPWR VPWR _00018_ sky130_fd_sc_hd__a21o_1
XFILLER_0_28_3 VPWR VGND VPWR VGND sky130_ef_sc_hd__decap_12
X_07675_ mem_do_rdata cpu_state\[6\] _02104_ _02085_ VGND VGND VPWR VPWR _02105_ sky130_fd_sc_hd__a31o_1
X_09414_ _03649_ VGND VGND VPWR VPWR _03650_ sky130_fd_sc_hd__buf_2
XFILLER_0_48_822 VGND VGND VPWR VPWR sky130_fd_sc_hd__fill_1
XFILLER_0_109_209 VGND VGND VPWR VPWR sky130_fd_sc_hd__fill_1
Xclkbuf_leaf_32_clk clknet_4_5_0_clk VGND VGND VPWR VPWR clknet_leaf_32_clk sky130_fd_sc_hd__clkbuf_16
X_09345_ _03590_ VGND VGND VPWR VPWR _03591_ sky130_fd_sc_hd__clkbuf_4
XFILLER_0_90_83 VGND VGND VPWR VPWR sky130_fd_sc_hd__fill_1
XFILLER_0_47_365 VGND VGND VPWR VPWR sky130_fd_sc_hd__fill_2
XFILLER_0_35_505 VGND VGND VPWR VPWR sky130_fd_sc_hd__decap_4
X_09276_ _03434_ _03527_ _03528_ _03530_ VGND VGND VPWR VPWR _03531_ sky130_fd_sc_hd__a22o_2
XFILLER_0_47_387 VGND VGND VPWR VPWR sky130_fd_sc_hd__fill_2
XFILLER_0_7_440 VGND VGND VPWR VPWR sky130_fd_sc_hd__decap_4
X_08227_ _02586_ _02599_ VGND VGND VPWR VPWR _02612_ sky130_fd_sc_hd__or2_1
XFILLER_0_74_195 VGND VGND VPWR VPWR sky130_fd_sc_hd__fill_1
XFILLER_0_99_81 VGND VGND VPWR VPWR sky130_fd_sc_hd__fill_1
X_08158_ net186 VGND VGND VPWR VPWR _02548_ sky130_fd_sc_hd__clkbuf_4
XFILLER_0_101_632 VGND VGND VPWR VPWR sky130_fd_sc_hd__fill_2
X_08089_ count_instr\[51\] _02233_ VGND VGND VPWR VPWR _02483_ sky130_fd_sc_hd__and2_1
XFILLER_0_100_131 VGND VGND VPWR VPWR sky130_fd_sc_hd__decap_8
X_10120_ _04127_ _04338_ _04340_ VGND VGND VPWR VPWR _04341_ sky130_fd_sc_hd__a21o_1
Xclkbuf_leaf_99_clk clknet_4_9_0_clk VGND VGND VPWR VPWR clknet_leaf_99_clk sky130_fd_sc_hd__clkbuf_16
X_10051_ _04127_ _04271_ _04273_ VGND VGND VPWR VPWR _04274_ sky130_fd_sc_hd__a21o_1
XFILLER_0_98_711 VGND VGND VPWR VPWR sky130_fd_sc_hd__fill_2
X_13810_ _07013_ _07277_ VGND VGND VPWR VPWR _07278_ sky130_fd_sc_hd__and2_1
X_14790_ net1666 VGND VGND VPWR VPWR _01767_ sky130_fd_sc_hd__clkbuf_8
X_13741_ _06457_ _07210_ VGND VGND VPWR VPWR _07211_ sky130_fd_sc_hd__and2_1
X_10953_ _05057_ VGND VGND VPWR VPWR _00200_ sky130_fd_sc_hd__clkbuf_1
XFILLER_0_97_276 VGND VGND VPWR VPWR sky130_fd_sc_hd__decap_4
XFILLER_0_97_254 VGND VGND VPWR VPWR sky130_fd_sc_hd__fill_2
X_13672_ cpuregs\[12\]\[27\] cpuregs\[13\]\[27\] cpuregs\[14\]\[27\] cpuregs\[15\]\[27\]
+ _07027_ _06392_ VGND VGND VPWR VPWR _07144_ sky130_fd_sc_hd__mux4_1
XFILLER_0_85_449 VGND VGND VPWR VPWR sky130_fd_sc_hd__decap_6
X_10884_ _03531_ VGND VGND VPWR VPWR _05012_ sky130_fd_sc_hd__buf_2
X_16460_ clknet_leaf_97_clk _01042_ VGND VGND VPWR VPWR cpuregs\[18\]\[13\] sky130_fd_sc_hd__dfxtp_1
X_15411_ clknet_leaf_70_clk _00066_ VGND VGND VPWR VPWR cpuregs\[11\]\[29\] sky130_fd_sc_hd__dfxtp_1
Xclkbuf_leaf_23_clk clknet_4_4_0_clk VGND VGND VPWR VPWR clknet_leaf_23_clk sky130_fd_sc_hd__clkbuf_16
X_16391_ clknet_leaf_144_clk _00973_ VGND VGND VPWR VPWR net144 sky130_fd_sc_hd__dfxtp_2
X_12623_ _06183_ _06179_ _06184_ VGND VGND VPWR VPWR _06185_ sky130_fd_sc_hd__and3b_1
XFILLER_0_38_365 VGND VGND VPWR VPWR sky130_fd_sc_hd__decap_4
X_15342_ _03544_ net1245 _02052_ VGND VGND VPWR VPWR _02058_ sky130_fd_sc_hd__mux2_1
XFILLER_0_81_633 VGND VGND VPWR VPWR sky130_fd_sc_hd__fill_1
X_12554_ count_cycle\[16\] _06132_ VGND VGND VPWR VPWR _06136_ sky130_fd_sc_hd__or2_1
XFILLER_0_108_253 VGND VGND VPWR VPWR sky130_fd_sc_hd__decap_6
X_11505_ _05365_ VGND VGND VPWR VPWR _00444_ sky130_fd_sc_hd__clkbuf_1
X_15273_ net509 VGND VGND VPWR VPWR _02022_ sky130_fd_sc_hd__clkbuf_1
X_12485_ _05759_ _06073_ VGND VGND VPWR VPWR _06085_ sky130_fd_sc_hd__nand2_1
XFILLER_0_108_297 VGND VGND VPWR VPWR sky130_fd_sc_hd__decap_8
X_14224_ net557 net104 _07530_ VGND VGND VPWR VPWR _07537_ sky130_fd_sc_hd__mux2_1
XFILLER_0_110_37 VPWR VGND VPWR VGND sky130_ef_sc_hd__decap_12
X_11436_ net952 _05211_ _05324_ VGND VGND VPWR VPWR _05329_ sky130_fd_sc_hd__mux2_1
X_11367_ _05292_ VGND VGND VPWR VPWR _00379_ sky130_fd_sc_hd__clkbuf_1
X_14155_ _05035_ net784 _07493_ VGND VGND VPWR VPWR _07498_ sky130_fd_sc_hd__mux2_1
XFILLER_0_0_126 VGND VGND VPWR VPWR sky130_fd_sc_hd__fill_1
XFILLER_0_0_104 VGND VGND VPWR VPWR sky130_fd_sc_hd__fill_1
XFILLER_0_22_766 VGND VGND VPWR VPWR sky130_fd_sc_hd__decap_6
XFILLER_0_22_788 VGND VGND VPWR VPWR sky130_fd_sc_hd__fill_1
X_10318_ cpuregs\[20\]\[20\] cpuregs\[21\]\[20\] cpuregs\[22\]\[20\] cpuregs\[23\]\[20\]
+ _04100_ _03939_ VGND VGND VPWR VPWR _04534_ sky130_fd_sc_hd__mux4_1
XTAP_405 VGND VPWR sky130_fd_sc_hd__tapvpwrvgnd_1
X_14086_ instr_jalr _02172_ is_alu_reg_imm VGND VGND VPWR VPWR _07460_ sky130_fd_sc_hd__or3_4
X_13106_ _06455_ _06591_ _06595_ _06466_ VGND VGND VPWR VPWR _06596_ sky130_fd_sc_hd__o211a_1
X_11298_ _05255_ VGND VGND VPWR VPWR _00347_ sky130_fd_sc_hd__clkbuf_1
XTAP_438 VGND VPWR sky130_fd_sc_hd__tapvpwrvgnd_1
XTAP_427 VGND VPWR sky130_fd_sc_hd__tapvpwrvgnd_1
XTAP_416 VGND VPWR sky130_fd_sc_hd__tapvpwrvgnd_1
XTAP_449 VGND VPWR sky130_fd_sc_hd__tapvpwrvgnd_1
X_13037_ _06461_ _06528_ VGND VGND VPWR VPWR _06529_ sky130_fd_sc_hd__and2_1
X_10249_ cpuregs\[16\]\[18\] cpuregs\[17\]\[18\] cpuregs\[18\]\[18\] cpuregs\[19\]\[18\]
+ _03938_ _03939_ VGND VGND VPWR VPWR _04467_ sky130_fd_sc_hd__mux4_1
XFILLER_0_44_10 VGND VGND VPWR VPWR sky130_fd_sc_hd__fill_1
X_14988_ _01872_ VGND VGND VPWR VPWR _01355_ sky130_fd_sc_hd__clkbuf_1
X_16727_ clknet_leaf_116_clk _01291_ VGND VGND VPWR VPWR cpuregs\[4\]\[6\] sky130_fd_sc_hd__dfxtp_1
XFILLER_0_76_405 VPWR VGND VPWR VGND sky130_ef_sc_hd__decap_12
X_13939_ _07332_ _07371_ VGND VGND VPWR VPWR _07372_ sky130_fd_sc_hd__and2_1
X_16658_ clknet_leaf_123_clk _01225_ VGND VGND VPWR VPWR cpuregs\[29\]\[4\] sky130_fd_sc_hd__dfxtp_1
X_15609_ clknet_leaf_99_clk _00259_ VGND VGND VPWR VPWR cpuregs\[28\]\[31\] sky130_fd_sc_hd__dfxtp_1
X_16589_ clknet_leaf_5_clk _00023_ VGND VGND VPWR VPWR cpu_state\[6\] sky130_fd_sc_hd__dfxtp_2
XFILLER_0_72_633 VGND VGND VPWR VPWR sky130_fd_sc_hd__fill_2
Xclkbuf_leaf_14_clk clknet_4_3_0_clk VGND VGND VPWR VPWR clknet_leaf_14_clk sky130_fd_sc_hd__clkbuf_16
X_09130_ cpuregs\[28\]\[4\] cpuregs\[29\]\[4\] _03342_ VGND VGND VPWR VPWR _03409_
+ sky130_fd_sc_hd__mux2_1
X_09061_ _00007_ VGND VGND VPWR VPWR _03342_ sky130_fd_sc_hd__buf_4
XFILLER_0_114_212 VGND VGND VPWR VPWR sky130_fd_sc_hd__fill_2
X_08012_ reg_pc\[14\] decoded_imm\[14\] VGND VGND VPWR VPWR _02411_ sky130_fd_sc_hd__nand2_1
XFILLER_0_44_368 VGND VGND VPWR VPWR sky130_fd_sc_hd__decap_4
Xhold612 cpuregs\[11\]\[21\] VGND VGND VPWR VPWR net970 sky130_fd_sc_hd__dlygate4sd3_1
XFILLER_0_102_418 VGND VGND VPWR VPWR sky130_fd_sc_hd__fill_2
Xhold601 cpuregs\[4\]\[15\] VGND VGND VPWR VPWR net959 sky130_fd_sc_hd__dlygate4sd3_1
XFILLER_0_40_530 VGND VGND VPWR VPWR sky130_fd_sc_hd__fill_2
XFILLER_0_114_289 VPWR VGND VPWR VGND sky130_ef_sc_hd__decap_12
Xhold623 cpuregs\[17\]\[31\] VGND VGND VPWR VPWR net981 sky130_fd_sc_hd__dlygate4sd3_1
Xhold645 cpuregs\[18\]\[13\] VGND VGND VPWR VPWR net1003 sky130_fd_sc_hd__dlygate4sd3_1
Xhold634 cpuregs\[9\]\[1\] VGND VGND VPWR VPWR net992 sky130_fd_sc_hd__dlygate4sd3_1
Xhold667 cpuregs\[25\]\[21\] VGND VGND VPWR VPWR net1025 sky130_fd_sc_hd__dlygate4sd3_1
Xhold678 cpuregs\[6\]\[18\] VGND VGND VPWR VPWR net1036 sky130_fd_sc_hd__dlygate4sd3_1
X_09963_ _04186_ _04187_ VGND VGND VPWR VPWR _04188_ sky130_fd_sc_hd__or2b_1
Xhold656 cpuregs\[20\]\[31\] VGND VGND VPWR VPWR net1014 sky130_fd_sc_hd__dlygate4sd3_1
Xhold689 cpuregs\[25\]\[31\] VGND VGND VPWR VPWR net1047 sky130_fd_sc_hd__dlygate4sd3_1
X_08914_ reg_out\[5\] reg_next_pc\[5\] _03225_ VGND VGND VPWR VPWR _03233_ sky130_fd_sc_hd__mux2_1
XFILLER_0_0_671 VGND VGND VPWR VPWR sky130_fd_sc_hd__fill_1
X_09894_ _03673_ VGND VGND VPWR VPWR _04121_ sky130_fd_sc_hd__clkbuf_8
XTAP_961 VGND VPWR sky130_fd_sc_hd__tapvpwrvgnd_1
XTAP_950 VGND VPWR sky130_fd_sc_hd__tapvpwrvgnd_1
X_08845_ _02740_ _03187_ _03195_ _02867_ VGND VGND VPWR VPWR alu_out\[30\] sky130_fd_sc_hd__a22o_1
XTAP_994 VGND VPWR sky130_fd_sc_hd__tapvpwrvgnd_1
XTAP_972 VGND VPWR sky130_fd_sc_hd__tapvpwrvgnd_1
XTAP_983 VGND VPWR sky130_fd_sc_hd__tapvpwrvgnd_1
Xhold1301 count_cycle\[49\] VGND VGND VPWR VPWR net1659 sky130_fd_sc_hd__dlygate4sd3_1
X_08776_ _03126_ _03132_ VGND VGND VPWR VPWR _03133_ sky130_fd_sc_hd__nand2_1
X_07727_ is_beq_bne_blt_bge_bltu_bgeu VGND VGND VPWR VPWR _02149_ sky130_fd_sc_hd__clkbuf_4
XFILLER_0_39_107 VGND VGND VPWR VPWR sky130_fd_sc_hd__fill_2
XFILLER_0_67_449 VGND VGND VPWR VPWR sky130_fd_sc_hd__decap_4
X_07658_ net33 net134 VGND VGND VPWR VPWR _02088_ sky130_fd_sc_hd__and2_1
Xclkbuf_4_8_0_clk clknet_0_clk VGND VGND VPWR VPWR clknet_4_8_0_clk sky130_fd_sc_hd__clkbuf_8
X_09328_ _03573_ _03574_ _03449_ _03575_ VGND VGND VPWR VPWR _03576_ sky130_fd_sc_hd__a2bb2o_2
XFILLER_0_90_474 VGND VGND VPWR VPWR sky130_fd_sc_hd__fill_2
X_09259_ _03467_ _03515_ VGND VGND VPWR VPWR _03516_ sky130_fd_sc_hd__nor2_1
XFILLER_0_50_316 VGND VGND VPWR VPWR sky130_fd_sc_hd__decap_8
XFILLER_0_8_793 VPWR VGND VPWR VGND sky130_ef_sc_hd__decap_12
XFILLER_0_105_245 VGND VGND VPWR VPWR sky130_fd_sc_hd__decap_4
X_12270_ decoded_imm_j\[12\] _05716_ VGND VGND VPWR VPWR _05888_ sky130_fd_sc_hd__or2_1
X_11221_ _05210_ VGND VGND VPWR VPWR _00315_ sky130_fd_sc_hd__clkbuf_1
XFILLER_0_105_278 VGND VGND VPWR VPWR sky130_fd_sc_hd__fill_2
X_11152_ net1111 _05163_ _05161_ VGND VGND VPWR VPWR _05164_ sky130_fd_sc_hd__mux2_1
X_10103_ _04324_ VGND VGND VPWR VPWR _00083_ sky130_fd_sc_hd__clkbuf_1
X_11083_ _05126_ VGND VGND VPWR VPWR _00261_ sky130_fd_sc_hd__clkbuf_1
X_15960_ clknet_leaf_0_clk _00610_ VGND VGND VPWR VPWR count_instr\[29\] sky130_fd_sc_hd__dfxtp_1
X_15891_ clknet_leaf_63_clk _00541_ VGND VGND VPWR VPWR cpuregs\[20\]\[25\] sky130_fd_sc_hd__dfxtp_1
X_10034_ decoded_imm\[13\] net175 VGND VGND VPWR VPWR _04257_ sky130_fd_sc_hd__nand2_1
X_14911_ _03456_ net1018 _01829_ VGND VGND VPWR VPWR _01832_ sky130_fd_sc_hd__mux2_1
X_14842_ _01795_ VGND VGND VPWR VPWR _01286_ sky130_fd_sc_hd__clkbuf_1
XFILLER_0_98_563 VGND VGND VPWR VPWR sky130_fd_sc_hd__fill_2
XFILLER_0_81_19 VGND VGND VPWR VPWR sky130_fd_sc_hd__fill_1
X_11985_ count_instr\[51\] _05654_ VGND VGND VPWR VPWR _05658_ sky130_fd_sc_hd__or2_1
X_14773_ _01758_ VGND VGND VPWR VPWR _01254_ sky130_fd_sc_hd__clkbuf_1
X_13724_ cpuregs\[30\]\[28\] cpuregs\[31\]\[28\] _06510_ VGND VGND VPWR VPWR _07195_
+ sky130_fd_sc_hd__mux2_1
X_10936_ _03640_ VGND VGND VPWR VPWR _05047_ sky130_fd_sc_hd__clkbuf_4
X_16512_ clknet_leaf_96_clk _00033_ VGND VGND VPWR VPWR _00013_ sky130_fd_sc_hd__dfxtp_4
X_13655_ _06962_ _07120_ _07127_ VGND VGND VPWR VPWR _07128_ sky130_fd_sc_hd__or3_2
XFILLER_0_85_257 VPWR VGND VPWR VGND sky130_ef_sc_hd__decap_12
X_16443_ clknet_leaf_13_clk net476 VGND VGND VPWR VPWR decoded_imm\[4\] sky130_fd_sc_hd__dfxtp_2
X_10867_ _05000_ VGND VGND VPWR VPWR _00171_ sky130_fd_sc_hd__clkbuf_1
XPHY_260 VGND VGND VPWR VPWR sky130_fd_sc_hd__decap_3
X_12606_ _06171_ _06128_ _06172_ VGND VGND VPWR VPWR _06173_ sky130_fd_sc_hd__and3b_1
X_16374_ clknet_leaf_66_clk _00956_ VGND VGND VPWR VPWR net146 sky130_fd_sc_hd__dfxtp_1
XPHY_271 VGND VGND VPWR VPWR sky130_fd_sc_hd__decap_3
X_13586_ _06868_ _07058_ _07060_ VGND VGND VPWR VPWR _07061_ sky130_fd_sc_hd__a21o_1
XFILLER_0_93_290 VGND VGND VPWR VPWR sky130_fd_sc_hd__fill_2
X_10798_ _04959_ VGND VGND VPWR VPWR _00143_ sky130_fd_sc_hd__clkbuf_1
X_12537_ net552 net381 _06123_ VGND VGND VPWR VPWR _00718_ sky130_fd_sc_hd__o21a_1
X_15325_ _03491_ net1135 _02041_ VGND VGND VPWR VPWR _02049_ sky130_fd_sc_hd__mux2_1
X_12468_ _06068_ _06069_ VGND VGND VPWR VPWR _06070_ sky130_fd_sc_hd__xnor2_1
XFILLER_0_30_89 VGND VGND VPWR VPWR sky130_fd_sc_hd__decap_3
X_15256_ _02013_ VGND VGND VPWR VPWR _01482_ sky130_fd_sc_hd__clkbuf_1
X_14207_ net515 net127 _07519_ VGND VGND VPWR VPWR _07528_ sky130_fd_sc_hd__mux2_1
X_11419_ net602 _05194_ _05313_ VGND VGND VPWR VPWR _05320_ sky130_fd_sc_hd__mux2_1
XFILLER_0_1_413 VGND VGND VPWR VPWR sky130_fd_sc_hd__fill_1
X_15187_ _03472_ net1481 _01973_ VGND VGND VPWR VPWR _01978_ sky130_fd_sc_hd__mux2_1
XFILLER_0_34_390 VGND VGND VPWR VPWR sky130_fd_sc_hd__fill_1
X_12399_ _06003_ _06006_ VGND VGND VPWR VPWR _06007_ sky130_fd_sc_hd__xnor2_1
X_14138_ _05018_ net1288 _07482_ VGND VGND VPWR VPWR _07489_ sky130_fd_sc_hd__mux2_1
XFILLER_0_10_769 VPWR VGND VPWR VGND sky130_ef_sc_hd__decap_12
XFILLER_0_39_54 VGND VGND VPWR VPWR sky130_fd_sc_hd__fill_2
X_14069_ decoded_imm_j\[15\] _01108_ _07420_ VGND VGND VPWR VPWR _07451_ sky130_fd_sc_hd__mux2_1
Xclkbuf_leaf_3_clk clknet_4_0_0_clk VGND VGND VPWR VPWR clknet_leaf_3_clk sky130_fd_sc_hd__clkbuf_16
X_08630_ _02691_ _02990_ _02997_ _02849_ VGND VGND VPWR VPWR alu_out\[13\] sky130_fd_sc_hd__a22o_1
X_08561_ _02922_ VGND VGND VPWR VPWR _02934_ sky130_fd_sc_hd__clkbuf_4
XFILLER_0_77_725 VGND VGND VPWR VPWR sky130_fd_sc_hd__decap_3
X_08492_ _02866_ _02868_ _02870_ VGND VGND VPWR VPWR alu_out\[2\] sky130_fd_sc_hd__a21o_1
XFILLER_0_49_427 VGND VGND VPWR VPWR sky130_fd_sc_hd__fill_1
XFILLER_0_92_717 VPWR VGND VPWR VGND sky130_ef_sc_hd__decap_12
XFILLER_0_119_337 VGND VGND VPWR VPWR sky130_fd_sc_hd__fill_1
XFILLER_0_134_318 VGND VGND VPWR VPWR sky130_fd_sc_hd__decap_4
XFILLER_0_44_121 VGND VGND VPWR VPWR sky130_fd_sc_hd__fill_1
X_09113_ reg_sh\[3\] reg_sh\[2\] reg_sh\[4\] VGND VGND VPWR VPWR _03393_ sky130_fd_sc_hd__or3b_1
XFILLER_0_72_463 VGND VGND VPWR VPWR sky130_fd_sc_hd__decap_4
XFILLER_0_60_603 VGND VGND VPWR VPWR sky130_fd_sc_hd__fill_2
XFILLER_0_5_741 VPWR VGND VPWR VGND sky130_ef_sc_hd__decap_12
X_09044_ _03324_ VGND VGND VPWR VPWR _03325_ sky130_fd_sc_hd__clkbuf_8
XFILLER_0_45_699 VGND VGND VPWR VPWR sky130_fd_sc_hd__fill_2
Xhold420 cpuregs\[24\]\[20\] VGND VGND VPWR VPWR net778 sky130_fd_sc_hd__dlygate4sd3_1
XFILLER_0_103_727 VGND VGND VPWR VPWR sky130_fd_sc_hd__fill_1
XFILLER_0_5_785 VPWR VGND VPWR VGND sky130_ef_sc_hd__decap_12
XFILLER_0_130_557 VGND VGND VPWR VPWR sky130_fd_sc_hd__fill_1
Xhold431 cpuregs\[7\]\[25\] VGND VGND VPWR VPWR net789 sky130_fd_sc_hd__dlygate4sd3_1
XFILLER_0_102_248 VGND VGND VPWR VPWR sky130_fd_sc_hd__decap_4
Xhold453 cpuregs\[5\]\[12\] VGND VGND VPWR VPWR net811 sky130_fd_sc_hd__dlygate4sd3_1
Xhold442 cpuregs\[10\]\[6\] VGND VGND VPWR VPWR net800 sky130_fd_sc_hd__dlygate4sd3_1
Xhold475 cpuregs\[2\]\[20\] VGND VGND VPWR VPWR net833 sky130_fd_sc_hd__dlygate4sd3_1
Xhold486 cpuregs\[12\]\[11\] VGND VGND VPWR VPWR net844 sky130_fd_sc_hd__dlygate4sd3_1
Xhold464 cpuregs\[10\]\[8\] VGND VGND VPWR VPWR net822 sky130_fd_sc_hd__dlygate4sd3_1
Xhold497 cpuregs\[22\]\[31\] VGND VGND VPWR VPWR net855 sky130_fd_sc_hd__dlygate4sd3_1
X_09946_ cpuregs\[0\]\[10\] cpuregs\[1\]\[10\] _03980_ VGND VGND VPWR VPWR _04172_
+ sky130_fd_sc_hd__mux2_1
Xhold1120 cpuregs\[5\]\[21\] VGND VGND VPWR VPWR net1478 sky130_fd_sc_hd__dlygate4sd3_1
Xhold1131 decoded_imm\[30\] VGND VGND VPWR VPWR net1489 sky130_fd_sc_hd__dlygate4sd3_1
X_09877_ _03690_ _04104_ _03657_ VGND VGND VPWR VPWR _04105_ sky130_fd_sc_hd__o21a_1
Xhold1142 cpuregs\[5\]\[4\] VGND VGND VPWR VPWR net1500 sky130_fd_sc_hd__dlygate4sd3_1
XTAP_791 VGND VPWR sky130_fd_sc_hd__tapvpwrvgnd_1
XTAP_780 VGND VPWR sky130_fd_sc_hd__tapvpwrvgnd_1
X_08828_ _02632_ _03179_ VGND VGND VPWR VPWR _03180_ sky130_fd_sc_hd__and2_1
Xhold1164 cpuregs\[15\]\[11\] VGND VGND VPWR VPWR net1522 sky130_fd_sc_hd__dlygate4sd3_1
Xhold1153 decoded_imm\[2\] VGND VGND VPWR VPWR net1511 sky130_fd_sc_hd__dlygate4sd3_1
Xhold1175 cpuregs\[1\]\[9\] VGND VGND VPWR VPWR net1533 sky130_fd_sc_hd__dlygate4sd3_1
Xhold1186 cpuregs\[16\]\[28\] VGND VGND VPWR VPWR net1544 sky130_fd_sc_hd__dlygate4sd3_1
X_08759_ _03115_ _03112_ _02982_ VGND VGND VPWR VPWR _03116_ sky130_fd_sc_hd__or3b_1
Xhold1197 cpuregs\[1\]\[31\] VGND VGND VPWR VPWR net1555 sky130_fd_sc_hd__dlygate4sd3_1
XTAP_1924 VGND VPWR sky130_fd_sc_hd__tapvpwrvgnd_1
XTAP_1913 VGND VPWR sky130_fd_sc_hd__tapvpwrvgnd_1
XTAP_1902 VGND VPWR sky130_fd_sc_hd__tapvpwrvgnd_1
X_11770_ _05506_ VGND VGND VPWR VPWR _00568_ sky130_fd_sc_hd__clkbuf_1
XTAP_1968 VGND VPWR sky130_fd_sc_hd__tapvpwrvgnd_1
XTAP_1957 VGND VPWR sky130_fd_sc_hd__tapvpwrvgnd_1
XTAP_1946 VGND VPWR sky130_fd_sc_hd__tapvpwrvgnd_1
XTAP_1935 VGND VPWR sky130_fd_sc_hd__tapvpwrvgnd_1
XFILLER_0_83_706 VGND VGND VPWR VPWR sky130_fd_sc_hd__decap_4
X_10721_ net836 _03504_ _04907_ VGND VGND VPWR VPWR _04917_ sky130_fd_sc_hd__mux2_1
XFILLER_0_137_134 VPWR VGND VPWR VGND sky130_ef_sc_hd__decap_12
XTAP_1979 VGND VPWR sky130_fd_sc_hd__tapvpwrvgnd_1
X_13440_ _06682_ _06919_ VGND VGND VPWR VPWR _06920_ sky130_fd_sc_hd__and2_1
X_10652_ cpuregs\[30\]\[29\] cpuregs\[31\]\[29\] _03835_ VGND VGND VPWR VPWR _04859_
+ sky130_fd_sc_hd__mux2_1
XFILLER_0_82_238 VGND VGND VPWR VPWR sky130_fd_sc_hd__decap_3
XFILLER_0_48_493 VGND VGND VPWR VPWR sky130_fd_sc_hd__fill_1
X_10583_ _04751_ VGND VGND VPWR VPWR _04791_ sky130_fd_sc_hd__inv_2
X_13371_ cpuregs\[22\]\[17\] cpuregs\[23\]\[17\] _06786_ VGND VGND VPWR VPWR _06853_
+ sky130_fd_sc_hd__mux2_1
X_12322_ decoded_imm_j\[16\] _05726_ VGND VGND VPWR VPWR _05936_ sky130_fd_sc_hd__or2_1
XFILLER_0_63_485 VGND VGND VPWR VPWR sky130_fd_sc_hd__fill_2
X_15110_ _01936_ VGND VGND VPWR VPWR _01937_ sky130_fd_sc_hd__buf_4
X_16090_ clknet_leaf_3_clk _00740_ VGND VGND VPWR VPWR count_cycle\[33\] sky130_fd_sc_hd__dfxtp_1
XFILLER_0_106_587 VGND VGND VPWR VPWR sky130_fd_sc_hd__fill_1
X_12253_ _05871_ _05872_ VGND VGND VPWR VPWR _05873_ sky130_fd_sc_hd__xnor2_1
X_15041_ _03444_ _01791_ VGND VGND VPWR VPWR _01900_ sky130_fd_sc_hd__nor2_4
X_11204_ net736 _05198_ _05182_ VGND VGND VPWR VPWR _05199_ sky130_fd_sc_hd__mux2_1
X_12184_ _05793_ _05798_ _05808_ VGND VGND VPWR VPWR _05809_ sky130_fd_sc_hd__nand3_1
X_11135_ _05153_ VGND VGND VPWR VPWR _00286_ sky130_fd_sc_hd__clkbuf_1
X_11066_ net596 _03616_ _05110_ VGND VGND VPWR VPWR _05117_ sky130_fd_sc_hd__mux2_1
X_15943_ clknet_leaf_146_clk _00593_ VGND VGND VPWR VPWR count_instr\[12\] sky130_fd_sc_hd__dfxtp_1
X_10017_ cpuregs\[4\]\[12\] cpuregs\[5\]\[12\] cpuregs\[6\]\[12\] cpuregs\[7\]\[12\]
+ _03667_ _04090_ VGND VGND VPWR VPWR _04241_ sky130_fd_sc_hd__mux4_1
X_15874_ clknet_leaf_141_clk _00524_ VGND VGND VPWR VPWR cpuregs\[20\]\[8\] sky130_fd_sc_hd__dfxtp_1
X_14825_ _01785_ VGND VGND VPWR VPWR _01279_ sky130_fd_sc_hd__clkbuf_1
X_14756_ _05039_ net1626 _01742_ VGND VGND VPWR VPWR _01749_ sky130_fd_sc_hd__mux2_1
XFILLER_0_86_533 VGND VGND VPWR VPWR sky130_fd_sc_hd__fill_2
X_13707_ _06430_ _07173_ _07177_ _03335_ VGND VGND VPWR VPWR _07178_ sky130_fd_sc_hd__o211a_1
XFILLER_0_58_235 VGND VGND VPWR VPWR sky130_fd_sc_hd__decap_6
X_11968_ count_instr\[46\] _05642_ VGND VGND VPWR VPWR _05646_ sky130_fd_sc_hd__or2_1
XFILLER_0_129_646 VGND VGND VPWR VPWR sky130_fd_sc_hd__fill_2
X_14687_ _01712_ VGND VGND VPWR VPWR _01214_ sky130_fd_sc_hd__clkbuf_1
X_10919_ _05035_ net1161 _05027_ VGND VGND VPWR VPWR _05036_ sky130_fd_sc_hd__mux2_1
X_11899_ _05594_ _05576_ _05595_ VGND VGND VPWR VPWR _05596_ sky130_fd_sc_hd__and3b_1
X_13638_ _06377_ _07101_ _07105_ _07111_ _06341_ VGND VGND VPWR VPWR _07112_ sky130_fd_sc_hd__a311o_1
XFILLER_0_117_819 VGND VGND VPWR VPWR sky130_fd_sc_hd__fill_2
XFILLER_0_116_318 VGND VGND VPWR VPWR sky130_fd_sc_hd__decap_4
X_16426_ clknet_leaf_25_clk _01008_ VGND VGND VPWR VPWR decoded_imm\[21\] sky130_fd_sc_hd__dfxtp_2
XFILLER_0_128_189 VGND VGND VPWR VPWR sky130_fd_sc_hd__decap_6
X_13569_ cpuregs\[22\]\[23\] cpuregs\[23\]\[23\] _06786_ VGND VGND VPWR VPWR _07045_
+ sky130_fd_sc_hd__mux2_1
X_16357_ clknet_leaf_78_clk _00939_ VGND VGND VPWR VPWR cpuregs\[1\]\[22\] sky130_fd_sc_hd__dfxtp_1
XFILLER_0_54_474 VGND VGND VPWR VPWR sky130_fd_sc_hd__fill_2
XFILLER_0_54_452 VGND VGND VPWR VPWR sky130_fd_sc_hd__decap_6
XFILLER_0_15_806 VPWR VGND VPWR VGND sky130_ef_sc_hd__decap_12
XFILLER_0_27_666 VGND VGND VPWR VPWR sky130_fd_sc_hd__decap_6
XFILLER_0_140_800 VGND VGND VPWR VPWR sky130_fd_sc_hd__fill_1
XFILLER_0_81_9 VGND VGND VPWR VPWR sky130_fd_sc_hd__fill_1
X_15308_ _02039_ VGND VGND VPWR VPWR _01508_ sky130_fd_sc_hd__clkbuf_1
X_16288_ clknet_leaf_140_clk _00873_ VGND VGND VPWR VPWR instr_slt sky130_fd_sc_hd__dfxtp_1
XFILLER_0_112_568 VGND VGND VPWR VPWR sky130_fd_sc_hd__fill_2
X_15239_ _03635_ net1215 _01995_ VGND VGND VPWR VPWR _02005_ sky130_fd_sc_hd__mux2_1
X_07992_ count_instr\[12\] _02270_ count_cycle\[12\] _02173_ _02392_ VGND VGND VPWR
+ VPWR _02393_ sky130_fd_sc_hd__a221o_2
X_09800_ _03796_ VGND VGND VPWR VPWR _04030_ sky130_fd_sc_hd__buf_6
X_09731_ cpuregs\[12\]\[5\] cpuregs\[13\]\[5\] _03880_ VGND VGND VPWR VPWR _03962_
+ sky130_fd_sc_hd__mux2_1
X_09662_ _03669_ VGND VGND VPWR VPWR _03895_ sky130_fd_sc_hd__clkbuf_8
XFILLER_0_96_319 VGND VGND VPWR VPWR sky130_fd_sc_hd__fill_1
X_08613_ _02980_ _02978_ _02981_ _02967_ VGND VGND VPWR VPWR _02982_ sky130_fd_sc_hd__a2bb2o_1
X_09593_ _03823_ _03825_ _03826_ VGND VGND VPWR VPWR _03827_ sky130_fd_sc_hd__a21o_1
XFILLER_0_89_393 VGND VGND VPWR VPWR sky130_fd_sc_hd__fill_2
X_08544_ _02867_ _02913_ _02914_ _02918_ VGND VGND VPWR VPWR alu_out\[6\] sky130_fd_sc_hd__a31o_1
XTAP_1209 VGND VPWR sky130_fd_sc_hd__tapvpwrvgnd_1
XFILLER_0_77_577 VGND VGND VPWR VPWR sky130_fd_sc_hd__fill_2
X_08475_ _02853_ _02854_ VGND VGND VPWR VPWR _02855_ sky130_fd_sc_hd__and2b_1
XFILLER_0_9_321 VPWR VGND VPWR VGND sky130_ef_sc_hd__decap_12
XFILLER_0_45_430 VGND VGND VPWR VPWR sky130_fd_sc_hd__decap_3
X_09027_ _00010_ VGND VGND VPWR VPWR _03308_ sky130_fd_sc_hd__clkinv_4
XFILLER_0_130_343 VGND VGND VPWR VPWR sky130_fd_sc_hd__fill_2
Xhold261 cpuregs\[16\]\[11\] VGND VGND VPWR VPWR net619 sky130_fd_sc_hd__dlygate4sd3_1
Xhold250 cpuregs\[26\]\[5\] VGND VGND VPWR VPWR net608 sky130_fd_sc_hd__dlygate4sd3_1
Xhold283 cpuregs\[15\]\[15\] VGND VGND VPWR VPWR net641 sky130_fd_sc_hd__dlygate4sd3_1
Xhold272 cpuregs\[11\]\[10\] VGND VGND VPWR VPWR net630 sky130_fd_sc_hd__dlygate4sd3_1
Xhold294 is_sll_srl_sra VGND VGND VPWR VPWR net652 sky130_fd_sc_hd__dlygate4sd3_1
X_09929_ decoded_imm\[9\] net202 VGND VGND VPWR VPWR _04155_ sky130_fd_sc_hd__nor2_1
X_12940_ _03325_ VGND VGND VPWR VPWR _06434_ sky130_fd_sc_hd__clkbuf_4
X_12871_ _03321_ _06369_ _03308_ VGND VGND VPWR VPWR _06370_ sky130_fd_sc_hd__o21a_1
X_14610_ _05029_ net1315 _01670_ VGND VGND VPWR VPWR _01672_ sky130_fd_sc_hd__mux2_1
XANTENNA_123 _03666_ VGND VGND VPWR VPWR sky130_fd_sc_hd__diode_2
XANTENNA_112 net224 VGND VGND VPWR VPWR sky130_fd_sc_hd__diode_2
XANTENNA_134 net22 VGND VGND VPWR VPWR sky130_fd_sc_hd__diode_2
XANTENNA_101 net184 VGND VGND VPWR VPWR sky130_fd_sc_hd__diode_2
X_11822_ count_instr\[6\] _05536_ VGND VGND VPWR VPWR _05540_ sky130_fd_sc_hd__and2_1
XANTENNA_156 net71 VGND VGND VPWR VPWR sky130_fd_sc_hd__diode_2
XTAP_1743 VGND VPWR sky130_fd_sc_hd__tapvpwrvgnd_1
XTAP_1732 VGND VPWR sky130_fd_sc_hd__tapvpwrvgnd_1
XTAP_1721 VGND VPWR sky130_fd_sc_hd__tapvpwrvgnd_1
XTAP_1710 VGND VPWR sky130_fd_sc_hd__tapvpwrvgnd_1
XFILLER_0_95_341 VGND VGND VPWR VPWR sky130_fd_sc_hd__fill_1
XANTENNA_167 net126 VGND VGND VPWR VPWR sky130_fd_sc_hd__diode_2
X_15590_ clknet_leaf_136_clk _00240_ VGND VGND VPWR VPWR cpuregs\[28\]\[12\] sky130_fd_sc_hd__dfxtp_1
XANTENNA_145 net129 VGND VGND VPWR VPWR sky130_fd_sc_hd__diode_2
X_14541_ _01635_ VGND VGND VPWR VPWR _01145_ sky130_fd_sc_hd__clkbuf_1
XTAP_1776 VGND VPWR sky130_fd_sc_hd__tapvpwrvgnd_1
XTAP_1765 VGND VPWR sky130_fd_sc_hd__tapvpwrvgnd_1
XTAP_1754 VGND VPWR sky130_fd_sc_hd__tapvpwrvgnd_1
X_11753_ _05497_ VGND VGND VPWR VPWR _00560_ sky130_fd_sc_hd__clkbuf_1
XTAP_1798 VGND VPWR sky130_fd_sc_hd__tapvpwrvgnd_1
XTAP_1787 VGND VPWR sky130_fd_sc_hd__tapvpwrvgnd_1
X_14472_ net624 _05202_ _01598_ VGND VGND VPWR VPWR _01599_ sky130_fd_sc_hd__mux2_1
X_11684_ net1040 _05186_ _05458_ VGND VGND VPWR VPWR _05461_ sky130_fd_sc_hd__mux2_1
X_10704_ _04908_ VGND VGND VPWR VPWR _00100_ sky130_fd_sc_hd__clkbuf_1
XFILLER_0_36_430 VGND VGND VPWR VPWR sky130_fd_sc_hd__decap_8
X_16211_ clknet_leaf_50_clk _00828_ VGND VGND VPWR VPWR net217 sky130_fd_sc_hd__dfxtp_4
X_10635_ _04045_ _04841_ _03674_ VGND VGND VPWR VPWR _04842_ sky130_fd_sc_hd__a21o_1
XFILLER_0_102_27 VGND VGND VPWR VPWR sky130_fd_sc_hd__fill_1
X_13423_ _06699_ _06902_ _06667_ VGND VGND VPWR VPWR _06903_ sky130_fd_sc_hd__a21o_1
XFILLER_0_64_761 VGND VGND VPWR VPWR sky130_fd_sc_hd__fill_1
X_16142_ clknet_leaf_30_clk _07630_ VGND VGND VPWR VPWR reg_out\[20\] sky130_fd_sc_hd__dfxtp_1
X_13354_ cpuregs\[10\]\[17\] cpuregs\[11\]\[17\] _06766_ VGND VGND VPWR VPWR _06836_
+ sky130_fd_sc_hd__mux2_1
XFILLER_0_140_107 VGND VGND VPWR VPWR sky130_fd_sc_hd__decap_4
X_10566_ _03818_ _04770_ _04774_ _03829_ VGND VGND VPWR VPWR _04775_ sky130_fd_sc_hd__o211a_1
X_12305_ _05720_ _05911_ VGND VGND VPWR VPWR _05921_ sky130_fd_sc_hd__or2b_1
XFILLER_0_12_809 VGND VGND VPWR VPWR sky130_fd_sc_hd__decap_3
XFILLER_0_23_135 VGND VGND VPWR VPWR sky130_fd_sc_hd__decap_6
X_10497_ _03834_ _04705_ _04707_ VGND VGND VPWR VPWR _04708_ sky130_fd_sc_hd__a21o_1
X_13285_ _06537_ _06765_ _06768_ VGND VGND VPWR VPWR _06769_ sky130_fd_sc_hd__a21o_1
X_16073_ clknet_leaf_150_clk _00723_ VGND VGND VPWR VPWR count_cycle\[16\] sky130_fd_sc_hd__dfxtp_1
X_15024_ _01891_ VGND VGND VPWR VPWR _01372_ sky130_fd_sc_hd__clkbuf_1
XFILLER_0_121_365 VGND VGND VPWR VPWR sky130_fd_sc_hd__fill_1
X_12236_ decoded_imm_j\[5\] _05702_ _05820_ _05830_ VGND VGND VPWR VPWR _05857_ sky130_fd_sc_hd__a31o_1
X_12167_ decoded_imm_j\[4\] _05700_ VGND VGND VPWR VPWR _05793_ sky130_fd_sc_hd__nand2_1
XFILLER_0_31_190 VGND VGND VPWR VPWR sky130_fd_sc_hd__fill_1
X_11118_ _05144_ VGND VGND VPWR VPWR _00278_ sky130_fd_sc_hd__clkbuf_1
X_12098_ _05735_ _05736_ _05738_ _05730_ VGND VGND VPWR VPWR _00664_ sky130_fd_sc_hd__o211a_1
X_16975_ clknet_leaf_91_clk _01539_ VGND VGND VPWR VPWR cpuregs\[10\]\[30\] sky130_fd_sc_hd__dfxtp_1
X_15926_ clknet_leaf_64_clk _00576_ VGND VGND VPWR VPWR cpuregs\[17\]\[28\] sky130_fd_sc_hd__dfxtp_1
XFILLER_0_127_57 VGND VGND VPWR VPWR sky130_fd_sc_hd__fill_2
Xinput7 mem_rdata[15] VGND VGND VPWR VPWR net7 sky130_fd_sc_hd__clkbuf_2
X_11049_ net926 _03564_ _05099_ VGND VGND VPWR VPWR _05108_ sky130_fd_sc_hd__mux2_1
XFILLER_0_36_33 VGND VGND VPWR VPWR sky130_fd_sc_hd__fill_1
X_15857_ clknet_leaf_45_clk _00507_ VGND VGND VPWR VPWR cpuregs\[25\]\[23\] sky130_fd_sc_hd__dfxtp_1
X_14808_ _01776_ VGND VGND VPWR VPWR _01271_ sky130_fd_sc_hd__clkbuf_1
XFILLER_0_98_190 VGND VGND VPWR VPWR sky130_fd_sc_hd__decap_6
X_15788_ clknet_leaf_56_clk _00438_ VGND VGND VPWR VPWR cpuregs\[26\]\[18\] sky130_fd_sc_hd__dfxtp_1
X_14739_ _05022_ net1443 _01731_ VGND VGND VPWR VPWR _01740_ sky130_fd_sc_hd__mux2_1
XFILLER_0_117_605 VGND VGND VPWR VPWR sky130_fd_sc_hd__fill_1
X_08260_ _02628_ _02641_ _02642_ VGND VGND VPWR VPWR _02643_ sky130_fd_sc_hd__and3_1
X_08191_ net18 _02466_ _02429_ VGND VGND VPWR VPWR _02579_ sky130_fd_sc_hd__a21oi_1
XFILLER_0_61_208 VGND VGND VPWR VPWR sky130_fd_sc_hd__decap_6
XFILLER_0_39_290 VGND VGND VPWR VPWR sky130_fd_sc_hd__fill_1
X_16409_ clknet_leaf_139_clk _00991_ VGND VGND VPWR VPWR latched_rd\[0\] sky130_fd_sc_hd__dfxtp_1
XFILLER_0_14_135 VGND VGND VPWR VPWR sky130_fd_sc_hd__fill_2
XFILLER_0_14_157 VGND VGND VPWR VPWR sky130_fd_sc_hd__fill_1
XFILLER_0_42_477 VGND VGND VPWR VPWR sky130_fd_sc_hd__fill_1
XFILLER_0_112_365 VGND VGND VPWR VPWR sky130_fd_sc_hd__decap_4
XFILLER_0_58_3 VGND VGND VPWR VPWR sky130_fd_sc_hd__fill_2
XFILLER_0_10_341 VGND VGND VPWR VPWR sky130_fd_sc_hd__decap_6
X_07975_ _02375_ _02376_ VGND VGND VPWR VPWR _02377_ sky130_fd_sc_hd__xnor2_1
X_09714_ _03702_ VGND VGND VPWR VPWR _03946_ sky130_fd_sc_hd__buf_4
XFILLER_0_69_308 VGND VGND VPWR VPWR sky130_fd_sc_hd__decap_3
X_09645_ _03719_ VGND VGND VPWR VPWR _03878_ sky130_fd_sc_hd__buf_4
XFILLER_0_139_229 VPWR VGND VPWR VGND sky130_ef_sc_hd__decap_12
XFILLER_0_96_149 VGND VGND VPWR VPWR sky130_fd_sc_hd__fill_2
XTAP_1028 VGND VPWR sky130_fd_sc_hd__tapvpwrvgnd_1
XTAP_1017 VGND VPWR sky130_fd_sc_hd__tapvpwrvgnd_1
XTAP_1006 VGND VPWR sky130_fd_sc_hd__tapvpwrvgnd_1
X_09576_ _03723_ _03809_ VGND VGND VPWR VPWR _03810_ sky130_fd_sc_hd__nand2_1
X_08527_ _02900_ _02902_ VGND VGND VPWR VPWR _02903_ sky130_fd_sc_hd__nand2_1
XFILLER_0_65_503 VGND VGND VPWR VPWR sky130_fd_sc_hd__fill_1
XTAP_1039 VGND VPWR sky130_fd_sc_hd__tapvpwrvgnd_1
X_08458_ _02838_ VGND VGND VPWR VPWR _02839_ sky130_fd_sc_hd__clkbuf_4
X_10420_ _04119_ _04632_ _04121_ VGND VGND VPWR VPWR _04633_ sky130_fd_sc_hd__a21o_1
X_08389_ _02493_ _02763_ _02769_ VGND VGND VPWR VPWR _02770_ sky130_fd_sc_hd__o21a_1
XFILLER_0_104_811 VGND VGND VPWR VPWR sky130_fd_sc_hd__fill_1
X_10351_ _03818_ _04561_ _04565_ _03829_ VGND VGND VPWR VPWR _04566_ sky130_fd_sc_hd__o211a_1
XFILLER_0_116_693 VGND VGND VPWR VPWR sky130_fd_sc_hd__decap_6
XFILLER_0_21_628 VGND VGND VPWR VPWR sky130_fd_sc_hd__fill_2
X_10282_ cpuregs\[24\]\[19\] cpuregs\[25\]\[19\] cpuregs\[26\]\[19\] cpuregs\[27\]\[19\]
+ _04192_ _04200_ VGND VGND VPWR VPWR _04499_ sky130_fd_sc_hd__mux4_1
XFILLER_0_60_285 VGND VGND VPWR VPWR sky130_fd_sc_hd__fill_1
X_13070_ cpuregs\[30\]\[8\] cpuregs\[31\]\[8\] _06462_ VGND VGND VPWR VPWR _06561_
+ sky130_fd_sc_hd__mux2_1
X_12021_ count_instr\[62\] count_instr\[61\] count_instr\[60\] _05677_ VGND VGND VPWR
+ VPWR _05683_ sky130_fd_sc_hd__and4_1
X_16760_ clknet_leaf_112_clk _01324_ VGND VGND VPWR VPWR cpuregs\[5\]\[7\] sky130_fd_sc_hd__dfxtp_1
X_13972_ _07394_ VGND VGND VPWR VPWR _00873_ sky130_fd_sc_hd__clkbuf_1
XFILLER_0_88_606 VGND VGND VPWR VPWR sky130_fd_sc_hd__decap_6
X_15711_ clknet_leaf_142_clk _00361_ VGND VGND VPWR VPWR cpuregs\[21\]\[5\] sky130_fd_sc_hd__dfxtp_1
X_12923_ _06343_ VGND VGND VPWR VPWR _06417_ sky130_fd_sc_hd__clkbuf_8
X_16691_ clknet_leaf_131_clk _01258_ VGND VGND VPWR VPWR cpuregs\[3\]\[5\] sky130_fd_sc_hd__dfxtp_1
XTAP_2252 VGND VPWR sky130_fd_sc_hd__tapvpwrvgnd_1
XTAP_2241 VGND VPWR sky130_fd_sc_hd__tapvpwrvgnd_1
XTAP_2230 VGND VPWR sky130_fd_sc_hd__tapvpwrvgnd_1
X_15642_ clknet_leaf_118_clk _00292_ VGND VGND VPWR VPWR cpuregs\[14\]\[0\] sky130_fd_sc_hd__dfxtp_1
X_12854_ _06351_ _06352_ _03377_ VGND VGND VPWR VPWR _06353_ sky130_fd_sc_hd__a21o_1
X_15573_ clknet_leaf_73_clk _00223_ VGND VGND VPWR VPWR cpuregs\[2\]\[27\] sky130_fd_sc_hd__dfxtp_1
X_12785_ net1546 net69 _06302_ VGND VGND VPWR VPWR _06307_ sky130_fd_sc_hd__mux2_1
XTAP_2296 VGND VPWR sky130_fd_sc_hd__tapvpwrvgnd_1
XTAP_2285 VGND VPWR sky130_fd_sc_hd__tapvpwrvgnd_1
XTAP_2274 VGND VPWR sky130_fd_sc_hd__tapvpwrvgnd_1
XTAP_2263 VGND VPWR sky130_fd_sc_hd__tapvpwrvgnd_1
XTAP_1540 VGND VPWR sky130_fd_sc_hd__tapvpwrvgnd_1
XTAP_1551 VGND VPWR sky130_fd_sc_hd__tapvpwrvgnd_1
XFILLER_0_56_514 VGND VGND VPWR VPWR sky130_fd_sc_hd__fill_1
X_11805_ _05525_ _05527_ VGND VGND VPWR VPWR _00582_ sky130_fd_sc_hd__nor2_1
XFILLER_0_139_785 VPWR VGND VPWR VGND sky130_ef_sc_hd__decap_12
XFILLER_0_138_251 VGND VGND VPWR VPWR sky130_fd_sc_hd__fill_1
XTAP_1584 VGND VPWR sky130_fd_sc_hd__tapvpwrvgnd_1
XTAP_1573 VGND VPWR sky130_fd_sc_hd__tapvpwrvgnd_1
XTAP_1562 VGND VPWR sky130_fd_sc_hd__tapvpwrvgnd_1
X_14524_ _01626_ VGND VGND VPWR VPWR _01137_ sky130_fd_sc_hd__clkbuf_1
XPHY_91 VGND VGND VPWR VPWR sky130_fd_sc_hd__decap_3
X_11736_ _05488_ VGND VGND VPWR VPWR _00552_ sky130_fd_sc_hd__clkbuf_1
XFILLER_0_22_13 VPWR VGND VPWR VGND sky130_ef_sc_hd__decap_12
XFILLER_0_28_216 VGND VGND VPWR VPWR sky130_fd_sc_hd__fill_2
XPHY_80 VGND VGND VPWR VPWR sky130_fd_sc_hd__decap_3
XTAP_1595 VGND VPWR sky130_fd_sc_hd__tapvpwrvgnd_1
XFILLER_0_71_539 VGND VGND VPWR VPWR sky130_fd_sc_hd__decap_4
X_14455_ net572 _05186_ _01587_ VGND VGND VPWR VPWR _01590_ sky130_fd_sc_hd__mux2_1
X_11667_ net1017 _05169_ _05447_ VGND VGND VPWR VPWR _05452_ sky130_fd_sc_hd__mux2_1
XFILLER_0_37_783 VGND VGND VPWR VPWR sky130_fd_sc_hd__fill_1
X_10618_ _03794_ _04812_ _04825_ _03992_ reg_pc\[28\] VGND VGND VPWR VPWR _04826_
+ sky130_fd_sc_hd__a32o_1
X_13406_ _06682_ _06886_ VGND VGND VPWR VPWR _06887_ sky130_fd_sc_hd__and2_1
X_14386_ _01553_ VGND VGND VPWR VPWR _01040_ sky130_fd_sc_hd__clkbuf_1
XFILLER_0_52_742 VGND VGND VPWR VPWR sky130_fd_sc_hd__fill_1
X_11598_ _05415_ VGND VGND VPWR VPWR _00487_ sky130_fd_sc_hd__clkbuf_1
X_10549_ cpuregs\[14\]\[27\] cpuregs\[15\]\[27\] _04058_ VGND VGND VPWR VPWR _04758_
+ sky130_fd_sc_hd__mux2_1
X_13337_ _06518_ _06819_ VGND VGND VPWR VPWR _06820_ sky130_fd_sc_hd__or2_1
X_16125_ clknet_leaf_13_clk _07643_ VGND VGND VPWR VPWR reg_out\[3\] sky130_fd_sc_hd__dfxtp_1
X_16056_ clknet_leaf_37_clk _00706_ VGND VGND VPWR VPWR reg_next_pc\[31\] sky130_fd_sc_hd__dfxtp_1
X_15007_ _01882_ VGND VGND VPWR VPWR _01364_ sky130_fd_sc_hd__clkbuf_1
X_13268_ cpuregs\[28\]\[14\] cpuregs\[29\]\[14\] _06687_ VGND VGND VPWR VPWR _06753_
+ sky130_fd_sc_hd__mux2_1
XFILLER_0_121_195 VPWR VGND VPWR VGND sky130_ef_sc_hd__decap_12
X_12219_ decoded_imm_j\[8\] _05708_ VGND VGND VPWR VPWR _05841_ sky130_fd_sc_hd__and2_1
X_13199_ cpuregs\[24\]\[12\] cpuregs\[25\]\[12\] cpuregs\[26\]\[12\] cpuregs\[27\]\[12\]
+ _06525_ _06558_ VGND VGND VPWR VPWR _06686_ sky130_fd_sc_hd__mux4_1
X_16958_ clknet_leaf_102_clk _01522_ VGND VGND VPWR VPWR cpuregs\[10\]\[13\] sky130_fd_sc_hd__dfxtp_1
X_07760_ _02178_ VGND VGND VPWR VPWR _00020_ sky130_fd_sc_hd__clkbuf_1
X_15909_ clknet_leaf_98_clk _00559_ VGND VGND VPWR VPWR cpuregs\[17\]\[11\] sky130_fd_sc_hd__dfxtp_1
XFILLER_0_63_31 VPWR VGND VPWR VGND sky130_ef_sc_hd__decap_12
X_07691_ instr_auipc instr_lui VGND VGND VPWR VPWR _02118_ sky130_fd_sc_hd__or2_2
X_16889_ clknet_leaf_114_clk _01453_ VGND VGND VPWR VPWR cpuregs\[8\]\[8\] sky130_fd_sc_hd__dfxtp_1
X_09430_ _03665_ VGND VGND VPWR VPWR _03666_ sky130_fd_sc_hd__buf_8
X_09361_ _03604_ VGND VGND VPWR VPWR _00061_ sky130_fd_sc_hd__clkbuf_1
XFILLER_0_86_160 VGND VGND VPWR VPWR sky130_fd_sc_hd__fill_1
XFILLER_0_59_352 VGND VGND VPWR VPWR sky130_fd_sc_hd__decap_3
XFILLER_0_47_503 VGND VGND VPWR VPWR sky130_fd_sc_hd__fill_1
X_08312_ net177 net209 VGND VGND VPWR VPWR _02693_ sky130_fd_sc_hd__nand2_1
X_09292_ net1134 _03544_ _03512_ VGND VGND VPWR VPWR _03545_ sky130_fd_sc_hd__mux2_1
XFILLER_0_86_182 VPWR VGND VPWR VGND sky130_ef_sc_hd__decap_12
X_08243_ reg_pc\[29\] decoded_imm\[29\] VGND VGND VPWR VPWR _02627_ sky130_fd_sc_hd__or2_1
XANTENNA_23 _03977_ VGND VGND VPWR VPWR sky130_fd_sc_hd__diode_2
XANTENNA_12 _03648_ VGND VGND VPWR VPWR sky130_fd_sc_hd__diode_2
XANTENNA_56 net72 VGND VGND VPWR VPWR sky130_fd_sc_hd__diode_2
XANTENNA_45 net29 VGND VGND VPWR VPWR sky130_fd_sc_hd__diode_2
XANTENNA_34 net1 VGND VGND VPWR VPWR sky130_fd_sc_hd__diode_2
XFILLER_0_34_208 VGND VGND VPWR VPWR sky130_fd_sc_hd__decap_6
XANTENNA_78 net104 VGND VGND VPWR VPWR sky130_fd_sc_hd__diode_2
X_08174_ _02561_ _02562_ VGND VGND VPWR VPWR _02563_ sky130_fd_sc_hd__and2_1
XANTENNA_67 net83 VGND VGND VPWR VPWR sky130_fd_sc_hd__diode_2
XANTENNA_89 net123 VGND VGND VPWR VPWR sky130_fd_sc_hd__diode_2
XFILLER_0_7_677 VGND VGND VPWR VPWR sky130_fd_sc_hd__fill_1
XFILLER_0_15_444 VGND VGND VPWR VPWR sky130_fd_sc_hd__decap_4
XFILLER_0_42_263 VGND VGND VPWR VPWR sky130_fd_sc_hd__fill_2
XFILLER_0_140_460 VGND VGND VPWR VPWR sky130_fd_sc_hd__fill_1
Xoutput152 net152 VGND VGND VPWR VPWR mem_wdata[25] sky130_fd_sc_hd__clkbuf_4
XFILLER_0_113_685 VGND VGND VPWR VPWR sky130_fd_sc_hd__decap_8
Xoutput130 net130 VGND VGND VPWR VPWR mem_la_wstrb[0] sky130_fd_sc_hd__clkbuf_4
XFILLER_0_88_83 VGND VGND VPWR VPWR sky130_fd_sc_hd__fill_1
Xoutput141 net141 VGND VGND VPWR VPWR mem_wdata[15] sky130_fd_sc_hd__clkbuf_4
Xoutput174 net174 VGND VGND VPWR VPWR pcpi_rs1[12] sky130_fd_sc_hd__clkbuf_4
Xoutput185 net185 VGND VGND VPWR VPWR pcpi_rs1[22] sky130_fd_sc_hd__clkbuf_4
Xoutput163 net163 VGND VGND VPWR VPWR mem_wdata[6] sky130_fd_sc_hd__buf_2
Xoutput196 net196 VGND VGND VPWR VPWR pcpi_rs1[3] sky130_fd_sc_hd__clkbuf_4
X_07958_ reg_pc\[10\] decoded_imm\[10\] VGND VGND VPWR VPWR _02361_ sky130_fd_sc_hd__nand2_1
X_07889_ net28 net130 _02296_ _02219_ VGND VGND VPWR VPWR _02297_ sky130_fd_sc_hd__a22o_1
XFILLER_0_69_127 VPWR VGND VPWR VGND sky130_ef_sc_hd__decap_12
X_09628_ _03857_ _03859_ _03856_ VGND VGND VPWR VPWR _03861_ sky130_fd_sc_hd__o21ai_1
X_09559_ _03709_ VGND VGND VPWR VPWR _03793_ sky130_fd_sc_hd__clkbuf_4
XFILLER_0_78_650 VGND VGND VPWR VPWR sky130_fd_sc_hd__decap_3
XFILLER_0_66_823 VGND VGND VPWR VPWR sky130_fd_sc_hd__fill_2
X_12570_ _06147_ VGND VGND VPWR VPWR _00727_ sky130_fd_sc_hd__clkbuf_1
XFILLER_0_135_210 VGND VGND VPWR VPWR sky130_fd_sc_hd__fill_1
XFILLER_0_92_141 VGND VGND VPWR VPWR sky130_fd_sc_hd__decap_8
XFILLER_0_65_377 VGND VGND VPWR VPWR sky130_fd_sc_hd__fill_1
X_11521_ _04905_ _05373_ VGND VGND VPWR VPWR _05374_ sky130_fd_sc_hd__or2_4
XFILLER_0_136_788 VPWR VGND VPWR VGND sky130_ef_sc_hd__decap_12
X_14240_ _07545_ VGND VGND VPWR VPWR _00978_ sky130_fd_sc_hd__clkbuf_1
X_11452_ _04944_ _05227_ VGND VGND VPWR VPWR _05337_ sky130_fd_sc_hd__nor2_4
X_10403_ _02493_ _02536_ _02605_ _02567_ _03364_ _03916_ VGND VGND VPWR VPWR _04616_
+ sky130_fd_sc_hd__mux4_1
X_11383_ _05300_ VGND VGND VPWR VPWR _00387_ sky130_fd_sc_hd__clkbuf_1
XFILLER_0_61_561 VGND VGND VPWR VPWR sky130_fd_sc_hd__fill_1
XFILLER_0_1_809 VGND VGND VPWR VPWR sky130_fd_sc_hd__decap_4
X_14171_ is_alu_reg_imm _07306_ _07319_ net236 VGND VGND VPWR VPWR _00949_ sky130_fd_sc_hd__a22o_1
XFILLER_0_33_241 VPWR VGND VPWR VGND sky130_ef_sc_hd__decap_12
X_10334_ cpuregs\[14\]\[21\] cpuregs\[15\]\[21\] _03801_ VGND VGND VPWR VPWR _04549_
+ sky130_fd_sc_hd__mux2_1
X_13122_ _06580_ _06610_ VGND VGND VPWR VPWR _06611_ sky130_fd_sc_hd__or2_1
XFILLER_0_21_458 VGND VGND VPWR VPWR sky130_fd_sc_hd__decap_4
X_10265_ cpuregs\[12\]\[19\] cpuregs\[13\]\[19\] _04058_ VGND VGND VPWR VPWR _04482_
+ sky130_fd_sc_hd__mux2_1
XTAP_609 VGND VPWR sky130_fd_sc_hd__tapvpwrvgnd_1
X_13053_ cpuregs\[4\]\[8\] cpuregs\[5\]\[8\] _06383_ VGND VGND VPWR VPWR _06544_ sky130_fd_sc_hd__mux2_1
X_10196_ cpuregs\[4\]\[17\] cpuregs\[5\]\[17\] cpuregs\[6\]\[17\] cpuregs\[7\]\[17\]
+ _03902_ _03718_ VGND VGND VPWR VPWR _04415_ sky130_fd_sc_hd__mux4_1
X_12004_ _05631_ _05671_ VGND VGND VPWR VPWR _05672_ sky130_fd_sc_hd__nor2_1
X_16812_ clknet_leaf_73_clk _01376_ VGND VGND VPWR VPWR cpuregs\[6\]\[27\] sky130_fd_sc_hd__dfxtp_1
XFILLER_0_108_15 VGND VGND VPWR VPWR sky130_fd_sc_hd__fill_1
X_16743_ clknet_leaf_76_clk _01307_ VGND VGND VPWR VPWR cpuregs\[4\]\[22\] sky130_fd_sc_hd__dfxtp_1
X_13955_ _07334_ _07364_ net242 _07382_ net405 VGND VGND VPWR VPWR _00868_ sky130_fd_sc_hd__a32o_1
X_16674_ clknet_leaf_60_clk _01241_ VGND VGND VPWR VPWR cpuregs\[29\]\[20\] sky130_fd_sc_hd__dfxtp_1
XFILLER_0_88_458 VGND VGND VPWR VPWR sky130_fd_sc_hd__decap_3
X_12906_ _03357_ _06397_ _06403_ _03360_ VGND VGND VPWR VPWR _06404_ sky130_fd_sc_hd__o31a_1
X_13886_ _07332_ _07336_ VGND VGND VPWR VPWR _07337_ sky130_fd_sc_hd__and2_1
XTAP_2060 VGND VPWR sky130_fd_sc_hd__tapvpwrvgnd_1
X_15625_ clknet_leaf_93_clk _00275_ VGND VGND VPWR VPWR cpuregs\[31\]\[15\] sky130_fd_sc_hd__dfxtp_1
X_12837_ _03306_ _03946_ _06338_ VGND VGND VPWR VPWR _06339_ sky130_fd_sc_hd__or3b_1
XTAP_2093 VGND VPWR sky130_fd_sc_hd__tapvpwrvgnd_1
XTAP_2082 VGND VPWR sky130_fd_sc_hd__tapvpwrvgnd_1
XTAP_2071 VGND VPWR sky130_fd_sc_hd__tapvpwrvgnd_1
X_12768_ net556 net91 _06294_ VGND VGND VPWR VPWR _06298_ sky130_fd_sc_hd__mux2_1
XFILLER_0_84_664 VGND VGND VPWR VPWR sky130_fd_sc_hd__fill_1
XTAP_1392 VGND VPWR sky130_fd_sc_hd__tapvpwrvgnd_1
XTAP_1381 VGND VPWR sky130_fd_sc_hd__tapvpwrvgnd_1
XTAP_1370 VGND VPWR sky130_fd_sc_hd__tapvpwrvgnd_1
XFILLER_0_68_193 VGND VGND VPWR VPWR sky130_fd_sc_hd__decap_3
X_15556_ clknet_leaf_109_clk _00206_ VGND VGND VPWR VPWR cpuregs\[2\]\[10\] sky130_fd_sc_hd__dfxtp_1
XFILLER_0_126_221 VGND VGND VPWR VPWR sky130_fd_sc_hd__decap_4
X_11719_ net777 _05221_ _05469_ VGND VGND VPWR VPWR _05479_ sky130_fd_sc_hd__mux2_1
XFILLER_0_71_303 VGND VGND VPWR VPWR sky130_fd_sc_hd__fill_2
X_12699_ _06239_ VGND VGND VPWR VPWR _00764_ sky130_fd_sc_hd__clkbuf_1
X_14507_ _01617_ VGND VGND VPWR VPWR _01129_ sky130_fd_sc_hd__clkbuf_1
X_15487_ clknet_leaf_130_clk _00137_ VGND VGND VPWR VPWR cpuregs\[30\]\[5\] sky130_fd_sc_hd__dfxtp_1
Xinput10 mem_rdata[18] VGND VGND VPWR VPWR net10 sky130_fd_sc_hd__buf_2
XFILLER_0_140_57 VGND VGND VPWR VPWR sky130_fd_sc_hd__fill_2
XFILLER_0_3_102 VGND VGND VPWR VPWR sky130_fd_sc_hd__fill_1
Xinput21 mem_rdata[28] VGND VGND VPWR VPWR net21 sky130_fd_sc_hd__buf_4
X_14438_ net830 _05169_ _01576_ VGND VGND VPWR VPWR _01581_ sky130_fd_sc_hd__mux2_1
Xinput32 mem_rdata[9] VGND VGND VPWR VPWR net32 sky130_fd_sc_hd__clkbuf_4
Xhold805 cpuregs\[16\]\[26\] VGND VGND VPWR VPWR net1163 sky130_fd_sc_hd__dlygate4sd3_1
X_16108_ clknet_leaf_152_clk _00758_ VGND VGND VPWR VPWR count_cycle\[51\] sky130_fd_sc_hd__dfxtp_1
X_14369_ _01544_ VGND VGND VPWR VPWR _01032_ sky130_fd_sc_hd__clkbuf_1
Xhold816 cpuregs\[8\]\[5\] VGND VGND VPWR VPWR net1174 sky130_fd_sc_hd__dlygate4sd3_1
Xhold827 cpuregs\[4\]\[2\] VGND VGND VPWR VPWR net1185 sky130_fd_sc_hd__dlygate4sd3_1
Xhold838 cpuregs\[10\]\[20\] VGND VGND VPWR VPWR net1196 sky130_fd_sc_hd__dlygate4sd3_1
XFILLER_0_58_20 VGND VGND VPWR VPWR sky130_fd_sc_hd__fill_1
Xhold849 cpuregs\[3\]\[13\] VGND VGND VPWR VPWR net1207 sky130_fd_sc_hd__dlygate4sd3_1
X_17088_ net251 VGND VGND VPWR VPWR net229 sky130_fd_sc_hd__clkbuf_2
XFILLER_0_0_831 VGND VGND VPWR VPWR sky130_fd_sc_hd__fill_1
X_16039_ clknet_leaf_30_clk _00689_ VGND VGND VPWR VPWR reg_next_pc\[14\] sky130_fd_sc_hd__dfxtp_1
X_08930_ _02366_ _03243_ _03227_ VGND VGND VPWR VPWR _03244_ sky130_fd_sc_hd__mux2_2
X_08861_ _02143_ _02748_ net248 _02187_ VGND VGND VPWR VPWR _03206_ sky130_fd_sc_hd__a22o_1
XFILLER_0_58_97 VGND VGND VPWR VPWR sky130_fd_sc_hd__decap_3
X_07812_ _02213_ VGND VGND VPWR VPWR _02224_ sky130_fd_sc_hd__clkbuf_4
X_08792_ _02593_ _03145_ VGND VGND VPWR VPWR _03147_ sky130_fd_sc_hd__nor2_1
XFILLER_0_74_85 VGND VGND VPWR VPWR sky130_fd_sc_hd__decap_6
X_07743_ _02085_ VGND VGND VPWR VPWR _02164_ sky130_fd_sc_hd__buf_4
XFILLER_0_79_458 VGND VGND VPWR VPWR sky130_fd_sc_hd__fill_1
XFILLER_0_79_436 VGND VGND VPWR VPWR sky130_fd_sc_hd__fill_2
X_07674_ mem_do_prefetch _02101_ VGND VGND VPWR VPWR _02104_ sky130_fd_sc_hd__nand2_2
X_09413_ instr_srl instr_srli _03648_ VGND VGND VPWR VPWR _03649_ sky130_fd_sc_hd__or3_1
X_09344_ _03546_ _03586_ _03587_ _03589_ VGND VGND VPWR VPWR _03590_ sky130_fd_sc_hd__a22o_2
XFILLER_0_74_141 VGND VGND VPWR VPWR sky130_fd_sc_hd__decap_6
XFILLER_0_47_333 VGND VGND VPWR VPWR sky130_fd_sc_hd__decap_3
X_09275_ _03467_ _03529_ VGND VGND VPWR VPWR _03530_ sky130_fd_sc_hd__nor2_1
X_08226_ _02587_ _02601_ VGND VGND VPWR VPWR _02611_ sky130_fd_sc_hd__or2_1
XFILLER_0_62_336 VGND VGND VPWR VPWR sky130_fd_sc_hd__decap_3
XFILLER_0_132_213 VGND VGND VPWR VPWR sky130_fd_sc_hd__fill_1
X_08157_ net16 _02466_ _02429_ VGND VGND VPWR VPWR _02547_ sky130_fd_sc_hd__a21o_1
XFILLER_0_43_561 VGND VGND VPWR VPWR sky130_fd_sc_hd__fill_1
XFILLER_0_132_279 VGND VGND VPWR VPWR sky130_fd_sc_hd__fill_2
X_08088_ _02286_ _02473_ _02482_ VGND VGND VPWR VPWR _07627_ sky130_fd_sc_hd__o21a_1
XFILLER_0_30_288 VGND VGND VPWR VPWR sky130_fd_sc_hd__decap_8
X_10050_ _03823_ _04272_ _03730_ VGND VGND VPWR VPWR _04273_ sky130_fd_sc_hd__a21o_1
XFILLER_0_98_701 VGND VGND VPWR VPWR sky130_fd_sc_hd__fill_1
X_13740_ cpuregs\[6\]\[29\] cpuregs\[7\]\[29\] _06383_ VGND VGND VPWR VPWR _07210_
+ sky130_fd_sc_hd__mux2_1
XFILLER_0_97_222 VGND VGND VPWR VPWR sky130_fd_sc_hd__fill_2
X_10952_ _04993_ net1056 _05052_ VGND VGND VPWR VPWR _05057_ sky130_fd_sc_hd__mux2_1
X_15410_ clknet_leaf_71_clk _00065_ VGND VGND VPWR VPWR cpuregs\[11\]\[28\] sky130_fd_sc_hd__dfxtp_1
X_13671_ _07143_ VGND VGND VPWR VPWR _00832_ sky130_fd_sc_hd__clkbuf_1
XFILLER_0_78_491 VGND VGND VPWR VPWR sky130_fd_sc_hd__fill_2
X_10883_ _05011_ VGND VGND VPWR VPWR _00176_ sky130_fd_sc_hd__clkbuf_1
X_16390_ clknet_leaf_34_clk _00972_ VGND VGND VPWR VPWR net143 sky130_fd_sc_hd__dfxtp_1
XFILLER_0_109_733 VGND VGND VPWR VPWR sky130_fd_sc_hd__fill_1
X_12622_ count_cycle\[35\] _06178_ count_cycle\[36\] VGND VGND VPWR VPWR _06184_ sky130_fd_sc_hd__a21o_1
XFILLER_0_136_530 VGND VGND VPWR VPWR sky130_fd_sc_hd__fill_2
XFILLER_0_66_697 VGND VGND VPWR VPWR sky130_fd_sc_hd__decap_3
XFILLER_0_65_163 VGND VGND VPWR VPWR sky130_fd_sc_hd__decap_4
X_15341_ _02057_ VGND VGND VPWR VPWR _01523_ sky130_fd_sc_hd__clkbuf_1
X_12553_ count_cycle\[14\] count_cycle\[15\] count_cycle\[16\] _06127_ VGND VGND VPWR
+ VPWR _06135_ sky130_fd_sc_hd__and4_1
X_11504_ net765 _05211_ _05360_ VGND VGND VPWR VPWR _05365_ sky130_fd_sc_hd__mux2_1
XFILLER_0_53_347 VGND VGND VPWR VPWR sky130_fd_sc_hd__decap_3
X_15272_ _02021_ VGND VGND VPWR VPWR _01490_ sky130_fd_sc_hd__clkbuf_1
X_12484_ _05759_ _06073_ VGND VGND VPWR VPWR _06084_ sky130_fd_sc_hd__or2_1
XFILLER_0_102_9 VGND VGND VPWR VPWR sky130_fd_sc_hd__fill_2
X_14223_ _07536_ VGND VGND VPWR VPWR _00970_ sky130_fd_sc_hd__clkbuf_1
X_11435_ _05328_ VGND VGND VPWR VPWR _00411_ sky130_fd_sc_hd__clkbuf_1
XFILLER_0_110_49 VGND VGND VPWR VPWR sky130_fd_sc_hd__decap_6
X_14154_ _07497_ VGND VGND VPWR VPWR _00940_ sky130_fd_sc_hd__clkbuf_1
XFILLER_0_132_791 VGND VGND VPWR VPWR sky130_fd_sc_hd__fill_2
X_11366_ _05033_ net1473 _05288_ VGND VGND VPWR VPWR _05292_ sky130_fd_sc_hd__mux2_1
XFILLER_0_21_233 VGND VGND VPWR VPWR sky130_fd_sc_hd__fill_2
X_11297_ net1538 _05209_ _05251_ VGND VGND VPWR VPWR _05255_ sky130_fd_sc_hd__mux2_1
X_10317_ cpuregs\[24\]\[20\] cpuregs\[25\]\[20\] cpuregs\[26\]\[20\] cpuregs\[27\]\[20\]
+ _03935_ _04200_ VGND VGND VPWR VPWR _04533_ sky130_fd_sc_hd__mux4_1
XTAP_406 VGND VPWR sky130_fd_sc_hd__tapvpwrvgnd_1
X_14085_ _07359_ VGND VGND VPWR VPWR _07459_ sky130_fd_sc_hd__buf_4
X_13105_ _06459_ _06592_ _06594_ _06563_ VGND VGND VPWR VPWR _06595_ sky130_fd_sc_hd__a211o_1
X_10248_ cpuregs\[20\]\[18\] cpuregs\[21\]\[18\] cpuregs\[22\]\[18\] cpuregs\[23\]\[18\]
+ _04100_ _03936_ VGND VGND VPWR VPWR _04466_ sky130_fd_sc_hd__mux4_1
XTAP_439 VGND VPWR sky130_fd_sc_hd__tapvpwrvgnd_1
XTAP_428 VGND VPWR sky130_fd_sc_hd__tapvpwrvgnd_1
XTAP_417 VGND VPWR sky130_fd_sc_hd__tapvpwrvgnd_1
X_13036_ cpuregs\[30\]\[7\] cpuregs\[31\]\[7\] _06462_ VGND VGND VPWR VPWR _06528_
+ sky130_fd_sc_hd__mux2_1
X_10179_ reg_pc\[16\] _03992_ _04392_ _04398_ _03946_ VGND VGND VPWR VPWR _04399_
+ sky130_fd_sc_hd__a221o_1
X_14987_ _03484_ net812 _01865_ VGND VGND VPWR VPWR _01872_ sky130_fd_sc_hd__mux2_1
XFILLER_0_135_57 VPWR VGND VPWR VGND sky130_ef_sc_hd__decap_12
X_16726_ clknet_leaf_122_clk _01290_ VGND VGND VPWR VPWR cpuregs\[4\]\[5\] sky130_fd_sc_hd__dfxtp_1
X_13938_ instr_sltiu _07367_ _07364_ _07370_ VGND VGND VPWR VPWR _07371_ sky130_fd_sc_hd__a22o_1
XFILLER_0_88_266 VGND VGND VPWR VPWR sky130_fd_sc_hd__fill_1
XFILLER_0_88_244 VGND VGND VPWR VPWR sky130_fd_sc_hd__fill_1
XFILLER_0_44_55 VGND VGND VPWR VPWR sky130_fd_sc_hd__decap_4
XFILLER_0_119_508 VGND VGND VPWR VPWR sky130_fd_sc_hd__fill_1
XFILLER_0_44_88 VGND VGND VPWR VPWR sky130_fd_sc_hd__fill_1
X_16657_ clknet_leaf_123_clk _01224_ VGND VGND VPWR VPWR cpuregs\[29\]\[3\] sky130_fd_sc_hd__dfxtp_1
X_13869_ _07309_ _01096_ _01095_ _07321_ VGND VGND VPWR VPWR _07322_ sky130_fd_sc_hd__and4b_1
X_15608_ clknet_leaf_59_clk _00258_ VGND VGND VPWR VPWR cpuregs\[28\]\[30\] sky130_fd_sc_hd__dfxtp_1
XFILLER_0_56_141 VGND VGND VPWR VPWR sky130_fd_sc_hd__decap_3
X_16588_ clknet_leaf_5_clk _00022_ VGND VGND VPWR VPWR cpu_state\[5\] sky130_fd_sc_hd__dfxtp_2
X_15539_ clknet_leaf_72_clk _00189_ VGND VGND VPWR VPWR cpuregs\[13\]\[25\] sky130_fd_sc_hd__dfxtp_1
XFILLER_0_84_483 VGND VGND VPWR VPWR sky130_fd_sc_hd__decap_8
XFILLER_0_71_100 VGND VGND VPWR VPWR sky130_fd_sc_hd__decap_4
XFILLER_0_115_725 VGND VGND VPWR VPWR sky130_fd_sc_hd__decap_3
XFILLER_0_72_645 VGND VGND VPWR VPWR sky130_fd_sc_hd__decap_4
X_09060_ _03340_ VGND VGND VPWR VPWR _03341_ sky130_fd_sc_hd__buf_4
XFILLER_0_44_347 VGND VGND VPWR VPWR sky130_fd_sc_hd__fill_1
XFILLER_0_44_325 VGND VGND VPWR VPWR sky130_fd_sc_hd__decap_6
XFILLER_0_115_747 VGND VGND VPWR VPWR sky130_fd_sc_hd__decap_4
X_08011_ reg_pc\[14\] decoded_imm\[14\] VGND VGND VPWR VPWR _02410_ sky130_fd_sc_hd__or2_1
XFILLER_0_72_678 VGND VGND VPWR VPWR sky130_fd_sc_hd__decap_3
Xhold602 cpuregs\[27\]\[0\] VGND VGND VPWR VPWR net960 sky130_fd_sc_hd__dlygate4sd3_1
Xhold635 cpuregs\[4\]\[22\] VGND VGND VPWR VPWR net993 sky130_fd_sc_hd__dlygate4sd3_1
Xhold613 cpuregs\[23\]\[30\] VGND VGND VPWR VPWR net971 sky130_fd_sc_hd__dlygate4sd3_1
Xhold624 cpuregs\[25\]\[11\] VGND VGND VPWR VPWR net982 sky130_fd_sc_hd__dlygate4sd3_1
Xhold679 cpuregs\[3\]\[27\] VGND VGND VPWR VPWR net1037 sky130_fd_sc_hd__dlygate4sd3_1
Xhold668 cpuregs\[10\]\[28\] VGND VGND VPWR VPWR net1026 sky130_fd_sc_hd__dlygate4sd3_1
X_09962_ decoded_imm\[11\] net173 VGND VGND VPWR VPWR _04187_ sky130_fd_sc_hd__nand2_1
Xhold657 cpuregs\[1\]\[12\] VGND VGND VPWR VPWR net1015 sky130_fd_sc_hd__dlygate4sd3_1
XFILLER_0_12_266 VGND VGND VPWR VPWR sky130_fd_sc_hd__fill_2
Xhold646 cpuregs\[3\]\[6\] VGND VGND VPWR VPWR net1004 sky130_fd_sc_hd__dlygate4sd3_1
XFILLER_0_40_597 VGND VGND VPWR VPWR sky130_fd_sc_hd__fill_1
X_08913_ _03232_ VGND VGND VPWR VPWR net90 sky130_fd_sc_hd__clkbuf_4
XFILLER_0_0_661 VGND VGND VPWR VPWR sky130_fd_sc_hd__fill_2
XFILLER_0_85_51 VGND VGND VPWR VPWR sky130_fd_sc_hd__decap_4
XTAP_962 VGND VPWR sky130_fd_sc_hd__tapvpwrvgnd_1
XTAP_951 VGND VPWR sky130_fd_sc_hd__tapvpwrvgnd_1
XTAP_940 VGND VPWR sky130_fd_sc_hd__tapvpwrvgnd_1
X_09893_ cpuregs\[12\]\[9\] cpuregs\[13\]\[9\] _03767_ VGND VGND VPWR VPWR _04120_
+ sky130_fd_sc_hd__mux2_1
X_08844_ _03192_ _03194_ VGND VGND VPWR VPWR _03195_ sky130_fd_sc_hd__xnor2_1
XTAP_995 VGND VPWR sky130_fd_sc_hd__tapvpwrvgnd_1
XTAP_973 VGND VPWR sky130_fd_sc_hd__tapvpwrvgnd_1
XTAP_984 VGND VPWR sky130_fd_sc_hd__tapvpwrvgnd_1
Xhold1302 count_cycle\[57\] VGND VGND VPWR VPWR net1660 sky130_fd_sc_hd__dlygate4sd3_1
X_08775_ _03130_ _03131_ VGND VGND VPWR VPWR _03132_ sky130_fd_sc_hd__nand2_1
X_07726_ _02147_ VGND VGND VPWR VPWR _02148_ sky130_fd_sc_hd__buf_4
XFILLER_0_79_233 VGND VGND VPWR VPWR sky130_fd_sc_hd__fill_2
X_07657_ mem_state\[0\] mem_state\[1\] VGND VGND VPWR VPWR _02087_ sky130_fd_sc_hd__or2_1
XFILLER_0_137_316 VGND VGND VPWR VPWR sky130_fd_sc_hd__fill_2
X_09327_ reg_out\[20\] alu_out_q\[20\] _03436_ VGND VGND VPWR VPWR _03575_ sky130_fd_sc_hd__mux2_1
XFILLER_0_105_202 VGND VGND VPWR VPWR sky130_fd_sc_hd__decap_3
X_09258_ reg_pc\[11\] reg_pc\[10\] _03500_ VGND VGND VPWR VPWR _03515_ sky130_fd_sc_hd__and3_1
X_08209_ _02286_ _02584_ _02595_ VGND VGND VPWR VPWR _07636_ sky130_fd_sc_hd__o21a_1
X_09189_ _03453_ _03454_ _03449_ VGND VGND VPWR VPWR _03455_ sky130_fd_sc_hd__mux2_2
X_11220_ net587 _05209_ _05203_ VGND VGND VPWR VPWR _05210_ sky130_fd_sc_hd__mux2_1
XFILLER_0_43_391 VGND VGND VPWR VPWR sky130_fd_sc_hd__fill_1
X_11151_ _03450_ VGND VGND VPWR VPWR _05163_ sky130_fd_sc_hd__clkbuf_4
X_10102_ _04323_ _02416_ _04150_ VGND VGND VPWR VPWR _04324_ sky130_fd_sc_hd__mux2_1
X_11082_ net1621 _03451_ _05124_ VGND VGND VPWR VPWR _05126_ sky130_fd_sc_hd__mux2_1
X_15890_ clknet_leaf_58_clk _00540_ VGND VGND VPWR VPWR cpuregs\[20\]\[24\] sky130_fd_sc_hd__dfxtp_1
X_10033_ _04256_ VGND VGND VPWR VPWR _00081_ sky130_fd_sc_hd__clkbuf_1
X_14910_ _01831_ VGND VGND VPWR VPWR _01318_ sky130_fd_sc_hd__clkbuf_1
X_14841_ _03451_ net1027 _01793_ VGND VGND VPWR VPWR _01795_ sky130_fd_sc_hd__mux2_1
X_16511_ clknet_leaf_19_clk _00032_ VGND VGND VPWR VPWR _00012_ sky130_fd_sc_hd__dfxtp_4
X_14772_ net1297 _05163_ _01756_ VGND VGND VPWR VPWR _01758_ sky130_fd_sc_hd__mux2_1
X_11984_ count_instr\[51\] _05654_ VGND VGND VPWR VPWR _05657_ sky130_fd_sc_hd__and2_1
X_13723_ cpuregs\[28\]\[28\] cpuregs\[29\]\[28\] _07018_ VGND VGND VPWR VPWR _07194_
+ sky130_fd_sc_hd__mux2_1
X_10935_ _05046_ VGND VGND VPWR VPWR _00193_ sky130_fd_sc_hd__clkbuf_1
XFILLER_0_105_38 VGND VGND VPWR VPWR sky130_fd_sc_hd__fill_2
XFILLER_0_58_439 VGND VGND VPWR VPWR sky130_fd_sc_hd__decap_8
X_13654_ _06969_ _07122_ _07124_ _03309_ _07126_ VGND VGND VPWR VPWR _07127_ sky130_fd_sc_hd__o311a_1
XFILLER_0_85_269 VGND VGND VPWR VPWR sky130_fd_sc_hd__decap_8
X_16442_ clknet_leaf_8_clk _01024_ VGND VGND VPWR VPWR decoded_imm\[5\] sky130_fd_sc_hd__dfxtp_2
X_10866_ _04999_ net1633 _04985_ VGND VGND VPWR VPWR _05000_ sky130_fd_sc_hd__mux2_1
XPHY_261 VGND VGND VPWR VPWR sky130_fd_sc_hd__decap_3
XPHY_250 VGND VGND VPWR VPWR sky130_fd_sc_hd__decap_3
X_16373_ clknet_leaf_115_clk _00955_ VGND VGND VPWR VPWR net135 sky130_fd_sc_hd__dfxtp_1
X_12605_ count_cycle\[29\] count_cycle\[30\] _06165_ count_cycle\[31\] VGND VGND VPWR
+ VPWR _06172_ sky130_fd_sc_hd__a31o_1
XFILLER_0_26_303 VGND VGND VPWR VPWR sky130_fd_sc_hd__decap_4
XPHY_272 VGND VGND VPWR VPWR sky130_fd_sc_hd__decap_3
X_13585_ _03340_ _07059_ _06998_ VGND VGND VPWR VPWR _07060_ sky130_fd_sc_hd__a21o_1
X_10797_ net904 _03519_ _04957_ VGND VGND VPWR VPWR _04959_ sky130_fd_sc_hd__mux2_1
X_15324_ _02048_ VGND VGND VPWR VPWR _01515_ sky130_fd_sc_hd__clkbuf_1
XFILLER_0_124_533 VGND VGND VPWR VPWR sky130_fd_sc_hd__decap_8
XFILLER_0_124_522 VGND VGND VPWR VPWR sky130_fd_sc_hd__decap_8
X_12536_ _05631_ _06122_ VGND VGND VPWR VPWR _06123_ sky130_fd_sc_hd__nor2_1
XFILLER_0_124_555 VGND VGND VPWR VPWR sky130_fd_sc_hd__fill_2
X_12467_ _06057_ _06060_ _06055_ VGND VGND VPWR VPWR _06069_ sky130_fd_sc_hd__a21oi_1
XFILLER_0_22_520 VGND VGND VPWR VPWR sky130_fd_sc_hd__fill_1
X_15255_ net510 VGND VGND VPWR VPWR _02013_ sky130_fd_sc_hd__clkbuf_1
XFILLER_0_111_216 VGND VGND VPWR VPWR sky130_fd_sc_hd__decap_3
X_14206_ _07527_ VGND VGND VPWR VPWR _00962_ sky130_fd_sc_hd__clkbuf_1
X_11418_ _05319_ VGND VGND VPWR VPWR _00403_ sky130_fd_sc_hd__clkbuf_1
X_15186_ _01977_ VGND VGND VPWR VPWR _01448_ sky130_fd_sc_hd__clkbuf_1
X_12398_ _06005_ _05739_ _05997_ VGND VGND VPWR VPWR _06006_ sky130_fd_sc_hd__a21oi_1
X_14137_ _07488_ VGND VGND VPWR VPWR _00932_ sky130_fd_sc_hd__clkbuf_1
X_11349_ _05016_ net1477 _05277_ VGND VGND VPWR VPWR _05283_ sky130_fd_sc_hd__mux2_1
X_14068_ _07450_ VGND VGND VPWR VPWR _00901_ sky130_fd_sc_hd__clkbuf_1
X_13019_ _06510_ VGND VGND VPWR VPWR _06511_ sky130_fd_sc_hd__clkbuf_8
XFILLER_0_77_715 VGND VGND VPWR VPWR sky130_fd_sc_hd__fill_1
X_08560_ _02906_ _02912_ _02927_ _02932_ VGND VGND VPWR VPWR _02933_ sky130_fd_sc_hd__a31o_1
X_16709_ clknet_leaf_74_clk _01276_ VGND VGND VPWR VPWR cpuregs\[3\]\[23\] sky130_fd_sc_hd__dfxtp_1
XFILLER_0_89_597 VGND VGND VPWR VPWR sky130_fd_sc_hd__decap_4
X_08491_ _02857_ _02869_ _02756_ VGND VGND VPWR VPWR _02870_ sky130_fd_sc_hd__o21a_1
XFILLER_0_64_409 VGND VGND VPWR VPWR sky130_fd_sc_hd__decap_3
XFILLER_0_9_525 VGND VGND VPWR VPWR sky130_fd_sc_hd__fill_2
XFILLER_0_9_514 VGND VGND VPWR VPWR sky130_fd_sc_hd__fill_2
XFILLER_0_92_729 VGND VGND VPWR VPWR sky130_fd_sc_hd__decap_3
XFILLER_0_115_500 VGND VGND VPWR VPWR sky130_fd_sc_hd__decap_4
XFILLER_0_17_325 VGND VGND VPWR VPWR sky130_fd_sc_hd__decap_8
X_09112_ _03391_ decoded_imm_j\[3\] is_slli_srli_srai VGND VGND VPWR VPWR _03392_
+ sky130_fd_sc_hd__mux2_1
XFILLER_0_127_393 VGND VGND VPWR VPWR sky130_fd_sc_hd__fill_2
XFILLER_0_115_511 VGND VGND VPWR VPWR sky130_fd_sc_hd__decap_4
XFILLER_0_72_475 VGND VGND VPWR VPWR sky130_fd_sc_hd__fill_1
XFILLER_0_88_3 VGND VGND VPWR VPWR sky130_fd_sc_hd__fill_2
X_09043_ _00008_ VGND VGND VPWR VPWR _03324_ sky130_fd_sc_hd__buf_4
XFILLER_0_5_775 VGND VGND VPWR VPWR sky130_fd_sc_hd__decap_8
XFILLER_0_5_764 VGND VGND VPWR VPWR sky130_fd_sc_hd__fill_2
XFILLER_0_5_753 VGND VGND VPWR VPWR sky130_fd_sc_hd__decap_8
Xhold410 cpuregs\[30\]\[23\] VGND VGND VPWR VPWR net768 sky130_fd_sc_hd__dlygate4sd3_1
XFILLER_0_102_205 VGND VGND VPWR VPWR sky130_fd_sc_hd__decap_4
XFILLER_0_5_797 VPWR VGND VPWR VGND sky130_ef_sc_hd__decap_12
Xhold432 cpuregs\[22\]\[29\] VGND VGND VPWR VPWR net790 sky130_fd_sc_hd__dlygate4sd3_1
Xhold421 cpuregs\[6\]\[15\] VGND VGND VPWR VPWR net779 sky130_fd_sc_hd__dlygate4sd3_1
Xhold454 cpuregs\[6\]\[6\] VGND VGND VPWR VPWR net812 sky130_fd_sc_hd__dlygate4sd3_1
Xhold443 cpuregs\[28\]\[0\] VGND VGND VPWR VPWR net801 sky130_fd_sc_hd__dlygate4sd3_1
Xhold465 cpuregs\[22\]\[23\] VGND VGND VPWR VPWR net823 sky130_fd_sc_hd__dlygate4sd3_1
Xhold487 cpuregs\[30\]\[18\] VGND VGND VPWR VPWR net845 sky130_fd_sc_hd__dlygate4sd3_1
Xhold476 cpuregs\[8\]\[10\] VGND VGND VPWR VPWR net834 sky130_fd_sc_hd__dlygate4sd3_1
Xhold498 cpuregs\[12\]\[25\] VGND VGND VPWR VPWR net856 sky130_fd_sc_hd__dlygate4sd3_1
X_09945_ cpuregs\[2\]\[10\] cpuregs\[3\]\[10\] _03977_ VGND VGND VPWR VPWR _04171_
+ sky130_fd_sc_hd__mux2_1
X_09876_ _04098_ _04099_ _04101_ _04102_ _04030_ _04103_ VGND VGND VPWR VPWR _04104_
+ sky130_fd_sc_hd__mux4_1
XTAP_770 VGND VPWR sky130_fd_sc_hd__tapvpwrvgnd_1
X_08827_ net224 _03178_ VGND VGND VPWR VPWR _03179_ sky130_fd_sc_hd__xnor2_1
Xhold1132 cpuregs\[16\]\[29\] VGND VGND VPWR VPWR net1490 sky130_fd_sc_hd__dlygate4sd3_1
XFILLER_0_99_306 VGND VGND VPWR VPWR sky130_fd_sc_hd__fill_2
Xhold1110 cpuregs\[20\]\[2\] VGND VGND VPWR VPWR net1468 sky130_fd_sc_hd__dlygate4sd3_1
XTAP_792 VGND VPWR sky130_fd_sc_hd__tapvpwrvgnd_1
XTAP_781 VGND VPWR sky130_fd_sc_hd__tapvpwrvgnd_1
Xhold1121 cpuregs\[2\]\[7\] VGND VGND VPWR VPWR net1479 sky130_fd_sc_hd__dlygate4sd3_1
Xhold1165 cpuregs\[1\]\[27\] VGND VGND VPWR VPWR net1523 sky130_fd_sc_hd__dlygate4sd3_1
Xhold1176 cpuregs\[29\]\[23\] VGND VGND VPWR VPWR net1534 sky130_fd_sc_hd__dlygate4sd3_1
Xhold1154 cpuregs\[17\]\[3\] VGND VGND VPWR VPWR net1512 sky130_fd_sc_hd__dlygate4sd3_1
Xhold1143 cpuregs\[28\]\[4\] VGND VGND VPWR VPWR net1501 sky130_fd_sc_hd__dlygate4sd3_1
Xhold1198 cpuregs\[21\]\[20\] VGND VGND VPWR VPWR net1556 sky130_fd_sc_hd__dlygate4sd3_1
X_08758_ _02977_ _02995_ VGND VGND VPWR VPWR _03115_ sky130_fd_sc_hd__nand2_1
Xhold1187 cpuregs\[19\]\[2\] VGND VGND VPWR VPWR net1545 sky130_fd_sc_hd__dlygate4sd3_1
XTAP_1925 VGND VPWR sky130_fd_sc_hd__tapvpwrvgnd_1
XTAP_1914 VGND VPWR sky130_fd_sc_hd__tapvpwrvgnd_1
XTAP_1903 VGND VPWR sky130_fd_sc_hd__tapvpwrvgnd_1
X_08689_ _02480_ net246 _03050_ _03051_ VGND VGND VPWR VPWR _03052_ sky130_fd_sc_hd__o22a_1
XFILLER_0_68_737 VGND VGND VPWR VPWR sky130_fd_sc_hd__fill_1
XFILLER_0_67_225 VGND VGND VPWR VPWR sky130_fd_sc_hd__fill_1
X_07709_ _02134_ net171 VGND VGND VPWR VPWR _02135_ sky130_fd_sc_hd__or2_1
XTAP_1958 VGND VPWR sky130_fd_sc_hd__tapvpwrvgnd_1
XTAP_1947 VGND VPWR sky130_fd_sc_hd__tapvpwrvgnd_1
XTAP_1936 VGND VPWR sky130_fd_sc_hd__tapvpwrvgnd_1
X_10720_ _04916_ VGND VGND VPWR VPWR _00108_ sky130_fd_sc_hd__clkbuf_1
XFILLER_0_137_146 VGND VGND VPWR VPWR sky130_fd_sc_hd__decap_6
XFILLER_0_137_113 VPWR VGND VPWR VGND sky130_ef_sc_hd__decap_12
XTAP_1969 VGND VPWR sky130_fd_sc_hd__tapvpwrvgnd_1
X_10651_ cpuregs\[24\]\[29\] cpuregs\[25\]\[29\] cpuregs\[26\]\[29\] cpuregs\[27\]\[29\]
+ _03831_ _03832_ VGND VGND VPWR VPWR _04858_ sky130_fd_sc_hd__mux4_1
XFILLER_0_134_831 VGND VGND VPWR VPWR sky130_fd_sc_hd__fill_1
X_10582_ _04787_ _04788_ _03365_ _04789_ VGND VGND VPWR VPWR _04790_ sky130_fd_sc_hd__a2bb2o_1
XFILLER_0_91_762 VGND VGND VPWR VPWR sky130_fd_sc_hd__fill_1
X_13370_ cpuregs\[20\]\[17\] cpuregs\[21\]\[17\] _06784_ VGND VGND VPWR VPWR _06852_
+ sky130_fd_sc_hd__mux2_1
XFILLER_0_63_442 VGND VGND VPWR VPWR sky130_fd_sc_hd__decap_6
X_12321_ _05726_ _05931_ _05791_ VGND VGND VPWR VPWR _05935_ sky130_fd_sc_hd__a21o_1
XFILLER_0_35_166 VGND VGND VPWR VPWR sky130_fd_sc_hd__fill_2
XFILLER_0_133_374 VGND VGND VPWR VPWR sky130_fd_sc_hd__fill_1
XFILLER_0_121_514 VGND VGND VPWR VPWR sky130_fd_sc_hd__decap_3
XFILLER_0_121_503 VGND VGND VPWR VPWR sky130_fd_sc_hd__fill_1
X_12252_ decoded_imm_j\[9\] _05710_ _05861_ VGND VGND VPWR VPWR _05872_ sky130_fd_sc_hd__a21boi_1
X_15040_ _01899_ VGND VGND VPWR VPWR _01380_ sky130_fd_sc_hd__clkbuf_1
XFILLER_0_121_547 VGND VGND VPWR VPWR sky130_fd_sc_hd__fill_2
X_11203_ _03563_ VGND VGND VPWR VPWR _05198_ sky130_fd_sc_hd__clkbuf_4
X_12183_ _05807_ VGND VGND VPWR VPWR _05808_ sky130_fd_sc_hd__inv_2
X_11134_ net1146 _03616_ _05146_ VGND VGND VPWR VPWR _05153_ sky130_fd_sc_hd__mux2_1
X_11065_ _05116_ VGND VGND VPWR VPWR _00253_ sky130_fd_sc_hd__clkbuf_1
X_15942_ clknet_leaf_144_clk _00592_ VGND VGND VPWR VPWR count_instr\[11\] sky130_fd_sc_hd__dfxtp_1
X_10016_ _03663_ _04235_ _04239_ _03685_ VGND VGND VPWR VPWR _04240_ sky130_fd_sc_hd__o211a_1
X_15873_ clknet_leaf_129_clk _00523_ VGND VGND VPWR VPWR cpuregs\[20\]\[7\] sky130_fd_sc_hd__dfxtp_1
X_14824_ net854 _05215_ _01778_ VGND VGND VPWR VPWR _01785_ sky130_fd_sc_hd__mux2_1
XFILLER_0_98_350 VGND VGND VPWR VPWR sky130_fd_sc_hd__fill_1
X_14755_ _01748_ VGND VGND VPWR VPWR _01246_ sky130_fd_sc_hd__clkbuf_1
X_11967_ count_instr\[46\] count_instr\[45\] count_instr\[44\] _05637_ VGND VGND VPWR
+ VPWR _05645_ sky130_fd_sc_hd__and4_1
X_13706_ _06431_ _07174_ _07176_ VGND VGND VPWR VPWR _07177_ sky130_fd_sc_hd__a21o_1
X_10918_ _03602_ VGND VGND VPWR VPWR _05035_ sky130_fd_sc_hd__clkbuf_4
XFILLER_0_86_567 VGND VGND VPWR VPWR sky130_fd_sc_hd__fill_1
X_14686_ net1167 _05213_ _01706_ VGND VGND VPWR VPWR _01712_ sky130_fd_sc_hd__mux2_1
XFILLER_0_74_729 VGND VGND VPWR VPWR sky130_fd_sc_hd__fill_1
X_16425_ clknet_leaf_24_clk _01007_ VGND VGND VPWR VPWR decoded_imm\[22\] sky130_fd_sc_hd__dfxtp_2
X_11898_ count_instr\[27\] _05591_ VGND VGND VPWR VPWR _05595_ sky130_fd_sc_hd__or2_1
X_13637_ _06442_ _07106_ _07110_ _06428_ VGND VGND VPWR VPWR _07111_ sky130_fd_sc_hd__o211a_1
X_10849_ _04988_ VGND VGND VPWR VPWR _00165_ sky130_fd_sc_hd__clkbuf_1
X_16356_ clknet_leaf_75_clk _00938_ VGND VGND VPWR VPWR cpuregs\[1\]\[21\] sky130_fd_sc_hd__dfxtp_1
XFILLER_0_125_820 VGND VGND VPWR VPWR sky130_fd_sc_hd__fill_2
X_13568_ cpuregs\[20\]\[23\] cpuregs\[21\]\[23\] _06784_ VGND VGND VPWR VPWR _07044_
+ sky130_fd_sc_hd__mux2_1
XFILLER_0_15_818 VPWR VGND VPWR VGND sky130_ef_sc_hd__decap_12
XFILLER_0_41_89 VGND VGND VPWR VPWR sky130_fd_sc_hd__fill_2
XFILLER_0_109_393 VGND VGND VPWR VPWR sky130_fd_sc_hd__fill_1
X_15307_ net522 VGND VGND VPWR VPWR _02039_ sky130_fd_sc_hd__clkbuf_1
XFILLER_0_14_306 VGND VGND VPWR VPWR sky130_fd_sc_hd__fill_2
X_12519_ count_cycle\[6\] _06107_ VGND VGND VPWR VPWR _06111_ sky130_fd_sc_hd__or2_1
XFILLER_0_26_166 VPWR VGND VPWR VGND sky130_ef_sc_hd__decap_12
X_16287_ clknet_leaf_149_clk _00872_ VGND VGND VPWR VPWR instr_sll sky130_fd_sc_hd__dfxtp_1
XFILLER_0_140_823 VGND VGND VPWR VPWR sky130_fd_sc_hd__fill_1
X_13499_ _06969_ _06972_ _06974_ _06739_ _06976_ VGND VGND VPWR VPWR _06977_ sky130_fd_sc_hd__o311a_1
X_15238_ _02004_ VGND VGND VPWR VPWR _01473_ sky130_fd_sc_hd__clkbuf_1
XFILLER_0_2_701 VGND VGND VPWR VPWR sky130_fd_sc_hd__fill_2
XFILLER_0_41_125 VGND VGND VPWR VPWR sky130_fd_sc_hd__decap_4
XFILLER_0_41_147 VGND VGND VPWR VPWR sky130_fd_sc_hd__fill_2
XFILLER_0_74_9 VGND VGND VPWR VPWR sky130_fd_sc_hd__fill_1
X_15169_ net838 _03628_ _01959_ VGND VGND VPWR VPWR _01968_ sky130_fd_sc_hd__mux2_1
X_07991_ count_instr\[44\] instr_rdinstrh count_cycle\[44\] instr_rdcycleh VGND VGND
+ VPWR VPWR _02392_ sky130_fd_sc_hd__a22o_1
Xclkbuf_4_7_0_clk clknet_0_clk VGND VGND VPWR VPWR clknet_4_7_0_clk sky130_fd_sc_hd__clkbuf_8
XFILLER_0_5_78 VGND VGND VPWR VPWR sky130_fd_sc_hd__decap_3
X_09730_ cpuregs\[14\]\[5\] cpuregs\[15\]\[5\] _03755_ VGND VGND VPWR VPWR _03961_
+ sky130_fd_sc_hd__mux2_1
X_09661_ _03875_ VGND VGND VPWR VPWR _03894_ sky130_fd_sc_hd__buf_6
X_09592_ _03673_ VGND VGND VPWR VPWR _03826_ sky130_fd_sc_hd__buf_4
XFILLER_0_96_309 VGND VGND VPWR VPWR sky130_fd_sc_hd__fill_1
X_08612_ _02963_ _02965_ _02956_ VGND VGND VPWR VPWR _02981_ sky130_fd_sc_hd__o21ai_1
XFILLER_0_77_501 VGND VGND VPWR VPWR sky130_fd_sc_hd__decap_3
X_08543_ _02916_ _02917_ _02665_ VGND VGND VPWR VPWR _02918_ sky130_fd_sc_hd__o21a_1
XFILLER_0_49_225 VGND VGND VPWR VPWR sky130_fd_sc_hd__decap_3
XFILLER_0_64_206 VGND VGND VPWR VPWR sky130_fd_sc_hd__decap_3
X_08474_ _02134_ _02851_ _02852_ VGND VGND VPWR VPWR _02854_ sky130_fd_sc_hd__or3_1
XFILLER_0_9_333 VGND VGND VPWR VPWR sky130_fd_sc_hd__decap_3
XFILLER_0_37_409 VGND VGND VPWR VPWR sky130_fd_sc_hd__decap_4
XFILLER_0_64_239 VGND VGND VPWR VPWR sky130_fd_sc_hd__decap_8
XFILLER_0_17_133 VPWR VGND VPWR VGND sky130_ef_sc_hd__decap_12
XFILLER_0_131_812 VPWR VGND VPWR VGND sky130_ef_sc_hd__decap_12
XFILLER_0_60_445 VPWR VGND VPWR VGND sky130_ef_sc_hd__decap_12
X_09026_ _00011_ VGND VGND VPWR VPWR _03307_ sky130_fd_sc_hd__clkbuf_4
XFILLER_0_41_670 VGND VGND VPWR VPWR sky130_fd_sc_hd__fill_2
Xhold262 cpuregs\[12\]\[26\] VGND VGND VPWR VPWR net620 sky130_fd_sc_hd__dlygate4sd3_1
Xhold251 cpuregs\[14\]\[15\] VGND VGND VPWR VPWR net609 sky130_fd_sc_hd__dlygate4sd3_1
Xhold240 cpuregs\[28\]\[5\] VGND VGND VPWR VPWR net598 sky130_fd_sc_hd__dlygate4sd3_1
Xhold273 cpuregs\[27\]\[18\] VGND VGND VPWR VPWR net631 sky130_fd_sc_hd__dlygate4sd3_1
Xhold284 cpuregs\[30\]\[2\] VGND VGND VPWR VPWR net642 sky130_fd_sc_hd__dlygate4sd3_1
Xhold295 _00915_ VGND VGND VPWR VPWR net653 sky130_fd_sc_hd__dlygate4sd3_1
X_09928_ _04152_ _04153_ VGND VGND VPWR VPWR _04154_ sky130_fd_sc_hd__nand2_1
XFILLER_0_99_125 VGND VGND VPWR VPWR sky130_fd_sc_hd__decap_8
X_09859_ _03901_ _04086_ _03796_ VGND VGND VPWR VPWR _04087_ sky130_fd_sc_hd__a21o_1
X_12870_ cpuregs\[0\]\[0\] cpuregs\[1\]\[0\] cpuregs\[2\]\[0\] cpuregs\[3\]\[0\] _03323_
+ _03325_ VGND VGND VPWR VPWR _06369_ sky130_fd_sc_hd__mux4_1
XFILLER_0_96_810 VGND VGND VPWR VPWR sky130_fd_sc_hd__fill_2
XTAP_1700 VGND VPWR sky130_fd_sc_hd__tapvpwrvgnd_1
XANTENNA_113 net235 VGND VGND VPWR VPWR sky130_fd_sc_hd__diode_2
XANTENNA_102 net188 VGND VGND VPWR VPWR sky130_fd_sc_hd__diode_2
X_11821_ _02085_ VGND VGND VPWR VPWR _05539_ sky130_fd_sc_hd__buf_4
XANTENNA_124 _03747_ VGND VGND VPWR VPWR sky130_fd_sc_hd__diode_2
XFILLER_0_138_400 VGND VGND VPWR VPWR sky130_fd_sc_hd__fill_2
X_14540_ net778 _05202_ _01634_ VGND VGND VPWR VPWR _01635_ sky130_fd_sc_hd__mux2_1
XTAP_1733 VGND VPWR sky130_fd_sc_hd__tapvpwrvgnd_1
XTAP_1722 VGND VPWR sky130_fd_sc_hd__tapvpwrvgnd_1
XTAP_1711 VGND VPWR sky130_fd_sc_hd__tapvpwrvgnd_1
XANTENNA_157 net120 VGND VGND VPWR VPWR sky130_fd_sc_hd__diode_2
XANTENNA_146 net131 VGND VGND VPWR VPWR sky130_fd_sc_hd__diode_2
XANTENNA_135 net30 VGND VGND VPWR VPWR sky130_fd_sc_hd__diode_2
XTAP_1766 VGND VPWR sky130_fd_sc_hd__tapvpwrvgnd_1
XTAP_1744 VGND VPWR sky130_fd_sc_hd__tapvpwrvgnd_1
XTAP_1755 VGND VPWR sky130_fd_sc_hd__tapvpwrvgnd_1
X_11752_ _05010_ net922 _05494_ VGND VGND VPWR VPWR _05497_ sky130_fd_sc_hd__mux2_1
XTAP_1799 VGND VPWR sky130_fd_sc_hd__tapvpwrvgnd_1
XTAP_1788 VGND VPWR sky130_fd_sc_hd__tapvpwrvgnd_1
XTAP_1777 VGND VPWR sky130_fd_sc_hd__tapvpwrvgnd_1
X_14471_ _01575_ VGND VGND VPWR VPWR _01598_ sky130_fd_sc_hd__buf_4
XFILLER_0_55_239 VGND VGND VPWR VPWR sky130_fd_sc_hd__decap_3
X_11683_ _05460_ VGND VGND VPWR VPWR _00527_ sky130_fd_sc_hd__clkbuf_1
X_10703_ net850 _03440_ _04907_ VGND VGND VPWR VPWR _04908_ sky130_fd_sc_hd__mux2_1
XFILLER_0_125_105 VGND VGND VPWR VPWR sky130_fd_sc_hd__decap_6
X_16210_ clknet_leaf_49_clk _00827_ VGND VGND VPWR VPWR net216 sky130_fd_sc_hd__dfxtp_4
X_10634_ cpuregs\[12\]\[29\] cpuregs\[13\]\[29\] _03749_ VGND VGND VPWR VPWR _04841_
+ sky130_fd_sc_hd__mux2_1
XFILLER_0_107_831 VGND VGND VPWR VPWR sky130_fd_sc_hd__fill_1
X_13422_ cpuregs\[10\]\[19\] cpuregs\[11\]\[19\] _06766_ VGND VGND VPWR VPWR _06902_
+ sky130_fd_sc_hd__mux2_1
XFILLER_0_64_751 VGND VGND VPWR VPWR sky130_fd_sc_hd__decap_4
XFILLER_0_11_15 VPWR VGND VPWR VGND sky130_ef_sc_hd__decap_12
X_16141_ clknet_leaf_31_clk _07628_ VGND VGND VPWR VPWR reg_out\[19\] sky130_fd_sc_hd__dfxtp_1
XFILLER_0_91_592 VGND VGND VPWR VPWR sky130_fd_sc_hd__decap_3
X_13353_ cpuregs\[8\]\[17\] cpuregs\[9\]\[17\] _06764_ VGND VGND VPWR VPWR _06835_
+ sky130_fd_sc_hd__mux2_1
XFILLER_0_24_615 VGND VGND VPWR VPWR sky130_fd_sc_hd__fill_2
XFILLER_0_36_475 VGND VGND VPWR VPWR sky130_fd_sc_hd__fill_1
XFILLER_0_140_119 VGND VGND VPWR VPWR sky130_fd_sc_hd__decap_3
XFILLER_0_122_801 VGND VGND VPWR VPWR sky130_fd_sc_hd__fill_2
X_10565_ _03695_ _04771_ _04773_ VGND VGND VPWR VPWR _04774_ sky130_fd_sc_hd__a21o_1
X_12304_ _05720_ _05910_ VGND VGND VPWR VPWR _05920_ sky130_fd_sc_hd__nand2_1
X_10496_ _03900_ _04706_ _03839_ VGND VGND VPWR VPWR _04707_ sky130_fd_sc_hd__a21o_1
X_13284_ _06699_ _06767_ _06667_ VGND VGND VPWR VPWR _06768_ sky130_fd_sc_hd__a21o_1
XFILLER_0_51_478 VGND VGND VPWR VPWR sky130_fd_sc_hd__fill_2
X_16072_ clknet_leaf_150_clk _00722_ VGND VGND VPWR VPWR count_cycle\[15\] sky130_fd_sc_hd__dfxtp_1
XFILLER_0_23_158 VGND VGND VPWR VPWR sky130_fd_sc_hd__fill_1
X_15023_ _03597_ net1080 _01887_ VGND VGND VPWR VPWR _01891_ sky130_fd_sc_hd__mux2_1
X_12235_ _05793_ _05798_ _05808_ _05822_ _05855_ VGND VGND VPWR VPWR _05856_ sky130_fd_sc_hd__a2111o_1
X_12166_ _05791_ VGND VGND VPWR VPWR _05792_ sky130_fd_sc_hd__clkbuf_4
X_11117_ net955 _03564_ _05135_ VGND VGND VPWR VPWR _05144_ sky130_fd_sc_hd__mux2_1
X_16974_ clknet_leaf_70_clk _01538_ VGND VGND VPWR VPWR cpuregs\[10\]\[29\] sky130_fd_sc_hd__dfxtp_1
X_12097_ _05737_ reg_pc\[20\] VGND VGND VPWR VPWR _05738_ sky130_fd_sc_hd__or2_1
X_15925_ clknet_leaf_45_clk _00575_ VGND VGND VPWR VPWR cpuregs\[17\]\[27\] sky130_fd_sc_hd__dfxtp_1
X_11048_ _05107_ VGND VGND VPWR VPWR _00245_ sky130_fd_sc_hd__clkbuf_1
Xinput8 mem_rdata[16] VGND VGND VPWR VPWR net8 sky130_fd_sc_hd__clkbuf_4
X_15856_ clknet_leaf_46_clk _00506_ VGND VGND VPWR VPWR cpuregs\[25\]\[22\] sky130_fd_sc_hd__dfxtp_1
XFILLER_0_78_309 VGND VGND VPWR VPWR sky130_fd_sc_hd__decap_6
XFILLER_0_99_681 VGND VGND VPWR VPWR sky130_fd_sc_hd__decap_4
X_14807_ net1299 _05198_ _01767_ VGND VGND VPWR VPWR _01776_ sky130_fd_sc_hd__mux2_1
XFILLER_0_59_501 VGND VGND VPWR VPWR sky130_fd_sc_hd__decap_3
X_15787_ clknet_leaf_95_clk _00437_ VGND VGND VPWR VPWR cpuregs\[26\]\[17\] sky130_fd_sc_hd__dfxtp_1
X_12999_ _06447_ _06489_ _06491_ _06453_ VGND VGND VPWR VPWR _06492_ sky130_fd_sc_hd__a211o_1
XFILLER_0_86_353 VGND VGND VPWR VPWR sky130_fd_sc_hd__decap_3
X_14738_ _01739_ VGND VGND VPWR VPWR _01238_ sky130_fd_sc_hd__clkbuf_1
XFILLER_0_117_617 VGND VGND VPWR VPWR sky130_fd_sc_hd__decap_3
X_14669_ net1260 _05196_ _01695_ VGND VGND VPWR VPWR _01703_ sky130_fd_sc_hd__mux2_1
X_08190_ net188 VGND VGND VPWR VPWR _02578_ sky130_fd_sc_hd__clkbuf_4
X_16408_ clknet_leaf_18_clk _00990_ VGND VGND VPWR VPWR net170 sky130_fd_sc_hd__dfxtp_2
X_16339_ clknet_leaf_124_clk _00921_ VGND VGND VPWR VPWR cpuregs\[1\]\[4\] sky130_fd_sc_hd__dfxtp_1
XFILLER_0_112_355 VGND VGND VPWR VPWR sky130_fd_sc_hd__fill_1
XFILLER_0_10_320 VGND VGND VPWR VPWR sky130_fd_sc_hd__fill_1
X_07974_ _02359_ _02362_ _02361_ VGND VGND VPWR VPWR _02376_ sky130_fd_sc_hd__o21ai_1
X_09713_ _03747_ _03944_ _03657_ VGND VGND VPWR VPWR _03945_ sky130_fd_sc_hd__o21a_1
X_09644_ cpuregs\[4\]\[3\] cpuregs\[5\]\[3\] cpuregs\[6\]\[3\] cpuregs\[7\]\[3\] _03876_
+ _03727_ VGND VGND VPWR VPWR _03877_ sky130_fd_sc_hd__mux4_1
XFILLER_0_96_139 VGND VGND VPWR VPWR sky130_fd_sc_hd__fill_1
XTAP_1029 VGND VPWR sky130_fd_sc_hd__tapvpwrvgnd_1
XTAP_1018 VGND VPWR sky130_fd_sc_hd__tapvpwrvgnd_1
XTAP_1007 VGND VPWR sky130_fd_sc_hd__tapvpwrvgnd_1
X_09575_ cpuregs\[4\]\[2\] cpuregs\[5\]\[2\] _03797_ VGND VGND VPWR VPWR _03809_ sky130_fd_sc_hd__mux2_1
XFILLER_0_77_364 VGND VGND VPWR VPWR sky130_fd_sc_hd__decap_3
X_08526_ _02901_ VGND VGND VPWR VPWR _02902_ sky130_fd_sc_hd__inv_2
XFILLER_0_9_141 VGND VGND VPWR VPWR sky130_fd_sc_hd__fill_1
XFILLER_0_9_130 VGND VGND VPWR VPWR sky130_fd_sc_hd__fill_1
XFILLER_0_37_217 VGND VGND VPWR VPWR sky130_fd_sc_hd__fill_2
X_08457_ _02837_ VGND VGND VPWR VPWR _02838_ sky130_fd_sc_hd__clkbuf_4
XFILLER_0_107_116 VGND VGND VPWR VPWR sky130_fd_sc_hd__fill_2
X_08388_ _02711_ _02712_ _02764_ _02768_ VGND VGND VPWR VPWR _02769_ sky130_fd_sc_hd__a22o_1
XFILLER_0_61_710 VGND VGND VPWR VPWR sky130_fd_sc_hd__fill_2
X_10350_ _03695_ _04562_ _04564_ VGND VGND VPWR VPWR _04565_ sky130_fd_sc_hd__a21o_1
XFILLER_0_60_253 VGND VGND VPWR VPWR sky130_fd_sc_hd__fill_1
X_10281_ _03732_ _04493_ _04497_ _03659_ VGND VGND VPWR VPWR _04498_ sky130_fd_sc_hd__o211a_1
X_09009_ _03298_ VGND VGND VPWR VPWR _01109_ sky130_fd_sc_hd__buf_1
XFILLER_0_103_377 VGND VGND VPWR VPWR sky130_fd_sc_hd__decap_4
X_12020_ _05682_ VGND VGND VPWR VPWR _00642_ sky130_fd_sc_hd__clkbuf_1
X_13971_ _07377_ _07393_ VGND VGND VPWR VPWR _07394_ sky130_fd_sc_hd__and2_1
X_15710_ clknet_leaf_126_clk _00360_ VGND VGND VPWR VPWR cpuregs\[21\]\[4\] sky130_fd_sc_hd__dfxtp_1
X_16690_ clknet_leaf_124_clk _01257_ VGND VGND VPWR VPWR cpuregs\[3\]\[4\] sky130_fd_sc_hd__dfxtp_1
X_12922_ _06415_ VGND VGND VPWR VPWR _06416_ sky130_fd_sc_hd__clkbuf_4
X_15641_ clknet_leaf_98_clk _00291_ VGND VGND VPWR VPWR cpuregs\[31\]\[31\] sky130_fd_sc_hd__dfxtp_1
XTAP_2253 VGND VPWR sky130_fd_sc_hd__tapvpwrvgnd_1
XTAP_2242 VGND VPWR sky130_fd_sc_hd__tapvpwrvgnd_1
XTAP_2220 VGND VPWR sky130_fd_sc_hd__tapvpwrvgnd_1
XTAP_2231 VGND VPWR sky130_fd_sc_hd__tapvpwrvgnd_1
XFILLER_0_68_320 VGND VGND VPWR VPWR sky130_fd_sc_hd__decap_6
X_12853_ cpuregs\[18\]\[0\] cpuregs\[19\]\[0\] _03336_ VGND VGND VPWR VPWR _06352_
+ sky130_fd_sc_hd__mux2_1
XTAP_2286 VGND VPWR sky130_fd_sc_hd__tapvpwrvgnd_1
XTAP_2275 VGND VPWR sky130_fd_sc_hd__tapvpwrvgnd_1
XTAP_2264 VGND VPWR sky130_fd_sc_hd__tapvpwrvgnd_1
X_15572_ clknet_leaf_81_clk _00222_ VGND VGND VPWR VPWR cpuregs\[2\]\[26\] sky130_fd_sc_hd__dfxtp_1
XFILLER_0_95_150 VGND VGND VPWR VPWR sky130_fd_sc_hd__decap_4
XTAP_1541 VGND VPWR sky130_fd_sc_hd__tapvpwrvgnd_1
XTAP_1530 VGND VPWR sky130_fd_sc_hd__tapvpwrvgnd_1
X_12784_ _06306_ VGND VGND VPWR VPWR _00782_ sky130_fd_sc_hd__clkbuf_1
X_11804_ net521 _05521_ _05526_ VGND VGND VPWR VPWR _05527_ sky130_fd_sc_hd__o21ai_1
XFILLER_0_29_729 VGND VGND VPWR VPWR sky130_fd_sc_hd__fill_2
XTAP_2297 VGND VPWR sky130_fd_sc_hd__tapvpwrvgnd_1
XTAP_1585 VGND VPWR sky130_fd_sc_hd__tapvpwrvgnd_1
XTAP_1574 VGND VPWR sky130_fd_sc_hd__tapvpwrvgnd_1
XTAP_1563 VGND VPWR sky130_fd_sc_hd__tapvpwrvgnd_1
XTAP_1552 VGND VPWR sky130_fd_sc_hd__tapvpwrvgnd_1
X_14523_ net914 _05186_ _01623_ VGND VGND VPWR VPWR _01626_ sky130_fd_sc_hd__mux2_1
XPHY_92 VGND VGND VPWR VPWR sky130_fd_sc_hd__decap_3
X_11735_ _04993_ net1435 _05483_ VGND VGND VPWR VPWR _05488_ sky130_fd_sc_hd__mux2_1
XFILLER_0_22_25 VGND VGND VPWR VPWR sky130_fd_sc_hd__decap_3
XPHY_70 VGND VGND VPWR VPWR sky130_fd_sc_hd__decap_3
XPHY_81 VGND VGND VPWR VPWR sky130_fd_sc_hd__decap_3
XFILLER_0_139_797 VPWR VGND VPWR VGND sky130_ef_sc_hd__decap_12
XTAP_1596 VGND VPWR sky130_fd_sc_hd__tapvpwrvgnd_1
X_14454_ _01589_ VGND VGND VPWR VPWR _01072_ sky130_fd_sc_hd__clkbuf_1
X_13405_ cpuregs\[22\]\[18\] cpuregs\[23\]\[18\] _06786_ VGND VGND VPWR VPWR _06886_
+ sky130_fd_sc_hd__mux2_1
XFILLER_0_64_581 VGND VGND VPWR VPWR sky130_fd_sc_hd__fill_1
X_11666_ _05451_ VGND VGND VPWR VPWR _00519_ sky130_fd_sc_hd__clkbuf_1
X_10617_ _03817_ _04818_ _04824_ VGND VGND VPWR VPWR _04825_ sky130_fd_sc_hd__or3_2
X_14385_ _05008_ net1148 _01551_ VGND VGND VPWR VPWR _01553_ sky130_fd_sc_hd__mux2_1
X_11597_ _04991_ net1203 _05411_ VGND VGND VPWR VPWR _05415_ sky130_fd_sc_hd__mux2_1
X_10548_ cpuregs\[8\]\[27\] cpuregs\[9\]\[27\] cpuregs\[10\]\[27\] cpuregs\[11\]\[27\]
+ _03798_ _03811_ VGND VGND VPWR VPWR _04757_ sky130_fd_sc_hd__mux4_1
XFILLER_0_106_160 VPWR VGND VPWR VGND sky130_ef_sc_hd__decap_12
X_13336_ cpuregs\[16\]\[16\] cpuregs\[17\]\[16\] cpuregs\[18\]\[16\] cpuregs\[19\]\[16\]
+ _06614_ _06648_ VGND VGND VPWR VPWR _06819_ sky130_fd_sc_hd__mux4_1
X_16124_ clknet_leaf_13_clk _07640_ VGND VGND VPWR VPWR reg_out\[2\] sky130_fd_sc_hd__dfxtp_1
XFILLER_0_51_253 VGND VGND VPWR VPWR sky130_fd_sc_hd__fill_2
X_16055_ clknet_leaf_37_clk _00705_ VGND VGND VPWR VPWR reg_next_pc\[30\] sky130_fd_sc_hd__dfxtp_1
X_13267_ cpuregs\[24\]\[14\] cpuregs\[25\]\[14\] cpuregs\[26\]\[14\] cpuregs\[27\]\[14\]
+ _06525_ _06558_ VGND VGND VPWR VPWR _06752_ sky130_fd_sc_hd__mux4_1
XFILLER_0_11_128 VGND VGND VPWR VPWR sky130_fd_sc_hd__fill_1
XFILLER_0_121_185 VGND VGND VPWR VPWR sky130_fd_sc_hd__decap_3
X_10479_ _02522_ _02567_ _02632_ _02593_ _03847_ _03916_ VGND VGND VPWR VPWR _04690_
+ sky130_fd_sc_hd__mux4_1
X_15006_ _03544_ net779 _01876_ VGND VGND VPWR VPWR _01882_ sky130_fd_sc_hd__mux2_1
X_12218_ _05839_ VGND VGND VPWR VPWR _05840_ sky130_fd_sc_hd__inv_2
XFILLER_0_138_13 VGND VGND VPWR VPWR sky130_fd_sc_hd__fill_2
X_13198_ _06447_ _06681_ _06684_ _06453_ VGND VGND VPWR VPWR _06685_ sky130_fd_sc_hd__a211o_1
X_12149_ _05741_ net436 _05725_ _05776_ VGND VGND VPWR VPWR _00677_ sky130_fd_sc_hd__o211a_1
XFILLER_0_138_79 VGND VGND VPWR VPWR sky130_fd_sc_hd__decap_4
X_16957_ clknet_leaf_107_clk _01521_ VGND VGND VPWR VPWR cpuregs\[10\]\[12\] sky130_fd_sc_hd__dfxtp_1
XFILLER_0_47_88 VGND VGND VPWR VPWR sky130_fd_sc_hd__decap_6
XFILLER_0_37_9 VGND VGND VPWR VPWR sky130_fd_sc_hd__fill_2
X_15908_ clknet_leaf_137_clk _00558_ VGND VGND VPWR VPWR cpuregs\[17\]\[10\] sky130_fd_sc_hd__dfxtp_1
X_16888_ clknet_leaf_112_clk _01452_ VGND VGND VPWR VPWR cpuregs\[8\]\[7\] sky130_fd_sc_hd__dfxtp_1
X_07690_ instr_sb instr_sh instr_sw _02095_ VGND VGND VPWR VPWR _02117_ sky130_fd_sc_hd__or4_1
XFILLER_0_63_43 VGND VGND VPWR VPWR sky130_fd_sc_hd__fill_1
X_15839_ clknet_leaf_129_clk _00489_ VGND VGND VPWR VPWR cpuregs\[25\]\[5\] sky130_fd_sc_hd__dfxtp_1
X_09360_ net1179 _03603_ _03578_ VGND VGND VPWR VPWR _03604_ sky130_fd_sc_hd__mux2_1
X_08311_ _02690_ _02691_ VGND VGND VPWR VPWR _02692_ sky130_fd_sc_hd__nand2_1
X_09291_ _03543_ VGND VGND VPWR VPWR _03544_ sky130_fd_sc_hd__clkbuf_4
XFILLER_0_19_217 VGND VGND VPWR VPWR sky130_fd_sc_hd__decap_3
XFILLER_0_86_194 VGND VGND VPWR VPWR sky130_fd_sc_hd__fill_2
XANTENNA_13 _03689_ VGND VGND VPWR VPWR sky130_fd_sc_hd__diode_2
X_08242_ count_cycle\[29\] _02202_ _02624_ _02625_ VGND VGND VPWR VPWR _02626_ sky130_fd_sc_hd__a211o_2
XANTENNA_57 net72 VGND VGND VPWR VPWR sky130_fd_sc_hd__diode_2
XANTENNA_46 net32 VGND VGND VPWR VPWR sky130_fd_sc_hd__diode_2
XANTENNA_24 _04024_ VGND VGND VPWR VPWR sky130_fd_sc_hd__diode_2
XFILLER_0_55_570 VGND VGND VPWR VPWR sky130_fd_sc_hd__fill_1
XANTENNA_35 net3 VGND VGND VPWR VPWR sky130_fd_sc_hd__diode_2
XFILLER_0_15_401 VGND VGND VPWR VPWR sky130_fd_sc_hd__fill_1
XFILLER_0_132_417 VGND VGND VPWR VPWR sky130_fd_sc_hd__decap_3
X_08173_ reg_pc\[24\] decoded_imm\[24\] VGND VGND VPWR VPWR _02562_ sky130_fd_sc_hd__nand2_2
XANTENNA_79 net106 VGND VGND VPWR VPWR sky130_fd_sc_hd__diode_2
XANTENNA_68 net86 VGND VGND VPWR VPWR sky130_fd_sc_hd__diode_2
XFILLER_0_42_253 VGND VGND VPWR VPWR sky130_fd_sc_hd__decap_3
XFILLER_0_113_642 VGND VGND VPWR VPWR sky130_fd_sc_hd__decap_3
XFILLER_0_112_141 VPWR VGND VPWR VGND sky130_ef_sc_hd__decap_12
XFILLER_0_70_3 VGND VGND VPWR VPWR sky130_fd_sc_hd__decap_4
XFILLER_0_42_275 VGND VGND VPWR VPWR sky130_fd_sc_hd__fill_1
XFILLER_0_112_163 VGND VGND VPWR VPWR sky130_fd_sc_hd__fill_1
Xoutput131 net131 VGND VGND VPWR VPWR mem_la_wstrb[1] sky130_fd_sc_hd__clkbuf_4
Xoutput142 net142 VGND VGND VPWR VPWR mem_wdata[16] sky130_fd_sc_hd__clkbuf_4
Xoutput120 net120 VGND VGND VPWR VPWR mem_la_wdata[30] sky130_fd_sc_hd__buf_2
Xoutput186 net186 VGND VGND VPWR VPWR pcpi_rs1[23] sky130_fd_sc_hd__clkbuf_4
Xoutput175 net175 VGND VGND VPWR VPWR pcpi_rs1[13] sky130_fd_sc_hd__clkbuf_4
Xoutput164 net164 VGND VGND VPWR VPWR mem_wdata[7] sky130_fd_sc_hd__clkbuf_4
Xoutput153 net153 VGND VGND VPWR VPWR mem_wdata[26] sky130_fd_sc_hd__buf_2
Xoutput197 net197 VGND VGND VPWR VPWR pcpi_rs1[4] sky130_fd_sc_hd__clkbuf_4
XFILLER_0_10_172 VGND VGND VPWR VPWR sky130_fd_sc_hd__fill_1
X_07957_ reg_pc\[10\] decoded_imm\[10\] VGND VGND VPWR VPWR _02360_ sky130_fd_sc_hd__or2_1
X_07888_ net14 _02216_ _02295_ _02212_ VGND VGND VPWR VPWR _02296_ sky130_fd_sc_hd__a22o_1
X_09627_ _03856_ _03857_ _03859_ VGND VGND VPWR VPWR _03860_ sky130_fd_sc_hd__or3_1
X_09558_ _03788_ _03791_ VGND VGND VPWR VPWR _03792_ sky130_fd_sc_hd__xnor2_1
XFILLER_0_77_183 VPWR VGND VPWR VGND sky130_ef_sc_hd__decap_12
X_08509_ net251 _02885_ VGND VGND VPWR VPWR _02886_ sky130_fd_sc_hd__xor2_1
X_09489_ _03723_ VGND VGND VPWR VPWR _03724_ sky130_fd_sc_hd__clkbuf_8
X_11520_ _04902_ _04901_ _04900_ VGND VGND VPWR VPWR _05373_ sky130_fd_sc_hd__or3b_2
XFILLER_0_136_767 VGND VGND VPWR VPWR sky130_fd_sc_hd__fill_1
XFILLER_0_80_326 VGND VGND VPWR VPWR sky130_fd_sc_hd__decap_6
XFILLER_0_135_277 VGND VGND VPWR VPWR sky130_fd_sc_hd__decap_3
XFILLER_0_92_197 VGND VGND VPWR VPWR sky130_fd_sc_hd__fill_2
X_11451_ _05336_ VGND VGND VPWR VPWR _00419_ sky130_fd_sc_hd__clkbuf_1
X_10402_ _04578_ _04583_ _04613_ VGND VGND VPWR VPWR _04615_ sky130_fd_sc_hd__a21o_1
X_11382_ _05049_ net1222 _05265_ VGND VGND VPWR VPWR _05300_ sky130_fd_sc_hd__mux2_1
X_14170_ _07505_ VGND VGND VPWR VPWR _00948_ sky130_fd_sc_hd__clkbuf_1
XFILLER_0_33_253 VGND VGND VPWR VPWR sky130_fd_sc_hd__decap_3
X_10333_ cpuregs\[8\]\[21\] cpuregs\[9\]\[21\] cpuregs\[10\]\[21\] cpuregs\[11\]\[21\]
+ _03798_ _03811_ VGND VGND VPWR VPWR _04548_ sky130_fd_sc_hd__mux4_1
X_13121_ cpuregs\[0\]\[10\] cpuregs\[1\]\[10\] cpuregs\[2\]\[10\] cpuregs\[3\]\[10\]
+ _06364_ _03400_ VGND VGND VPWR VPWR _06610_ sky130_fd_sc_hd__mux4_1
X_10264_ cpuregs\[14\]\[19\] cpuregs\[15\]\[19\] _04194_ VGND VGND VPWR VPWR _04481_
+ sky130_fd_sc_hd__mux2_1
X_13052_ _06535_ _06536_ _06541_ _06542_ VGND VGND VPWR VPWR _06543_ sky130_fd_sc_hd__o211a_1
X_10195_ _04020_ _04409_ _04413_ _00015_ VGND VGND VPWR VPWR _04414_ sky130_fd_sc_hd__o211a_1
X_12003_ count_instr\[56\] count_instr\[55\] count_instr\[54\] _05664_ VGND VGND VPWR
+ VPWR _05671_ sky130_fd_sc_hd__and4_2
X_16811_ clknet_leaf_71_clk _01375_ VGND VGND VPWR VPWR cpuregs\[6\]\[26\] sky130_fd_sc_hd__dfxtp_1
X_16742_ clknet_leaf_76_clk _01306_ VGND VGND VPWR VPWR cpuregs\[4\]\[21\] sky130_fd_sc_hd__dfxtp_1
X_13954_ _07325_ VGND VGND VPWR VPWR _07382_ sky130_fd_sc_hd__clkbuf_4
XFILLER_0_88_448 VGND VGND VPWR VPWR sky130_fd_sc_hd__fill_1
X_16673_ clknet_leaf_93_clk _01240_ VGND VGND VPWR VPWR cpuregs\[29\]\[19\] sky130_fd_sc_hd__dfxtp_1
X_12905_ _03328_ _06398_ _06402_ _03308_ VGND VGND VPWR VPWR _06403_ sky130_fd_sc_hd__o211a_1
X_13885_ instr_bne _07325_ _07335_ _02149_ VGND VGND VPWR VPWR _07336_ sky130_fd_sc_hd__a22o_1
XFILLER_0_124_26 VGND VGND VPWR VPWR sky130_fd_sc_hd__fill_2
XTAP_2061 VGND VPWR sky130_fd_sc_hd__tapvpwrvgnd_1
XTAP_2050 VGND VPWR sky130_fd_sc_hd__tapvpwrvgnd_1
X_15624_ clknet_leaf_136_clk _00274_ VGND VGND VPWR VPWR cpuregs\[31\]\[14\] sky130_fd_sc_hd__dfxtp_1
X_12836_ cpu_state\[1\] cpu_state\[2\] cpu_state\[0\] VGND VGND VPWR VPWR _06338_
+ sky130_fd_sc_hd__nor3_1
XTAP_2094 VGND VPWR sky130_fd_sc_hd__tapvpwrvgnd_1
XTAP_2083 VGND VPWR sky130_fd_sc_hd__tapvpwrvgnd_1
XTAP_2072 VGND VPWR sky130_fd_sc_hd__tapvpwrvgnd_1
X_15555_ clknet_leaf_110_clk _00205_ VGND VGND VPWR VPWR cpuregs\[2\]\[9\] sky130_fd_sc_hd__dfxtp_1
XFILLER_0_127_723 VGND VGND VPWR VPWR sky130_fd_sc_hd__decap_4
X_12767_ _06297_ VGND VGND VPWR VPWR _00774_ sky130_fd_sc_hd__clkbuf_1
XTAP_1393 VGND VPWR sky130_fd_sc_hd__tapvpwrvgnd_1
XTAP_1382 VGND VPWR sky130_fd_sc_hd__tapvpwrvgnd_1
XTAP_1371 VGND VPWR sky130_fd_sc_hd__tapvpwrvgnd_1
XTAP_1360 VGND VPWR sky130_fd_sc_hd__tapvpwrvgnd_1
X_14506_ net1283 _05169_ _01612_ VGND VGND VPWR VPWR _01617_ sky130_fd_sc_hd__mux2_1
X_11718_ _05478_ VGND VGND VPWR VPWR _00544_ sky130_fd_sc_hd__clkbuf_1
XFILLER_0_126_233 VGND VGND VPWR VPWR sky130_fd_sc_hd__fill_1
XFILLER_0_84_698 VGND VGND VPWR VPWR sky130_fd_sc_hd__fill_2
X_12698_ _02141_ _06237_ _06238_ VGND VGND VPWR VPWR _06239_ sky130_fd_sc_hd__and3_1
X_15486_ clknet_leaf_123_clk _00136_ VGND VGND VPWR VPWR cpuregs\[30\]\[4\] sky130_fd_sc_hd__dfxtp_1
XFILLER_0_16_209 VGND VGND VPWR VPWR sky130_fd_sc_hd__decap_6
Xinput11 mem_rdata[19] VGND VGND VPWR VPWR net11 sky130_fd_sc_hd__clkbuf_4
Xinput22 mem_rdata[29] VGND VGND VPWR VPWR net22 sky130_fd_sc_hd__buf_4
X_11649_ _05043_ net1344 _05433_ VGND VGND VPWR VPWR _05442_ sky130_fd_sc_hd__mux2_1
XFILLER_0_71_337 VGND VGND VPWR VPWR sky130_fd_sc_hd__fill_2
X_14437_ _01580_ VGND VGND VPWR VPWR _01064_ sky130_fd_sc_hd__clkbuf_1
XFILLER_0_140_69 VGND VGND VPWR VPWR sky130_fd_sc_hd__decap_8
Xinput33 mem_ready VGND VGND VPWR VPWR net33 sky130_fd_sc_hd__buf_1
X_14368_ _04991_ net979 _07616_ VGND VGND VPWR VPWR _01544_ sky130_fd_sc_hd__mux2_1
XFILLER_0_24_253 VGND VGND VPWR VPWR sky130_fd_sc_hd__decap_4
Xhold806 cpuregs\[4\]\[21\] VGND VGND VPWR VPWR net1164 sky130_fd_sc_hd__dlygate4sd3_1
X_13319_ _06762_ _06779_ _06801_ _06802_ decoded_imm\[15\] VGND VGND VPWR VPWR _06803_
+ sky130_fd_sc_hd__a32o_1
Xhold817 cpuregs\[2\]\[19\] VGND VGND VPWR VPWR net1175 sky130_fd_sc_hd__dlygate4sd3_1
Xhold828 cpuregs\[20\]\[11\] VGND VGND VPWR VPWR net1186 sky130_fd_sc_hd__dlygate4sd3_1
X_16107_ clknet_leaf_152_clk _00757_ VGND VGND VPWR VPWR count_cycle\[50\] sky130_fd_sc_hd__dfxtp_1
XFILLER_0_3_169 VGND VGND VPWR VPWR sky130_fd_sc_hd__fill_2
XFILLER_0_12_437 VGND VGND VPWR VPWR sky130_fd_sc_hd__fill_1
XFILLER_0_25_798 VGND VGND VPWR VPWR sky130_fd_sc_hd__decap_4
X_14299_ mem_rdata_q\[26\] _07576_ VGND VGND VPWR VPWR _07580_ sky130_fd_sc_hd__and2_1
Xhold839 cpuregs\[23\]\[11\] VGND VGND VPWR VPWR net1197 sky130_fd_sc_hd__dlygate4sd3_1
X_17087_ net122 VGND VGND VPWR VPWR net228 sky130_fd_sc_hd__buf_1
XFILLER_0_122_494 VGND VGND VPWR VPWR sky130_fd_sc_hd__fill_1
X_16038_ clknet_leaf_30_clk _00688_ VGND VGND VPWR VPWR reg_next_pc\[13\] sky130_fd_sc_hd__dfxtp_1
XFILLER_0_58_32 VGND VGND VPWR VPWR sky130_fd_sc_hd__decap_4
XFILLER_0_110_678 VGND VGND VPWR VPWR sky130_fd_sc_hd__fill_1
X_08860_ _02671_ _03204_ _03205_ VGND VGND VPWR VPWR net127 sky130_fd_sc_hd__a21o_2
X_07811_ _02197_ decoded_imm\[0\] _02200_ _02206_ _02223_ VGND VGND VPWR VPWR _07618_
+ sky130_fd_sc_hd__a221o_1
X_08791_ _02593_ _03145_ VGND VGND VPWR VPWR _03146_ sky130_fd_sc_hd__and2_1
X_07742_ _02148_ _02151_ _00841_ _02162_ VGND VGND VPWR VPWR _02163_ sky130_fd_sc_hd__a211o_1
X_07673_ cpu_state\[1\] _02082_ _02102_ VGND VGND VPWR VPWR _02103_ sky130_fd_sc_hd__o21ai_1
XFILLER_0_66_109 VGND VGND VPWR VPWR sky130_fd_sc_hd__decap_4
X_09412_ instr_sra instr_srai VGND VGND VPWR VPWR _03648_ sky130_fd_sc_hd__or2_4
X_09343_ _03433_ _03588_ VGND VGND VPWR VPWR _03589_ sky130_fd_sc_hd__nor2_1
XFILLER_0_94_429 VGND VGND VPWR VPWR sky130_fd_sc_hd__fill_2
XFILLER_0_59_172 VGND VGND VPWR VPWR sky130_fd_sc_hd__decap_4
XFILLER_0_114_70 VGND VGND VPWR VPWR sky130_fd_sc_hd__fill_1
X_09274_ reg_pc\[13\] reg_pc\[12\] _03515_ VGND VGND VPWR VPWR _03529_ sky130_fd_sc_hd__and3_1
XFILLER_0_28_570 VGND VGND VPWR VPWR sky130_fd_sc_hd__fill_2
XFILLER_0_133_704 VGND VGND VPWR VPWR sky130_fd_sc_hd__decap_3
XFILLER_0_132_203 VGND VGND VPWR VPWR sky130_fd_sc_hd__decap_4
XFILLER_0_105_417 VGND VGND VPWR VPWR sky130_fd_sc_hd__decap_4
X_08225_ count_cycle\[28\] _02454_ _02608_ _02609_ VGND VGND VPWR VPWR _02610_ sky130_fd_sc_hd__a211o_2
XFILLER_0_117_288 VGND VGND VPWR VPWR sky130_fd_sc_hd__fill_1
X_08156_ _02544_ _02545_ VGND VGND VPWR VPWR _02546_ sky130_fd_sc_hd__nor2_1
XFILLER_0_15_242 VGND VGND VPWR VPWR sky130_fd_sc_hd__decap_4
XFILLER_0_30_212 VGND VGND VPWR VPWR sky130_fd_sc_hd__decap_3
XFILLER_0_113_483 VGND VGND VPWR VPWR sky130_fd_sc_hd__fill_2
XFILLER_0_101_623 VGND VGND VPWR VPWR sky130_fd_sc_hd__fill_1
X_08087_ _02148_ _02478_ _02481_ _02200_ VGND VGND VPWR VPWR _02482_ sky130_fd_sc_hd__a211o_1
XFILLER_0_100_166 VGND VGND VPWR VPWR sky130_fd_sc_hd__decap_3
XFILLER_0_11_492 VGND VGND VPWR VPWR sky130_fd_sc_hd__fill_1
X_08989_ _03284_ VGND VGND VPWR VPWR net84 sky130_fd_sc_hd__clkbuf_1
X_10951_ _05056_ VGND VGND VPWR VPWR _00199_ sky130_fd_sc_hd__clkbuf_1
X_13670_ _07142_ net221 _06960_ VGND VGND VPWR VPWR _07143_ sky130_fd_sc_hd__mux2_1
XFILLER_0_85_418 VGND VGND VPWR VPWR sky130_fd_sc_hd__fill_1
X_10882_ _05010_ net878 _05006_ VGND VGND VPWR VPWR _05011_ sky130_fd_sc_hd__mux2_1
X_12621_ count_cycle\[35\] count_cycle\[36\] _06178_ VGND VGND VPWR VPWR _06183_ sky130_fd_sc_hd__and3_1
XFILLER_0_66_654 VGND VGND VPWR VPWR sky130_fd_sc_hd__fill_1
X_15340_ _03538_ net813 _02052_ VGND VGND VPWR VPWR _02057_ sky130_fd_sc_hd__mux2_1
X_12552_ _06134_ VGND VGND VPWR VPWR _00722_ sky130_fd_sc_hd__clkbuf_1
X_11503_ _05364_ VGND VGND VPWR VPWR _00443_ sky130_fd_sc_hd__clkbuf_1
X_12483_ _05763_ net437 _05526_ _06083_ VGND VGND VPWR VPWR _00704_ sky130_fd_sc_hd__o211a_1
XFILLER_0_108_266 VGND VGND VPWR VPWR sky130_fd_sc_hd__decap_8
XFILLER_0_53_337 VGND VGND VPWR VPWR sky130_fd_sc_hd__fill_1
X_15271_ net467 VGND VGND VPWR VPWR _02021_ sky130_fd_sc_hd__clkbuf_1
X_11434_ net887 _05209_ _05324_ VGND VGND VPWR VPWR _05328_ sky130_fd_sc_hd__mux2_1
XFILLER_0_81_668 VGND VGND VPWR VPWR sky130_fd_sc_hd__fill_1
X_14222_ net494 net103 _07530_ VGND VGND VPWR VPWR _07536_ sky130_fd_sc_hd__mux2_1
X_14153_ _05033_ net1302 _07493_ VGND VGND VPWR VPWR _07497_ sky130_fd_sc_hd__mux2_1
X_11365_ _05291_ VGND VGND VPWR VPWR _00378_ sky130_fd_sc_hd__clkbuf_1
XFILLER_0_104_483 VGND VGND VPWR VPWR sky130_fd_sc_hd__fill_1
Xclkbuf_leaf_100_clk clknet_4_9_0_clk VGND VGND VPWR VPWR clknet_leaf_100_clk sky130_fd_sc_hd__clkbuf_16
XFILLER_0_21_223 VGND VGND VPWR VPWR sky130_fd_sc_hd__fill_1
X_11296_ _05254_ VGND VGND VPWR VPWR _00346_ sky130_fd_sc_hd__clkbuf_1
X_10316_ cpuregs\[28\]\[20\] cpuregs\[29\]\[20\] cpuregs\[30\]\[20\] cpuregs\[31\]\[20\]
+ _03941_ _03942_ VGND VGND VPWR VPWR _04532_ sky130_fd_sc_hd__mux4_1
XFILLER_0_95_19 VGND VGND VPWR VPWR sky130_fd_sc_hd__fill_1
XFILLER_0_0_139 VGND VGND VPWR VPWR sky130_fd_sc_hd__fill_1
XFILLER_0_21_256 VGND VGND VPWR VPWR sky130_fd_sc_hd__decap_4
X_14084_ _07458_ VGND VGND VPWR VPWR _00909_ sky130_fd_sc_hd__clkbuf_1
X_13104_ _06461_ _06593_ VGND VGND VPWR VPWR _06594_ sky130_fd_sc_hd__and2_1
X_10247_ cpuregs\[24\]\[18\] cpuregs\[25\]\[18\] cpuregs\[26\]\[18\] cpuregs\[27\]\[18\]
+ _04192_ _04200_ VGND VGND VPWR VPWR _04465_ sky130_fd_sc_hd__mux4_1
XTAP_429 VGND VPWR sky130_fd_sc_hd__tapvpwrvgnd_1
XTAP_418 VGND VPWR sky130_fd_sc_hd__tapvpwrvgnd_1
XTAP_407 VGND VPWR sky130_fd_sc_hd__tapvpwrvgnd_1
X_13035_ cpuregs\[28\]\[7\] cpuregs\[29\]\[7\] _06349_ VGND VGND VPWR VPWR _06527_
+ sky130_fd_sc_hd__mux2_1
X_10178_ _03690_ _04397_ _03959_ VGND VGND VPWR VPWR _04398_ sky130_fd_sc_hd__o21a_1
XFILLER_0_89_702 VGND VGND VPWR VPWR sky130_fd_sc_hd__fill_2
X_14986_ _01871_ VGND VGND VPWR VPWR _01354_ sky130_fd_sc_hd__clkbuf_1
X_16725_ clknet_leaf_123_clk _01289_ VGND VGND VPWR VPWR cpuregs\[4\]\[4\] sky130_fd_sc_hd__dfxtp_1
X_13937_ _07327_ mem_rdata_q\[13\] mem_rdata_q\[12\] VGND VGND VPWR VPWR _07370_ sky130_fd_sc_hd__and3b_1
XFILLER_0_135_69 VPWR VGND VPWR VGND sky130_ef_sc_hd__decap_12
X_16656_ clknet_leaf_132_clk _01223_ VGND VGND VPWR VPWR cpuregs\[29\]\[2\] sky130_fd_sc_hd__dfxtp_1
X_13868_ _01097_ _01099_ _01098_ VGND VGND VPWR VPWR _07321_ sky130_fd_sc_hd__and3b_1
X_12819_ _06324_ VGND VGND VPWR VPWR _00799_ sky130_fd_sc_hd__clkbuf_1
X_15607_ clknet_leaf_69_clk _00257_ VGND VGND VPWR VPWR cpuregs\[28\]\[29\] sky130_fd_sc_hd__dfxtp_1
X_13799_ _06970_ _07266_ VGND VGND VPWR VPWR _07267_ sky130_fd_sc_hd__and2_1
XFILLER_0_9_718 VGND VGND VPWR VPWR sky130_fd_sc_hd__fill_1
XFILLER_0_8_217 VGND VGND VPWR VPWR sky130_fd_sc_hd__fill_2
X_16587_ clknet_leaf_5_clk _00021_ VGND VGND VPWR VPWR cpu_state\[4\] sky130_fd_sc_hd__dfxtp_4
X_15538_ clknet_leaf_70_clk _00188_ VGND VGND VPWR VPWR cpuregs\[13\]\[24\] sky130_fd_sc_hd__dfxtp_1
XFILLER_0_72_613 VGND VGND VPWR VPWR sky130_fd_sc_hd__fill_2
XTAP_1190 VGND VPWR sky130_fd_sc_hd__tapvpwrvgnd_1
XFILLER_0_60_44 VGND VGND VPWR VPWR sky130_fd_sc_hd__decap_8
X_15469_ clknet_leaf_89_clk _00119_ VGND VGND VPWR VPWR cpuregs\[12\]\[19\] sky130_fd_sc_hd__dfxtp_1
X_08010_ _02384_ _02387_ _02400_ _02408_ _02399_ VGND VGND VPWR VPWR _02409_ sky130_fd_sc_hd__o311ai_4
XFILLER_0_60_808 VGND VGND VPWR VPWR sky130_fd_sc_hd__fill_1
Xhold603 cpuregs\[15\]\[17\] VGND VGND VPWR VPWR net961 sky130_fd_sc_hd__dlygate4sd3_1
XFILLER_0_52_370 VGND VGND VPWR VPWR sky130_fd_sc_hd__fill_1
XFILLER_0_40_521 VGND VGND VPWR VPWR sky130_fd_sc_hd__fill_1
Xhold625 cpuregs\[22\]\[16\] VGND VGND VPWR VPWR net983 sky130_fd_sc_hd__dlygate4sd3_1
Xhold614 cpuregs\[22\]\[19\] VGND VGND VPWR VPWR net972 sky130_fd_sc_hd__dlygate4sd3_1
Xhold636 cpuregs\[30\]\[8\] VGND VGND VPWR VPWR net994 sky130_fd_sc_hd__dlygate4sd3_1
Xhold647 cpuregs\[24\]\[29\] VGND VGND VPWR VPWR net1005 sky130_fd_sc_hd__dlygate4sd3_1
X_09961_ decoded_imm\[11\] net173 VGND VGND VPWR VPWR _04186_ sky130_fd_sc_hd__nor2_1
Xhold658 cpuregs\[13\]\[13\] VGND VGND VPWR VPWR net1016 sky130_fd_sc_hd__dlygate4sd3_1
Xhold669 cpuregs\[4\]\[1\] VGND VGND VPWR VPWR net1027 sky130_fd_sc_hd__dlygate4sd3_1
X_08912_ _02280_ _03231_ _03227_ VGND VGND VPWR VPWR _03232_ sky130_fd_sc_hd__mux2_1
XFILLER_0_0_673 VGND VGND VPWR VPWR sky130_fd_sc_hd__fill_2
X_09892_ _03722_ VGND VGND VPWR VPWR _04119_ sky130_fd_sc_hd__clkbuf_8
XTAP_952 VGND VPWR sky130_fd_sc_hd__tapvpwrvgnd_1
XTAP_941 VGND VPWR sky130_fd_sc_hd__tapvpwrvgnd_1
XTAP_930 VGND VPWR sky130_fd_sc_hd__tapvpwrvgnd_1
X_08843_ _03193_ _03184_ _03180_ VGND VGND VPWR VPWR _03194_ sky130_fd_sc_hd__a21oi_1
XTAP_996 VGND VPWR sky130_fd_sc_hd__tapvpwrvgnd_1
XTAP_974 VGND VPWR sky130_fd_sc_hd__tapvpwrvgnd_1
XTAP_985 VGND VPWR sky130_fd_sc_hd__tapvpwrvgnd_1
XTAP_963 VGND VPWR sky130_fd_sc_hd__tapvpwrvgnd_1
Xhold1303 count_cycle\[38\] VGND VGND VPWR VPWR net1661 sky130_fd_sc_hd__dlygate4sd3_1
X_08774_ _02567_ _03129_ VGND VGND VPWR VPWR _03131_ sky130_fd_sc_hd__or2_1
XFILLER_0_33_3 VGND VGND VPWR VPWR sky130_fd_sc_hd__decap_3
X_07725_ cpu_state\[3\] VGND VGND VPWR VPWR _02147_ sky130_fd_sc_hd__buf_4
XFILLER_0_79_245 VPWR VGND VPWR VGND sky130_ef_sc_hd__decap_12
X_07656_ mem_state\[0\] mem_state\[1\] VGND VGND VPWR VPWR _02086_ sky130_fd_sc_hd__and2_1
X_09326_ reg_pc\[20\] _03568_ _03460_ VGND VGND VPWR VPWR _03574_ sky130_fd_sc_hd__o21ai_1
XFILLER_0_48_698 VGND VGND VPWR VPWR sky130_fd_sc_hd__fill_2
XFILLER_0_36_827 VGND VGND VPWR VPWR sky130_fd_sc_hd__fill_1
X_09257_ reg_out\[11\] alu_out_q\[11\] _03435_ VGND VGND VPWR VPWR _03514_ sky130_fd_sc_hd__mux2_1
XFILLER_0_63_646 VGND VGND VPWR VPWR sky130_fd_sc_hd__decap_4
XFILLER_0_47_186 VGND VGND VPWR VPWR sky130_fd_sc_hd__fill_1
XFILLER_0_8_751 VGND VGND VPWR VPWR sky130_fd_sc_hd__decap_4
X_08208_ _02148_ _02590_ _02591_ _02594_ _02284_ VGND VGND VPWR VPWR _02595_ sky130_fd_sc_hd__a311o_1
XFILLER_0_62_167 VGND VGND VPWR VPWR sky130_fd_sc_hd__decap_6
XFILLER_0_35_359 VGND VGND VPWR VPWR sky130_fd_sc_hd__fill_2
X_09188_ reg_out\[2\] alu_out_q\[2\] latched_stalu VGND VGND VPWR VPWR _03454_ sky130_fd_sc_hd__mux2_1
X_08139_ reg_pc\[22\] decoded_imm\[22\] VGND VGND VPWR VPWR _02530_ sky130_fd_sc_hd__nand2_1
X_11150_ _05162_ VGND VGND VPWR VPWR _00292_ sky130_fd_sc_hd__clkbuf_1
XFILLER_0_101_475 VGND VGND VPWR VPWR sky130_fd_sc_hd__fill_2
X_10101_ _03862_ _04302_ _04322_ VGND VGND VPWR VPWR _04323_ sky130_fd_sc_hd__o21a_1
X_11081_ _05125_ VGND VGND VPWR VPWR _00260_ sky130_fd_sc_hd__clkbuf_1
X_10032_ _04255_ _02391_ _04150_ VGND VGND VPWR VPWR _04256_ sky130_fd_sc_hd__mux2_1
X_14840_ _01794_ VGND VGND VPWR VPWR _01285_ sky130_fd_sc_hd__clkbuf_1
X_14771_ _01757_ VGND VGND VPWR VPWR _01253_ sky130_fd_sc_hd__clkbuf_1
X_13722_ cpuregs\[24\]\[28\] cpuregs\[25\]\[28\] cpuregs\[26\]\[28\] cpuregs\[27\]\[28\]
+ _06443_ _06444_ VGND VGND VPWR VPWR _07193_ sky130_fd_sc_hd__mux4_1
X_16510_ clknet_leaf_55_clk _01092_ VGND VGND VPWR VPWR cpuregs\[19\]\[31\] sky130_fd_sc_hd__dfxtp_1
X_11983_ _05656_ VGND VGND VPWR VPWR _00631_ sky130_fd_sc_hd__clkbuf_1
Xclkbuf_leaf_149_clk clknet_4_2_0_clk VGND VGND VPWR VPWR clknet_leaf_149_clk sky130_fd_sc_hd__clkbuf_16
X_10934_ _05045_ net1440 _05027_ VGND VGND VPWR VPWR _05046_ sky130_fd_sc_hd__mux2_1
XFILLER_0_98_587 VGND VGND VPWR VPWR sky130_fd_sc_hd__fill_1
XFILLER_0_58_429 VGND VGND VPWR VPWR sky130_fd_sc_hd__decap_3
XFILLER_0_14_26 VGND VGND VPWR VPWR sky130_fd_sc_hd__fill_2
X_13653_ _06911_ _07125_ VGND VGND VPWR VPWR _07126_ sky130_fd_sc_hd__or2_1
X_16441_ clknet_leaf_7_clk _01023_ VGND VGND VPWR VPWR decoded_imm\[6\] sky130_fd_sc_hd__dfxtp_2
X_10865_ _03490_ VGND VGND VPWR VPWR _04999_ sky130_fd_sc_hd__clkbuf_4
XFILLER_0_39_654 VGND VGND VPWR VPWR sky130_fd_sc_hd__fill_1
XPHY_251 VGND VGND VPWR VPWR sky130_fd_sc_hd__decap_3
XPHY_240 VGND VGND VPWR VPWR sky130_fd_sc_hd__decap_3
X_13584_ cpuregs\[10\]\[24\] cpuregs\[11\]\[24\] _06766_ VGND VGND VPWR VPWR _07059_
+ sky130_fd_sc_hd__mux2_1
X_16372_ clknet_leaf_6_clk _00954_ VGND VGND VPWR VPWR mem_state\[1\] sky130_fd_sc_hd__dfxtp_1
X_12604_ count_cycle\[29\] count_cycle\[30\] count_cycle\[31\] _06165_ VGND VGND VPWR
+ VPWR _06171_ sky130_fd_sc_hd__and4_2
XPHY_273 VGND VGND VPWR VPWR sky130_fd_sc_hd__decap_3
XPHY_262 VGND VGND VPWR VPWR sky130_fd_sc_hd__decap_3
XFILLER_0_109_564 VGND VGND VPWR VPWR sky130_fd_sc_hd__fill_2
X_10796_ _04958_ VGND VGND VPWR VPWR _00142_ sky130_fd_sc_hd__clkbuf_1
X_12535_ count_cycle\[11\] net381 VGND VGND VPWR VPWR _06122_ sky130_fd_sc_hd__and2_1
X_15323_ _03484_ net800 _02041_ VGND VGND VPWR VPWR _02048_ sky130_fd_sc_hd__mux2_1
XFILLER_0_38_175 VGND VGND VPWR VPWR sky130_fd_sc_hd__fill_1
XFILLER_0_38_197 VPWR VGND VPWR VGND sky130_ef_sc_hd__decap_12
X_12466_ _06004_ _05755_ VGND VGND VPWR VPWR _06068_ sky130_fd_sc_hd__xor2_1
XFILLER_0_53_167 VGND VGND VPWR VPWR sky130_fd_sc_hd__fill_1
X_15254_ _02012_ VGND VGND VPWR VPWR _01481_ sky130_fd_sc_hd__clkbuf_1
X_12397_ _06004_ VGND VGND VPWR VPWR _06005_ sky130_fd_sc_hd__clkbuf_4
X_14205_ net495 net126 _07519_ VGND VGND VPWR VPWR _07527_ sky130_fd_sc_hd__mux2_1
X_11417_ net641 _05192_ _05313_ VGND VGND VPWR VPWR _05319_ sky130_fd_sc_hd__mux2_1
X_15185_ _03464_ net840 _01973_ VGND VGND VPWR VPWR _01977_ sky130_fd_sc_hd__mux2_1
X_14136_ _05016_ net1464 _07482_ VGND VGND VPWR VPWR _07488_ sky130_fd_sc_hd__mux2_1
X_11348_ _05282_ VGND VGND VPWR VPWR _00370_ sky130_fd_sc_hd__clkbuf_1
XFILLER_0_22_587 VGND VGND VPWR VPWR sky130_fd_sc_hd__fill_1
X_11279_ _05245_ VGND VGND VPWR VPWR _00338_ sky130_fd_sc_hd__clkbuf_1
X_14067_ net392 _01104_ _07420_ VGND VGND VPWR VPWR _07450_ sky130_fd_sc_hd__mux2_1
X_13018_ _00007_ VGND VGND VPWR VPWR _06510_ sky130_fd_sc_hd__clkbuf_8
X_14969_ _03641_ net1030 _01828_ VGND VGND VPWR VPWR _01862_ sky130_fd_sc_hd__mux2_1
X_16708_ clknet_leaf_78_clk _01275_ VGND VGND VPWR VPWR cpuregs\[3\]\[22\] sky130_fd_sc_hd__dfxtp_1
X_08490_ _02839_ _02846_ _02757_ VGND VGND VPWR VPWR _02869_ sky130_fd_sc_hd__mux2_1
X_16639_ clknet_leaf_97_clk _01206_ VGND VGND VPWR VPWR cpuregs\[23\]\[17\] sky130_fd_sc_hd__dfxtp_1
XFILLER_0_71_54 VGND VGND VPWR VPWR sky130_fd_sc_hd__fill_2
XFILLER_0_71_76 VGND VGND VPWR VPWR sky130_fd_sc_hd__decap_6
XFILLER_0_57_440 VGND VGND VPWR VPWR sky130_fd_sc_hd__decap_8
XFILLER_0_17_337 VGND VGND VPWR VPWR sky130_fd_sc_hd__fill_1
X_09111_ _03307_ _03376_ _03390_ _03360_ VGND VGND VPWR VPWR _03391_ sky130_fd_sc_hd__o211a_1
XFILLER_0_45_668 VGND VGND VPWR VPWR sky130_fd_sc_hd__fill_1
XFILLER_0_44_145 VGND VGND VPWR VPWR sky130_fd_sc_hd__decap_4
X_09042_ _03322_ VGND VGND VPWR VPWR _03323_ sky130_fd_sc_hd__buf_6
Xhold411 cpuregs\[19\]\[26\] VGND VGND VPWR VPWR net769 sky130_fd_sc_hd__dlygate4sd3_1
Xhold400 cpuregs\[14\]\[0\] VGND VGND VPWR VPWR net758 sky130_fd_sc_hd__dlygate4sd3_1
XFILLER_0_25_381 VGND VGND VPWR VPWR sky130_fd_sc_hd__fill_2
Xhold444 cpuregs\[17\]\[20\] VGND VGND VPWR VPWR net802 sky130_fd_sc_hd__dlygate4sd3_1
Xhold422 cpuregs\[23\]\[16\] VGND VGND VPWR VPWR net780 sky130_fd_sc_hd__dlygate4sd3_1
Xhold433 cpuregs\[24\]\[15\] VGND VGND VPWR VPWR net791 sky130_fd_sc_hd__dlygate4sd3_1
XFILLER_0_96_62 VGND VGND VPWR VPWR sky130_fd_sc_hd__decap_4
Xhold466 cpuregs\[14\]\[19\] VGND VGND VPWR VPWR net824 sky130_fd_sc_hd__dlygate4sd3_1
Xhold455 cpuregs\[10\]\[14\] VGND VGND VPWR VPWR net813 sky130_fd_sc_hd__dlygate4sd3_1
Xhold477 cpuregs\[6\]\[11\] VGND VGND VPWR VPWR net835 sky130_fd_sc_hd__dlygate4sd3_1
XFILLER_0_40_373 VGND VGND VPWR VPWR sky130_fd_sc_hd__fill_2
XFILLER_0_40_395 VGND VGND VPWR VPWR sky130_fd_sc_hd__decap_6
Xhold499 cpuregs\[7\]\[18\] VGND VGND VPWR VPWR net857 sky130_fd_sc_hd__dlygate4sd3_1
Xhold488 cpuregs\[11\]\[11\] VGND VGND VPWR VPWR net846 sky130_fd_sc_hd__dlygate4sd3_1
X_09944_ cpuregs\[4\]\[10\] cpuregs\[5\]\[10\] cpuregs\[6\]\[10\] cpuregs\[7\]\[10\]
+ _03667_ _04090_ VGND VGND VPWR VPWR _04170_ sky130_fd_sc_hd__mux4_1
X_09875_ _03971_ VGND VGND VPWR VPWR _04103_ sky130_fd_sc_hd__clkbuf_8
Xhold1100 cpuregs\[21\]\[14\] VGND VGND VPWR VPWR net1458 sky130_fd_sc_hd__dlygate4sd3_1
XTAP_760 VGND VPWR sky130_fd_sc_hd__tapvpwrvgnd_1
X_08826_ net223 _03169_ _02934_ VGND VGND VPWR VPWR _03178_ sky130_fd_sc_hd__o21a_1
Xhold1133 cpuregs\[17\]\[19\] VGND VGND VPWR VPWR net1491 sky130_fd_sc_hd__dlygate4sd3_1
Xhold1122 cpuregs\[31\]\[19\] VGND VGND VPWR VPWR net1480 sky130_fd_sc_hd__dlygate4sd3_1
Xhold1111 cpuregs\[20\]\[6\] VGND VGND VPWR VPWR net1469 sky130_fd_sc_hd__dlygate4sd3_1
XTAP_771 VGND VPWR sky130_fd_sc_hd__tapvpwrvgnd_1
XTAP_793 VGND VPWR sky130_fd_sc_hd__tapvpwrvgnd_1
XTAP_782 VGND VPWR sky130_fd_sc_hd__tapvpwrvgnd_1
Xhold1166 cpuregs\[9\]\[20\] VGND VGND VPWR VPWR net1524 sky130_fd_sc_hd__dlygate4sd3_1
Xhold1144 cpuregs\[9\]\[17\] VGND VGND VPWR VPWR net1502 sky130_fd_sc_hd__dlygate4sd3_1
Xhold1155 cpuregs\[16\]\[3\] VGND VGND VPWR VPWR net1513 sky130_fd_sc_hd__dlygate4sd3_1
Xhold1188 net38 VGND VGND VPWR VPWR net1546 sky130_fd_sc_hd__dlygate4sd3_1
X_08757_ _03111_ _03112_ _03113_ VGND VGND VPWR VPWR _03114_ sky130_fd_sc_hd__o21a_1
Xhold1199 cpuregs\[5\]\[13\] VGND VGND VPWR VPWR net1557 sky130_fd_sc_hd__dlygate4sd3_1
Xhold1177 cpuregs\[13\]\[1\] VGND VGND VPWR VPWR net1535 sky130_fd_sc_hd__dlygate4sd3_1
XTAP_1915 VGND VPWR sky130_fd_sc_hd__tapvpwrvgnd_1
XTAP_1904 VGND VPWR sky130_fd_sc_hd__tapvpwrvgnd_1
X_08688_ _02480_ net246 _02839_ _02857_ VGND VGND VPWR VPWR _03051_ sky130_fd_sc_hd__a31o_1
X_07708_ net182 VGND VGND VPWR VPWR _02134_ sky130_fd_sc_hd__clkbuf_4
XFILLER_0_138_626 VGND VGND VPWR VPWR sky130_fd_sc_hd__fill_2
XTAP_1959 VGND VPWR sky130_fd_sc_hd__tapvpwrvgnd_1
XTAP_1948 VGND VPWR sky130_fd_sc_hd__tapvpwrvgnd_1
XTAP_1926 VGND VPWR sky130_fd_sc_hd__tapvpwrvgnd_1
XTAP_1937 VGND VPWR sky130_fd_sc_hd__tapvpwrvgnd_1
XFILLER_0_137_125 VGND VGND VPWR VPWR sky130_fd_sc_hd__decap_6
X_10650_ _04116_ _04852_ _04856_ _03658_ VGND VGND VPWR VPWR _04857_ sky130_fd_sc_hd__o211a_1
XFILLER_0_137_169 VGND VGND VPWR VPWR sky130_fd_sc_hd__decap_4
X_09309_ _03559_ VGND VGND VPWR VPWR _00054_ sky130_fd_sc_hd__clkbuf_1
X_10581_ _02605_ _02632_ _03651_ VGND VGND VPWR VPWR _04789_ sky130_fd_sc_hd__mux2_1
XFILLER_0_106_501 VGND VGND VPWR VPWR sky130_fd_sc_hd__decap_6
X_12320_ _05726_ _05931_ VGND VGND VPWR VPWR _05934_ sky130_fd_sc_hd__nor2_1
X_12251_ _05869_ _05870_ VGND VGND VPWR VPWR _05871_ sky130_fd_sc_hd__nand2_1
XFILLER_0_121_559 VGND VGND VPWR VPWR sky130_fd_sc_hd__fill_1
X_11202_ _05197_ VGND VGND VPWR VPWR _00309_ sky130_fd_sc_hd__clkbuf_1
X_12182_ _05805_ _05806_ VGND VGND VPWR VPWR _05807_ sky130_fd_sc_hd__and2_1
X_11133_ _05152_ VGND VGND VPWR VPWR _00285_ sky130_fd_sc_hd__clkbuf_1
X_11064_ net633 _03610_ _05110_ VGND VGND VPWR VPWR _05116_ sky130_fd_sc_hd__mux2_1
X_15941_ clknet_leaf_146_clk _00591_ VGND VGND VPWR VPWR count_instr\[10\] sky130_fd_sc_hd__dfxtp_1
X_10015_ _03878_ _04236_ _04238_ VGND VGND VPWR VPWR _04239_ sky130_fd_sc_hd__a21o_1
X_15872_ clknet_leaf_143_clk _00522_ VGND VGND VPWR VPWR cpuregs\[20\]\[6\] sky130_fd_sc_hd__dfxtp_1
X_14823_ _01784_ VGND VGND VPWR VPWR _01278_ sky130_fd_sc_hd__clkbuf_1
XFILLER_0_116_27 VGND VGND VPWR VPWR sky130_fd_sc_hd__fill_1
X_14754_ _05037_ net1581 _01742_ VGND VGND VPWR VPWR _01748_ sky130_fd_sc_hd__mux2_1
XFILLER_0_59_716 VGND VGND VPWR VPWR sky130_fd_sc_hd__fill_2
X_11966_ _05644_ VGND VGND VPWR VPWR _00626_ sky130_fd_sc_hd__clkbuf_1
XFILLER_0_129_615 VGND VGND VPWR VPWR sky130_fd_sc_hd__fill_1
X_10917_ _05034_ VGND VGND VPWR VPWR _00187_ sky130_fd_sc_hd__clkbuf_1
X_13705_ _03340_ _07175_ _06998_ VGND VGND VPWR VPWR _07176_ sky130_fd_sc_hd__a21o_1
X_14685_ _01711_ VGND VGND VPWR VPWR _01213_ sky130_fd_sc_hd__clkbuf_1
X_13636_ _06421_ _07107_ _07109_ _06894_ VGND VGND VPWR VPWR _07110_ sky130_fd_sc_hd__a211o_1
XFILLER_0_128_103 VGND VGND VPWR VPWR sky130_fd_sc_hd__fill_2
X_16424_ clknet_leaf_25_clk _01006_ VGND VGND VPWR VPWR decoded_imm\[23\] sky130_fd_sc_hd__dfxtp_2
X_11897_ count_instr\[27\] count_instr\[26\] _05585_ _05589_ VGND VGND VPWR VPWR _05594_
+ sky130_fd_sc_hd__and4_1
XFILLER_0_66_281 VGND VGND VPWR VPWR sky130_fd_sc_hd__fill_2
X_10848_ _04987_ net1535 _04985_ VGND VGND VPWR VPWR _04988_ sky130_fd_sc_hd__mux2_1
XFILLER_0_41_24 VGND VGND VPWR VPWR sky130_fd_sc_hd__decap_4
X_13567_ _06849_ _07042_ VGND VGND VPWR VPWR _07043_ sky130_fd_sc_hd__or2_1
X_16355_ clknet_leaf_83_clk _00937_ VGND VGND VPWR VPWR cpuregs\[1\]\[20\] sky130_fd_sc_hd__dfxtp_1
XFILLER_0_54_432 VGND VGND VPWR VPWR sky130_fd_sc_hd__fill_2
X_10779_ _04949_ VGND VGND VPWR VPWR _00134_ sky130_fd_sc_hd__clkbuf_1
X_13498_ _06911_ _06975_ VGND VGND VPWR VPWR _06976_ sky130_fd_sc_hd__or2_1
XFILLER_0_124_342 VGND VGND VPWR VPWR sky130_fd_sc_hd__fill_1
X_15306_ _02038_ VGND VGND VPWR VPWR _01507_ sky130_fd_sc_hd__clkbuf_1
X_12518_ count_cycle\[4\] count_cycle\[5\] count_cycle\[6\] _06104_ VGND VGND VPWR
+ VPWR _06110_ sky130_fd_sc_hd__and4_2
XFILLER_0_26_178 VGND VGND VPWR VPWR sky130_fd_sc_hd__fill_1
X_16286_ clknet_leaf_140_clk _00871_ VGND VGND VPWR VPWR instr_sub sky130_fd_sc_hd__dfxtp_1
X_15237_ _03629_ net1316 _01995_ VGND VGND VPWR VPWR _02004_ sky130_fd_sc_hd__mux2_1
X_12449_ _05751_ _06052_ _05520_ VGND VGND VPWR VPWR _06053_ sky130_fd_sc_hd__mux2_1
XFILLER_0_41_137 VGND VGND VPWR VPWR sky130_fd_sc_hd__fill_2
XFILLER_0_2_757 VPWR VGND VPWR VGND sky130_ef_sc_hd__decap_12
X_15168_ _01967_ VGND VGND VPWR VPWR _01440_ sky130_fd_sc_hd__clkbuf_1
X_15099_ net701 _05217_ _01923_ VGND VGND VPWR VPWR _01931_ sky130_fd_sc_hd__mux2_1
X_07990_ net174 VGND VGND VPWR VPWR _02391_ sky130_fd_sc_hd__clkbuf_4
XFILLER_0_1_278 VGND VGND VPWR VPWR sky130_fd_sc_hd__fill_2
X_14119_ _04999_ net1324 _07471_ VGND VGND VPWR VPWR _07479_ sky130_fd_sc_hd__mux2_1
X_09660_ _03739_ _03888_ _03892_ _03885_ VGND VGND VPWR VPWR _03893_ sky130_fd_sc_hd__o211a_1
X_08611_ _02938_ _02947_ _02948_ VGND VGND VPWR VPWR _02980_ sky130_fd_sc_hd__a21bo_1
X_09591_ cpuregs\[20\]\[2\] cpuregs\[21\]\[2\] _03824_ VGND VGND VPWR VPWR _03825_
+ sky130_fd_sc_hd__mux2_1
XFILLER_0_89_384 VGND VGND VPWR VPWR sky130_fd_sc_hd__decap_8
XFILLER_0_82_53 VGND VGND VPWR VPWR sky130_fd_sc_hd__decap_6
X_08542_ _02666_ _02846_ _02857_ VGND VGND VPWR VPWR _02917_ sky130_fd_sc_hd__a21o_1
X_08473_ _02851_ _02852_ _02134_ VGND VGND VPWR VPWR _02853_ sky130_fd_sc_hd__o21a_1
XFILLER_0_106_82 VGND VGND VPWR VPWR sky130_fd_sc_hd__fill_2
XFILLER_0_64_218 VGND VGND VPWR VPWR sky130_fd_sc_hd__decap_4
XFILLER_0_57_281 VGND VGND VPWR VPWR sky130_fd_sc_hd__fill_1
XFILLER_0_17_145 VPWR VGND VPWR VGND sky130_ef_sc_hd__decap_12
XFILLER_0_134_139 VGND VGND VPWR VPWR sky130_fd_sc_hd__fill_1
XFILLER_0_72_273 VGND VGND VPWR VPWR sky130_fd_sc_hd__decap_8
XFILLER_0_17_167 VGND VGND VPWR VPWR sky130_fd_sc_hd__fill_1
XFILLER_0_131_824 VGND VGND VPWR VPWR sky130_fd_sc_hd__decap_4
XFILLER_0_60_457 VGND VGND VPWR VPWR sky130_fd_sc_hd__fill_1
X_09025_ _02170_ _02083_ _03306_ _03296_ _00841_ VGND VGND VPWR VPWR _00000_ sky130_fd_sc_hd__o32a_1
Xhold230 cpuregs\[24\]\[22\] VGND VGND VPWR VPWR net588 sky130_fd_sc_hd__dlygate4sd3_1
Xhold241 cpuregs\[28\]\[20\] VGND VGND VPWR VPWR net599 sky130_fd_sc_hd__dlygate4sd3_1
Xhold252 cpuregs\[8\]\[0\] VGND VGND VPWR VPWR net610 sky130_fd_sc_hd__dlygate4sd3_1
Xhold274 cpuregs\[26\]\[22\] VGND VGND VPWR VPWR net632 sky130_fd_sc_hd__dlygate4sd3_1
Xhold296 cpuregs\[12\]\[24\] VGND VGND VPWR VPWR net654 sky130_fd_sc_hd__dlygate4sd3_1
Xhold285 cpuregs\[26\]\[11\] VGND VGND VPWR VPWR net643 sky130_fd_sc_hd__dlygate4sd3_1
Xhold263 cpuregs\[20\]\[3\] VGND VGND VPWR VPWR net621 sky130_fd_sc_hd__dlygate4sd3_1
X_09927_ decoded_imm\[10\] net172 VGND VGND VPWR VPWR _04153_ sky130_fd_sc_hd__nand2_1
XTAP_590 VGND VPWR sky130_fd_sc_hd__tapvpwrvgnd_1
X_09858_ cpuregs\[12\]\[8\] cpuregs\[13\]\[8\] _03976_ VGND VGND VPWR VPWR _04086_
+ sky130_fd_sc_hd__mux2_1
X_08809_ _03148_ VGND VGND VPWR VPWR _03163_ sky130_fd_sc_hd__inv_2
XFILLER_0_99_148 VPWR VGND VPWR VGND sky130_ef_sc_hd__decap_12
X_09789_ cpuregs\[0\]\[6\] cpuregs\[1\]\[6\] _03980_ VGND VGND VPWR VPWR _04019_ sky130_fd_sc_hd__mux2_1
XFILLER_0_96_800 VGND VGND VPWR VPWR sky130_fd_sc_hd__fill_2
XANTENNA_114 net250 VGND VGND VPWR VPWR sky130_fd_sc_hd__diode_2
XANTENNA_125 _03991_ VGND VGND VPWR VPWR sky130_fd_sc_hd__diode_2
XANTENNA_103 net191 VGND VGND VPWR VPWR sky130_fd_sc_hd__diode_2
X_11820_ _05538_ VGND VGND VPWR VPWR _00586_ sky130_fd_sc_hd__clkbuf_1
XANTENNA_136 net74 VGND VGND VPWR VPWR sky130_fd_sc_hd__diode_2
XTAP_1734 VGND VPWR sky130_fd_sc_hd__tapvpwrvgnd_1
XTAP_1723 VGND VPWR sky130_fd_sc_hd__tapvpwrvgnd_1
XTAP_1712 VGND VPWR sky130_fd_sc_hd__tapvpwrvgnd_1
XANTENNA_158 net120 VGND VGND VPWR VPWR sky130_fd_sc_hd__diode_2
XTAP_1701 VGND VPWR sky130_fd_sc_hd__tapvpwrvgnd_1
XANTENNA_147 net168 VGND VGND VPWR VPWR sky130_fd_sc_hd__diode_2
X_11751_ _05496_ VGND VGND VPWR VPWR _00559_ sky130_fd_sc_hd__clkbuf_1
Xclkbuf_leaf_80_clk clknet_4_15_0_clk VGND VGND VPWR VPWR clknet_leaf_80_clk sky130_fd_sc_hd__clkbuf_16
XTAP_1767 VGND VPWR sky130_fd_sc_hd__tapvpwrvgnd_1
XTAP_1745 VGND VPWR sky130_fd_sc_hd__tapvpwrvgnd_1
XTAP_1756 VGND VPWR sky130_fd_sc_hd__tapvpwrvgnd_1
XFILLER_0_56_719 VGND VGND VPWR VPWR sky130_fd_sc_hd__decap_3
X_10702_ _04906_ VGND VGND VPWR VPWR _04907_ sky130_fd_sc_hd__clkbuf_8
XTAP_1789 VGND VPWR sky130_fd_sc_hd__tapvpwrvgnd_1
XTAP_1778 VGND VPWR sky130_fd_sc_hd__tapvpwrvgnd_1
X_14470_ _01597_ VGND VGND VPWR VPWR _01080_ sky130_fd_sc_hd__clkbuf_1
XFILLER_0_49_782 VGND VGND VPWR VPWR sky130_fd_sc_hd__fill_2
X_11682_ net1186 _05184_ _05458_ VGND VGND VPWR VPWR _05460_ sky130_fd_sc_hd__mux2_1
X_10633_ cpuregs\[14\]\[29\] cpuregs\[15\]\[29\] _04058_ VGND VGND VPWR VPWR _04840_
+ sky130_fd_sc_hd__mux2_1
X_13421_ cpuregs\[8\]\[19\] cpuregs\[9\]\[19\] _06764_ VGND VGND VPWR VPWR _06901_
+ sky130_fd_sc_hd__mux2_1
X_10564_ _04119_ _04772_ _04121_ VGND VGND VPWR VPWR _04773_ sky130_fd_sc_hd__a21o_1
XFILLER_0_118_191 VGND VGND VPWR VPWR sky130_fd_sc_hd__decap_4
XFILLER_0_106_331 VGND VGND VPWR VPWR sky130_fd_sc_hd__decap_8
X_16140_ clknet_leaf_31_clk _07627_ VGND VGND VPWR VPWR reg_out\[18\] sky130_fd_sc_hd__dfxtp_1
X_13352_ cpuregs\[12\]\[17\] cpuregs\[13\]\[17\] cpuregs\[14\]\[17\] cpuregs\[15\]\[17\]
+ _06696_ _06728_ VGND VGND VPWR VPWR _06834_ sky130_fd_sc_hd__mux4_1
XFILLER_0_11_27 VGND VGND VPWR VPWR sky130_fd_sc_hd__decap_8
X_12303_ _05917_ _05918_ VGND VGND VPWR VPWR _05919_ sky130_fd_sc_hd__xnor2_1
X_16071_ clknet_leaf_151_clk _00721_ VGND VGND VPWR VPWR count_cycle\[14\] sky130_fd_sc_hd__dfxtp_1
XFILLER_0_133_161 VGND VGND VPWR VPWR sky130_fd_sc_hd__fill_1
X_15022_ _01890_ VGND VGND VPWR VPWR _01371_ sky130_fd_sc_hd__clkbuf_1
X_10495_ cpuregs\[20\]\[25\] cpuregs\[21\]\[25\] _03880_ VGND VGND VPWR VPWR _04706_
+ sky130_fd_sc_hd__mux2_1
X_13283_ cpuregs\[10\]\[15\] cpuregs\[11\]\[15\] _06766_ VGND VGND VPWR VPWR _06767_
+ sky130_fd_sc_hd__mux2_1
X_12234_ _05829_ _05842_ VGND VGND VPWR VPWR _05855_ sky130_fd_sc_hd__nand2_1
X_12165_ instr_jal VGND VGND VPWR VPWR _05791_ sky130_fd_sc_hd__clkbuf_4
X_11116_ _05143_ VGND VGND VPWR VPWR _00277_ sky130_fd_sc_hd__clkbuf_1
X_16973_ clknet_leaf_70_clk _01537_ VGND VGND VPWR VPWR cpuregs\[10\]\[28\] sky130_fd_sc_hd__dfxtp_1
X_12096_ _05519_ VGND VGND VPWR VPWR _05737_ sky130_fd_sc_hd__buf_2
X_15924_ clknet_leaf_46_clk _00574_ VGND VGND VPWR VPWR cpuregs\[17\]\[26\] sky130_fd_sc_hd__dfxtp_1
X_11047_ net937 _03558_ _05099_ VGND VGND VPWR VPWR _05107_ sky130_fd_sc_hd__mux2_1
X_15855_ clknet_leaf_46_clk _00505_ VGND VGND VPWR VPWR cpuregs\[25\]\[21\] sky130_fd_sc_hd__dfxtp_1
Xinput9 mem_rdata[17] VGND VGND VPWR VPWR net9 sky130_fd_sc_hd__clkbuf_4
XFILLER_0_87_800 VGND VGND VPWR VPWR sky130_fd_sc_hd__fill_1
X_14806_ _01775_ VGND VGND VPWR VPWR _01270_ sky130_fd_sc_hd__clkbuf_1
XFILLER_0_98_170 VGND VGND VPWR VPWR sky130_fd_sc_hd__fill_2
X_15786_ clknet_leaf_18_clk _00436_ VGND VGND VPWR VPWR cpuregs\[26\]\[16\] sky130_fd_sc_hd__dfxtp_1
X_12998_ _03341_ _06490_ VGND VGND VPWR VPWR _06491_ sky130_fd_sc_hd__and2_1
Xclkbuf_leaf_71_clk clknet_4_15_0_clk VGND VGND VPWR VPWR clknet_leaf_71_clk sky130_fd_sc_hd__clkbuf_16
XFILLER_0_86_365 VGND VGND VPWR VPWR sky130_fd_sc_hd__decap_4
X_14737_ _05020_ net1415 _01731_ VGND VGND VPWR VPWR _01739_ sky130_fd_sc_hd__mux2_1
X_11949_ count_instr\[41\] net377 VGND VGND VPWR VPWR _05632_ sky130_fd_sc_hd__and2_1
XFILLER_0_139_3 VGND VGND VPWR VPWR sky130_fd_sc_hd__fill_1
X_14668_ _01702_ VGND VGND VPWR VPWR _01205_ sky130_fd_sc_hd__clkbuf_1
X_13619_ _06970_ _07092_ VGND VGND VPWR VPWR _07093_ sky130_fd_sc_hd__and2_1
X_16407_ clknet_leaf_18_clk _00989_ VGND VGND VPWR VPWR net169 sky130_fd_sc_hd__dfxtp_2
XFILLER_0_6_326 VGND VGND VPWR VPWR sky130_fd_sc_hd__fill_2
XFILLER_0_116_139 VGND VGND VPWR VPWR sky130_fd_sc_hd__fill_1
X_14599_ _05018_ net1403 _01659_ VGND VGND VPWR VPWR _01666_ sky130_fd_sc_hd__mux2_1
X_16338_ clknet_leaf_121_clk _00920_ VGND VGND VPWR VPWR cpuregs\[1\]\[3\] sky130_fd_sc_hd__dfxtp_1
XFILLER_0_70_755 VGND VGND VPWR VPWR sky130_fd_sc_hd__fill_1
XFILLER_0_14_126 VGND VGND VPWR VPWR sky130_fd_sc_hd__fill_1
XFILLER_0_42_446 VGND VGND VPWR VPWR sky130_fd_sc_hd__decap_4
XFILLER_0_140_643 VGND VGND VPWR VPWR sky130_fd_sc_hd__fill_1
XFILLER_0_124_161 VPWR VGND VPWR VGND sky130_ef_sc_hd__decap_12
X_16269_ clknet_leaf_3_clk _00854_ VGND VGND VPWR VPWR instr_lb sky130_fd_sc_hd__dfxtp_1
XFILLER_0_11_822 VGND VGND VPWR VPWR sky130_fd_sc_hd__fill_2
XFILLER_0_77_75 VGND VGND VPWR VPWR sky130_fd_sc_hd__fill_1
X_07973_ _02373_ _02374_ VGND VGND VPWR VPWR _02375_ sky130_fd_sc_hd__nand2_1
X_09712_ _03934_ _03937_ _03940_ _03943_ _03732_ _03873_ VGND VGND VPWR VPWR _03944_
+ sky130_fd_sc_hd__mux4_2
X_09643_ _03875_ VGND VGND VPWR VPWR _03876_ sky130_fd_sc_hd__clkbuf_8
XFILLER_0_93_52 VGND VGND VPWR VPWR sky130_fd_sc_hd__decap_4
X_09574_ cpuregs\[0\]\[2\] cpuregs\[1\]\[2\] cpuregs\[2\]\[2\] cpuregs\[3\]\[2\] _03666_
+ _03669_ VGND VGND VPWR VPWR _03808_ sky130_fd_sc_hd__mux4_1
XFILLER_0_139_209 VGND VGND VPWR VPWR sky130_fd_sc_hd__decap_8
XFILLER_0_89_192 VGND VGND VPWR VPWR sky130_fd_sc_hd__decap_4
X_08525_ _02294_ _02899_ VGND VGND VPWR VPWR _02901_ sky130_fd_sc_hd__and2_1
XTAP_1019 VGND VPWR sky130_fd_sc_hd__tapvpwrvgnd_1
XTAP_1008 VGND VPWR sky130_fd_sc_hd__tapvpwrvgnd_1
Xclkbuf_leaf_62_clk clknet_4_13_0_clk VGND VGND VPWR VPWR clknet_leaf_62_clk sky130_fd_sc_hd__clkbuf_16
XFILLER_0_92_302 VGND VGND VPWR VPWR sky130_fd_sc_hd__decap_6
X_08456_ instr_and instr_andi VGND VGND VPWR VPWR _02837_ sky130_fd_sc_hd__or2_1
X_08387_ _02719_ _02767_ VGND VGND VPWR VPWR _02768_ sky130_fd_sc_hd__nand2_1
XFILLER_0_60_221 VGND VGND VPWR VPWR sky130_fd_sc_hd__decap_8
XFILLER_0_103_334 VGND VGND VPWR VPWR sky130_fd_sc_hd__fill_2
X_09008_ mem_rdata_q\[16\] net8 _03292_ VGND VGND VPWR VPWR _03298_ sky130_fd_sc_hd__mux2_1
X_10280_ _03696_ _04494_ _04496_ VGND VGND VPWR VPWR _04497_ sky130_fd_sc_hd__a21o_1
XFILLER_0_61_799 VGND VGND VPWR VPWR sky130_fd_sc_hd__fill_1
XFILLER_0_130_186 VGND VGND VPWR VPWR sky130_fd_sc_hd__decap_8
X_13970_ instr_slt _07367_ _07361_ _07384_ VGND VGND VPWR VPWR _07393_ sky130_fd_sc_hd__a22o_1
X_12921_ _06414_ VGND VGND VPWR VPWR _06415_ sky130_fd_sc_hd__buf_4
XTAP_2210 VGND VPWR sky130_fd_sc_hd__tapvpwrvgnd_1
X_15640_ clknet_leaf_58_clk _00290_ VGND VGND VPWR VPWR cpuregs\[31\]\[30\] sky130_fd_sc_hd__dfxtp_1
XTAP_2243 VGND VPWR sky130_fd_sc_hd__tapvpwrvgnd_1
XTAP_2221 VGND VPWR sky130_fd_sc_hd__tapvpwrvgnd_1
XTAP_2232 VGND VPWR sky130_fd_sc_hd__tapvpwrvgnd_1
XFILLER_0_68_332 VGND VGND VPWR VPWR sky130_fd_sc_hd__fill_2
X_12852_ _03337_ VGND VGND VPWR VPWR _06351_ sky130_fd_sc_hd__buf_4
X_15571_ clknet_leaf_72_clk _00221_ VGND VGND VPWR VPWR cpuregs\[2\]\[25\] sky130_fd_sc_hd__dfxtp_1
XTAP_2287 VGND VPWR sky130_fd_sc_hd__tapvpwrvgnd_1
XTAP_2276 VGND VPWR sky130_fd_sc_hd__tapvpwrvgnd_1
XTAP_2265 VGND VPWR sky130_fd_sc_hd__tapvpwrvgnd_1
XTAP_2254 VGND VPWR sky130_fd_sc_hd__tapvpwrvgnd_1
Xclkbuf_leaf_53_clk clknet_4_6_0_clk VGND VGND VPWR VPWR clknet_leaf_53_clk sky130_fd_sc_hd__clkbuf_16
XTAP_1542 VGND VPWR sky130_fd_sc_hd__tapvpwrvgnd_1
XTAP_1531 VGND VPWR sky130_fd_sc_hd__tapvpwrvgnd_1
XTAP_1520 VGND VPWR sky130_fd_sc_hd__tapvpwrvgnd_1
XFILLER_0_68_365 VGND VGND VPWR VPWR sky130_fd_sc_hd__fill_1
X_12783_ net478 net68 _06302_ VGND VGND VPWR VPWR _06306_ sky130_fd_sc_hd__mux2_1
X_11803_ _02140_ VGND VGND VPWR VPWR _05526_ sky130_fd_sc_hd__buf_4
XTAP_2298 VGND VPWR sky130_fd_sc_hd__tapvpwrvgnd_1
XTAP_1575 VGND VPWR sky130_fd_sc_hd__tapvpwrvgnd_1
XTAP_1564 VGND VPWR sky130_fd_sc_hd__tapvpwrvgnd_1
XTAP_1553 VGND VPWR sky130_fd_sc_hd__tapvpwrvgnd_1
XFILLER_0_83_324 VGND VGND VPWR VPWR sky130_fd_sc_hd__decap_3
X_14522_ _01625_ VGND VGND VPWR VPWR _01136_ sky130_fd_sc_hd__clkbuf_1
X_11734_ _05487_ VGND VGND VPWR VPWR _00551_ sky130_fd_sc_hd__clkbuf_1
XPHY_60 VGND VGND VPWR VPWR sky130_fd_sc_hd__decap_3
XPHY_71 VGND VGND VPWR VPWR sky130_fd_sc_hd__decap_3
XPHY_82 VGND VGND VPWR VPWR sky130_fd_sc_hd__decap_3
XFILLER_0_138_253 VGND VGND VPWR VPWR sky130_fd_sc_hd__decap_3
XTAP_1597 VGND VPWR sky130_fd_sc_hd__tapvpwrvgnd_1
XTAP_1586 VGND VPWR sky130_fd_sc_hd__tapvpwrvgnd_1
XFILLER_0_83_335 VGND VGND VPWR VPWR sky130_fd_sc_hd__fill_1
X_14453_ net946 _05184_ _01587_ VGND VGND VPWR VPWR _01589_ sky130_fd_sc_hd__mux2_1
XPHY_93 VGND VGND VPWR VPWR sky130_fd_sc_hd__decap_3
X_11665_ net621 _05167_ _05447_ VGND VGND VPWR VPWR _05451_ sky130_fd_sc_hd__mux2_1
X_10616_ _03662_ _04819_ _04823_ _03684_ VGND VGND VPWR VPWR _04824_ sky130_fd_sc_hd__o211a_1
Xclkbuf_4_6_0_clk clknet_0_clk VGND VGND VPWR VPWR clknet_4_6_0_clk sky130_fd_sc_hd__clkbuf_8
X_13404_ cpuregs\[20\]\[18\] cpuregs\[21\]\[18\] _06784_ VGND VGND VPWR VPWR _06885_
+ sky130_fd_sc_hd__mux2_1
XFILLER_0_71_519 VGND VGND VPWR VPWR sky130_fd_sc_hd__decap_4
XFILLER_0_37_796 VGND VGND VPWR VPWR sky130_fd_sc_hd__fill_2
XFILLER_0_113_109 VGND VGND VPWR VPWR sky130_fd_sc_hd__decap_3
X_14384_ _01552_ VGND VGND VPWR VPWR _01039_ sky130_fd_sc_hd__clkbuf_1
XFILLER_0_52_755 VGND VGND VPWR VPWR sky130_fd_sc_hd__fill_1
X_11596_ _05414_ VGND VGND VPWR VPWR _00486_ sky130_fd_sc_hd__clkbuf_1
X_10547_ _02548_ _02593_ _02653_ _02621_ _03364_ _03916_ VGND VGND VPWR VPWR _04756_
+ sky130_fd_sc_hd__mux4_1
XFILLER_0_106_172 VGND VGND VPWR VPWR sky130_fd_sc_hd__fill_2
X_13335_ _06631_ _06810_ _06817_ VGND VGND VPWR VPWR _06818_ sky130_fd_sc_hd__or3_2
X_16123_ clknet_leaf_13_clk _07629_ VGND VGND VPWR VPWR reg_out\[1\] sky130_fd_sc_hd__dfxtp_1
X_16054_ clknet_leaf_37_clk _00704_ VGND VGND VPWR VPWR reg_next_pc\[29\] sky130_fd_sc_hd__dfxtp_1
X_10478_ _04687_ _04688_ VGND VGND VPWR VPWR _04689_ sky130_fd_sc_hd__xnor2_1
X_13266_ _06382_ VGND VGND VPWR VPWR _06751_ sky130_fd_sc_hd__buf_4
X_15005_ _01881_ VGND VGND VPWR VPWR _01363_ sky130_fd_sc_hd__clkbuf_1
X_12217_ decoded_imm_j\[8\] _05708_ VGND VGND VPWR VPWR _05839_ sky130_fd_sc_hd__or2_1
X_13197_ _06682_ _06683_ VGND VGND VPWR VPWR _06684_ sky130_fd_sc_hd__and2_1
X_12148_ _05769_ _05771_ _05772_ _05775_ VGND VGND VPWR VPWR _05776_ sky130_fd_sc_hd__a31o_1
X_12079_ _05696_ reg_pc\[15\] _05697_ _05724_ VGND VGND VPWR VPWR _00659_ sky130_fd_sc_hd__o211a_1
X_16956_ clknet_leaf_103_clk _01520_ VGND VGND VPWR VPWR cpuregs\[10\]\[11\] sky130_fd_sc_hd__dfxtp_1
X_15907_ clknet_leaf_138_clk _00557_ VGND VGND VPWR VPWR cpuregs\[17\]\[9\] sky130_fd_sc_hd__dfxtp_1
X_16887_ clknet_leaf_115_clk _01451_ VGND VGND VPWR VPWR cpuregs\[8\]\[6\] sky130_fd_sc_hd__dfxtp_1
XFILLER_0_63_55 VGND VGND VPWR VPWR sky130_fd_sc_hd__fill_1
X_15838_ clknet_leaf_125_clk _00488_ VGND VGND VPWR VPWR cpuregs\[25\]\[4\] sky130_fd_sc_hd__dfxtp_1
Xclkbuf_leaf_44_clk clknet_4_7_0_clk VGND VGND VPWR VPWR clknet_leaf_44_clk sky130_fd_sc_hd__clkbuf_16
X_15769_ clknet_leaf_94_clk _00419_ VGND VGND VPWR VPWR cpuregs\[15\]\[31\] sky130_fd_sc_hd__dfxtp_1
X_08310_ net175 net207 VGND VGND VPWR VPWR _02691_ sky130_fd_sc_hd__or2_1
X_09290_ _03434_ _03540_ _03541_ _03542_ VGND VGND VPWR VPWR _03543_ sky130_fd_sc_hd__a22o_2
XFILLER_0_87_696 VGND VGND VPWR VPWR sky130_fd_sc_hd__fill_1
XFILLER_0_59_387 VGND VGND VPWR VPWR sky130_fd_sc_hd__fill_1
XFILLER_0_74_357 VGND VGND VPWR VPWR sky130_fd_sc_hd__decap_6
XANTENNA_14 _03766_ VGND VGND VPWR VPWR sky130_fd_sc_hd__diode_2
X_08241_ count_instr\[29\] _02270_ count_cycle\[61\] _02456_ VGND VGND VPWR VPWR _02625_
+ sky130_fd_sc_hd__a22o_1
XFILLER_0_103_61 VGND VGND VPWR VPWR sky130_fd_sc_hd__fill_1
XANTENNA_47 net56 VGND VGND VPWR VPWR sky130_fd_sc_hd__diode_2
XANTENNA_25 _04050_ VGND VGND VPWR VPWR sky130_fd_sc_hd__diode_2
XANTENNA_36 net3 VGND VGND VPWR VPWR sky130_fd_sc_hd__diode_2
XFILLER_0_28_774 VGND VGND VPWR VPWR sky130_fd_sc_hd__fill_1
X_08172_ reg_pc\[24\] decoded_imm\[24\] VGND VGND VPWR VPWR _02561_ sky130_fd_sc_hd__or2_1
XFILLER_0_104_109 VGND VGND VPWR VPWR sky130_fd_sc_hd__decap_3
XANTENNA_58 net72 VGND VGND VPWR VPWR sky130_fd_sc_hd__diode_2
XANTENNA_69 net88 VGND VGND VPWR VPWR sky130_fd_sc_hd__diode_2
XFILLER_0_88_52 VGND VGND VPWR VPWR sky130_fd_sc_hd__fill_1
Xoutput110 net110 VGND VGND VPWR VPWR mem_la_wdata[21] sky130_fd_sc_hd__clkbuf_4
Xoutput121 net121 VGND VGND VPWR VPWR mem_la_wdata[31] sky130_fd_sc_hd__clkbuf_4
Xoutput132 net132 VGND VGND VPWR VPWR mem_la_wstrb[2] sky130_fd_sc_hd__clkbuf_4
XFILLER_0_112_153 VGND VGND VPWR VPWR sky130_fd_sc_hd__decap_4
Xoutput143 net143 VGND VGND VPWR VPWR mem_wdata[17] sky130_fd_sc_hd__clkbuf_4
XFILLER_0_88_85 VGND VGND VPWR VPWR sky130_fd_sc_hd__decap_4
Xoutput165 net165 VGND VGND VPWR VPWR mem_wdata[8] sky130_fd_sc_hd__clkbuf_4
Xoutput176 net176 VGND VGND VPWR VPWR pcpi_rs1[14] sky130_fd_sc_hd__clkbuf_4
Xoutput154 net154 VGND VGND VPWR VPWR mem_wdata[27] sky130_fd_sc_hd__clkbuf_4
XFILLER_0_112_197 VGND VGND VPWR VPWR sky130_fd_sc_hd__decap_3
XFILLER_0_10_162 VGND VGND VPWR VPWR sky130_fd_sc_hd__fill_1
Xoutput198 net198 VGND VGND VPWR VPWR pcpi_rs1[5] sky130_fd_sc_hd__clkbuf_4
XFILLER_0_10_195 VGND VGND VPWR VPWR sky130_fd_sc_hd__fill_1
Xoutput187 net187 VGND VGND VPWR VPWR pcpi_rs1[24] sky130_fd_sc_hd__clkbuf_4
X_07956_ _02331_ _02334_ _02349_ _02358_ VGND VGND VPWR VPWR _02359_ sky130_fd_sc_hd__o31a_1
X_07887_ net5 net22 _02213_ VGND VGND VPWR VPWR _02295_ sky130_fd_sc_hd__mux2_1
X_09626_ _03858_ VGND VGND VPWR VPWR _03859_ sky130_fd_sc_hd__inv_2
XFILLER_0_78_641 VGND VGND VPWR VPWR sky130_fd_sc_hd__decap_3
X_09557_ _03789_ _03790_ VGND VGND VPWR VPWR _03791_ sky130_fd_sc_hd__and2b_1
Xclkbuf_leaf_35_clk clknet_4_5_0_clk VGND VGND VPWR VPWR clknet_leaf_35_clk sky130_fd_sc_hd__clkbuf_16
XFILLER_0_93_611 VGND VGND VPWR VPWR sky130_fd_sc_hd__decap_4
XFILLER_0_78_685 VGND VGND VPWR VPWR sky130_fd_sc_hd__decap_3
X_08508_ _02850_ _02884_ VGND VGND VPWR VPWR _02885_ sky130_fd_sc_hd__nand2_1
X_09488_ _03722_ VGND VGND VPWR VPWR _03723_ sky130_fd_sc_hd__buf_4
X_08439_ _02734_ _02818_ _02819_ VGND VGND VPWR VPWR _02820_ sky130_fd_sc_hd__a21oi_1
XFILLER_0_136_757 VGND VGND VPWR VPWR sky130_fd_sc_hd__decap_4
XFILLER_0_135_223 VGND VGND VPWR VPWR sky130_fd_sc_hd__fill_1
XFILLER_0_53_519 VGND VGND VPWR VPWR sky130_fd_sc_hd__decap_3
XFILLER_0_18_251 VGND VGND VPWR VPWR sky130_fd_sc_hd__fill_1
XFILLER_0_19_785 VGND VGND VPWR VPWR sky130_fd_sc_hd__fill_1
X_11450_ net1130 _05225_ _05301_ VGND VGND VPWR VPWR _05336_ sky130_fd_sc_hd__mux2_1
X_10401_ _04578_ _04583_ _04613_ VGND VGND VPWR VPWR _04614_ sky130_fd_sc_hd__nand3_1
X_11381_ _05299_ VGND VGND VPWR VPWR _00386_ sky130_fd_sc_hd__clkbuf_1
X_10332_ _02468_ _02509_ _02578_ _02536_ _03364_ _03916_ VGND VGND VPWR VPWR _04547_
+ sky130_fd_sc_hd__mux4_1
X_13120_ _06434_ _06608_ VGND VGND VPWR VPWR _06609_ sky130_fd_sc_hd__and2_1
XFILLER_0_21_427 VGND VGND VPWR VPWR sky130_fd_sc_hd__decap_4
X_13051_ _03332_ VGND VGND VPWR VPWR _06542_ sky130_fd_sc_hd__buf_4
X_10263_ cpuregs\[8\]\[19\] cpuregs\[9\]\[19\] cpuregs\[10\]\[19\] cpuregs\[11\]\[19\]
+ _04192_ _03719_ VGND VGND VPWR VPWR _04480_ sky130_fd_sc_hd__mux4_1
X_12002_ _05670_ VGND VGND VPWR VPWR _00636_ sky130_fd_sc_hd__clkbuf_1
X_10194_ _03984_ _04410_ _04412_ VGND VGND VPWR VPWR _04413_ sky130_fd_sc_hd__a21o_1
X_16810_ clknet_leaf_72_clk _01374_ VGND VGND VPWR VPWR cpuregs\[6\]\[25\] sky130_fd_sc_hd__dfxtp_1
X_16741_ clknet_leaf_84_clk _01305_ VGND VGND VPWR VPWR cpuregs\[4\]\[20\] sky130_fd_sc_hd__dfxtp_1
XFILLER_0_17_37 VGND VGND VPWR VPWR sky130_fd_sc_hd__fill_1
X_13953_ mem_rdata_q\[31\] mem_rdata_q\[30\] mem_rdata_q\[29\] _07380_ VGND VGND VPWR
+ VPWR _07381_ sky130_fd_sc_hd__nor4_1
X_16672_ clknet_leaf_93_clk _01239_ VGND VGND VPWR VPWR cpuregs\[29\]\[18\] sky130_fd_sc_hd__dfxtp_1
X_12904_ _03346_ _06399_ _06401_ VGND VGND VPWR VPWR _06402_ sky130_fd_sc_hd__a21o_1
X_13884_ _07326_ _07334_ VGND VGND VPWR VPWR _07335_ sky130_fd_sc_hd__and2_1
XTAP_2051 VGND VPWR sky130_fd_sc_hd__tapvpwrvgnd_1
XTAP_2040 VGND VPWR sky130_fd_sc_hd__tapvpwrvgnd_1
X_15623_ clknet_leaf_99_clk _00273_ VGND VGND VPWR VPWR cpuregs\[31\]\[13\] sky130_fd_sc_hd__dfxtp_1
X_12835_ _06332_ _06335_ _06336_ _02091_ VGND VGND VPWR VPWR _06337_ sky130_fd_sc_hd__a211o_1
XTAP_2095 VGND VPWR sky130_fd_sc_hd__tapvpwrvgnd_1
XTAP_2084 VGND VPWR sky130_fd_sc_hd__tapvpwrvgnd_1
XTAP_2073 VGND VPWR sky130_fd_sc_hd__tapvpwrvgnd_1
XTAP_2062 VGND VPWR sky130_fd_sc_hd__tapvpwrvgnd_1
XTAP_1350 VGND VPWR sky130_fd_sc_hd__tapvpwrvgnd_1
Xclkbuf_leaf_26_clk clknet_4_4_0_clk VGND VGND VPWR VPWR clknet_leaf_26_clk sky130_fd_sc_hd__clkbuf_16
X_15554_ clknet_leaf_113_clk _00204_ VGND VGND VPWR VPWR cpuregs\[2\]\[8\] sky130_fd_sc_hd__dfxtp_1
X_12766_ net548 net90 _06294_ VGND VGND VPWR VPWR _06297_ sky130_fd_sc_hd__mux2_1
XTAP_1383 VGND VPWR sky130_fd_sc_hd__tapvpwrvgnd_1
XTAP_1372 VGND VPWR sky130_fd_sc_hd__tapvpwrvgnd_1
XTAP_1361 VGND VPWR sky130_fd_sc_hd__tapvpwrvgnd_1
X_14505_ _01616_ VGND VGND VPWR VPWR _01128_ sky130_fd_sc_hd__clkbuf_1
X_11717_ net629 _05219_ _05469_ VGND VGND VPWR VPWR _05478_ sky130_fd_sc_hd__mux2_1
XTAP_1394 VGND VPWR sky130_fd_sc_hd__tapvpwrvgnd_1
X_12697_ net1660 _06234_ VGND VGND VPWR VPWR _06238_ sky130_fd_sc_hd__nand2_1
X_15485_ clknet_leaf_123_clk _00135_ VGND VGND VPWR VPWR cpuregs\[30\]\[3\] sky130_fd_sc_hd__dfxtp_1
Xinput12 mem_rdata[1] VGND VGND VPWR VPWR net12 sky130_fd_sc_hd__clkbuf_4
XFILLER_0_140_26 VGND VGND VPWR VPWR sky130_fd_sc_hd__fill_2
X_11648_ _05441_ VGND VGND VPWR VPWR _00511_ sky130_fd_sc_hd__clkbuf_1
XFILLER_0_64_390 VGND VGND VPWR VPWR sky130_fd_sc_hd__decap_3
X_14436_ net693 _05167_ _01576_ VGND VGND VPWR VPWR _01580_ sky130_fd_sc_hd__mux2_1
X_11579_ _05041_ net1298 _05397_ VGND VGND VPWR VPWR _05405_ sky130_fd_sc_hd__mux2_1
Xinput34 resetn VGND VGND VPWR VPWR net34 sky130_fd_sc_hd__buf_6
Xinput23 mem_rdata[2] VGND VGND VPWR VPWR net23 sky130_fd_sc_hd__clkbuf_2
X_14367_ _01543_ VGND VGND VPWR VPWR _01031_ sky130_fd_sc_hd__clkbuf_1
Xhold807 cpuregs\[22\]\[27\] VGND VGND VPWR VPWR net1165 sky130_fd_sc_hd__dlygate4sd3_1
X_13318_ _02181_ VGND VGND VPWR VPWR _06802_ sky130_fd_sc_hd__clkbuf_4
Xhold818 net170 VGND VGND VPWR VPWR net1176 sky130_fd_sc_hd__dlygate4sd3_1
X_16106_ clknet_leaf_152_clk _00756_ VGND VGND VPWR VPWR count_cycle\[49\] sky130_fd_sc_hd__dfxtp_1
XFILLER_0_25_788 VGND VGND VPWR VPWR sky130_fd_sc_hd__fill_1
X_17086_ net119 VGND VGND VPWR VPWR net225 sky130_fd_sc_hd__clkbuf_2
X_14298_ _07569_ _07573_ _07579_ _07575_ net1568 VGND VGND VPWR VPWR _01002_ sky130_fd_sc_hd__o32a_1
XFILLER_0_0_811 VGND VGND VPWR VPWR sky130_fd_sc_hd__fill_1
Xhold829 cpuregs\[28\]\[7\] VGND VGND VPWR VPWR net1187 sky130_fd_sc_hd__dlygate4sd3_1
X_16037_ clknet_leaf_28_clk _00687_ VGND VGND VPWR VPWR reg_next_pc\[12\] sky130_fd_sc_hd__dfxtp_1
X_13249_ _06535_ _06729_ _06733_ _06542_ VGND VGND VPWR VPWR _06734_ sky130_fd_sc_hd__o211a_1
XFILLER_0_58_66 VGND VGND VPWR VPWR sky130_fd_sc_hd__decap_4
X_08790_ net221 _03144_ VGND VGND VPWR VPWR _03145_ sky130_fd_sc_hd__xnor2_1
X_07810_ _02132_ _02207_ _02220_ _02222_ VGND VGND VPWR VPWR _02223_ sky130_fd_sc_hd__a22o_1
X_07741_ cpu_state\[1\] _02154_ _02158_ _02160_ _02161_ VGND VGND VPWR VPWR _02162_
+ sky130_fd_sc_hd__a221o_1
X_16939_ clknet_leaf_82_clk _01503_ VGND VGND VPWR VPWR cpuregs\[0\]\[26\] sky130_fd_sc_hd__dfxtp_1
X_07672_ _02097_ _02098_ _02100_ _02101_ mem_do_prefetch VGND VGND VPWR VPWR _02102_
+ sky130_fd_sc_hd__a32o_1
X_09411_ _03647_ VGND VGND VPWR VPWR _00068_ sky130_fd_sc_hd__clkbuf_1
XFILLER_0_48_803 VGND VGND VPWR VPWR sky130_fd_sc_hd__fill_1
X_09342_ reg_pc\[22\] reg_pc\[21\] _03573_ VGND VGND VPWR VPWR _03588_ sky130_fd_sc_hd__and3_1
Xclkbuf_leaf_17_clk clknet_4_3_0_clk VGND VGND VPWR VPWR clknet_leaf_17_clk sky130_fd_sc_hd__clkbuf_16
XFILLER_0_118_713 VGND VGND VPWR VPWR sky130_fd_sc_hd__decap_4
XFILLER_0_74_110 VGND VGND VPWR VPWR sky130_fd_sc_hd__fill_2
XFILLER_0_117_223 VGND VGND VPWR VPWR sky130_fd_sc_hd__fill_1
X_09273_ reg_pc\[12\] _03515_ reg_pc\[13\] VGND VGND VPWR VPWR _03528_ sky130_fd_sc_hd__a21o_1
XFILLER_0_62_327 VGND VGND VPWR VPWR sky130_fd_sc_hd__fill_1
X_08224_ count_instr\[28\] _02201_ count_cycle\[60\] _02456_ VGND VGND VPWR VPWR _02609_
+ sky130_fd_sc_hd__a22o_1
XFILLER_0_7_476 VGND VGND VPWR VPWR sky130_fd_sc_hd__decap_3
XFILLER_0_15_210 VGND VGND VPWR VPWR sky130_fd_sc_hd__fill_2
X_08155_ _02530_ _02533_ _02543_ _02170_ VGND VGND VPWR VPWR _02545_ sky130_fd_sc_hd__a31o_1
XFILLER_0_132_259 VPWR VGND VPWR VGND sky130_ef_sc_hd__decap_12
XFILLER_0_70_360 VGND VGND VPWR VPWR sky130_fd_sc_hd__decap_4
XFILLER_0_101_602 VGND VGND VPWR VPWR sky130_fd_sc_hd__decap_3
X_08086_ _02221_ _02465_ _02479_ _02242_ _02480_ VGND VGND VPWR VPWR _02481_ sky130_fd_sc_hd__a32o_1
XFILLER_0_3_671 VGND VGND VPWR VPWR sky130_fd_sc_hd__fill_1
XFILLER_0_31_758 VGND VGND VPWR VPWR sky130_fd_sc_hd__fill_2
XFILLER_0_140_281 VGND VGND VPWR VPWR sky130_fd_sc_hd__decap_3
X_08988_ _02621_ _03283_ _03268_ VGND VGND VPWR VPWR _03284_ sky130_fd_sc_hd__mux2_1
X_07939_ _02197_ _02335_ _02339_ _02222_ _02343_ VGND VGND VPWR VPWR _07648_ sky130_fd_sc_hd__a221o_1
X_10950_ _04991_ net1566 _05052_ VGND VGND VPWR VPWR _05056_ sky130_fd_sc_hd__mux2_1
X_10881_ _03524_ VGND VGND VPWR VPWR _05010_ sky130_fd_sc_hd__clkbuf_4
X_09609_ _03817_ _03830_ _03842_ VGND VGND VPWR VPWR _03843_ sky130_fd_sc_hd__or3_1
X_12620_ net1645 _06178_ _06182_ VGND VGND VPWR VPWR _00742_ sky130_fd_sc_hd__o21a_1
X_12551_ _06132_ _06128_ _06133_ VGND VGND VPWR VPWR _06134_ sky130_fd_sc_hd__and3b_1
X_11502_ net991 _05209_ _05360_ VGND VGND VPWR VPWR _05364_ sky130_fd_sc_hd__mux2_1
X_12482_ _06081_ _06082_ _05695_ VGND VGND VPWR VPWR _06083_ sky130_fd_sc_hd__o21ai_1
X_15270_ _02020_ VGND VGND VPWR VPWR _01489_ sky130_fd_sc_hd__clkbuf_1
X_14221_ _07535_ VGND VGND VPWR VPWR _00969_ sky130_fd_sc_hd__clkbuf_1
X_11433_ _05327_ VGND VGND VPWR VPWR _00410_ sky130_fd_sc_hd__clkbuf_1
XFILLER_0_34_530 VGND VGND VPWR VPWR sky130_fd_sc_hd__fill_2
X_14152_ _07496_ VGND VGND VPWR VPWR _00939_ sky130_fd_sc_hd__clkbuf_1
XFILLER_0_21_213 VGND VGND VPWR VPWR sky130_fd_sc_hd__fill_2
XFILLER_0_132_771 VPWR VGND VPWR VGND sky130_ef_sc_hd__decap_12
X_11364_ _05031_ net1104 _05288_ VGND VGND VPWR VPWR _05291_ sky130_fd_sc_hd__mux2_1
XFILLER_0_61_393 VGND VGND VPWR VPWR sky130_fd_sc_hd__decap_4
XFILLER_0_0_118 VGND VGND VPWR VPWR sky130_fd_sc_hd__fill_2
XFILLER_0_131_281 VGND VGND VPWR VPWR sky130_fd_sc_hd__decap_4
X_11295_ net584 _05207_ _05251_ VGND VGND VPWR VPWR _05254_ sky130_fd_sc_hd__mux2_1
X_10315_ _03747_ _04524_ _04530_ VGND VGND VPWR VPWR _04531_ sky130_fd_sc_hd__or3_2
XFILLER_0_21_268 VGND VGND VPWR VPWR sky130_fd_sc_hd__fill_1
X_14083_ decoded_imm_j\[3\] _01116_ _03295_ VGND VGND VPWR VPWR _07458_ sky130_fd_sc_hd__mux2_1
X_13103_ cpuregs\[30\]\[9\] cpuregs\[31\]\[9\] _06462_ VGND VGND VPWR VPWR _06593_
+ sky130_fd_sc_hd__mux2_1
X_10246_ cpuregs\[28\]\[18\] cpuregs\[29\]\[18\] cpuregs\[30\]\[18\] cpuregs\[31\]\[18\]
+ _03938_ _03939_ VGND VGND VPWR VPWR _04464_ sky130_fd_sc_hd__mux4_1
XTAP_419 VGND VPWR sky130_fd_sc_hd__tapvpwrvgnd_1
XTAP_408 VGND VPWR sky130_fd_sc_hd__tapvpwrvgnd_1
XFILLER_0_30_791 VGND VGND VPWR VPWR sky130_fd_sc_hd__fill_2
X_13034_ cpuregs\[24\]\[7\] cpuregs\[25\]\[7\] cpuregs\[26\]\[7\] cpuregs\[27\]\[7\]
+ _06525_ _06457_ VGND VGND VPWR VPWR _06526_ sky130_fd_sc_hd__mux4_1
X_10177_ _04393_ _04394_ _04395_ _04396_ _04030_ _04103_ VGND VGND VPWR VPWR _04397_
+ sky130_fd_sc_hd__mux4_1
XFILLER_0_28_58 VPWR VGND VPWR VGND sky130_ef_sc_hd__decap_12
X_14985_ _03478_ net1451 _01865_ VGND VGND VPWR VPWR _01871_ sky130_fd_sc_hd__mux2_1
X_16724_ clknet_leaf_121_clk _01288_ VGND VGND VPWR VPWR cpuregs\[4\]\[3\] sky130_fd_sc_hd__dfxtp_1
X_13936_ _07369_ VGND VGND VPWR VPWR _00862_ sky130_fd_sc_hd__clkbuf_1
X_16655_ clknet_leaf_143_clk _01222_ VGND VGND VPWR VPWR cpuregs\[29\]\[1\] sky130_fd_sc_hd__dfxtp_1
X_15606_ clknet_leaf_66_clk _00256_ VGND VGND VPWR VPWR cpuregs\[28\]\[28\] sky130_fd_sc_hd__dfxtp_1
XFILLER_0_97_791 VGND VGND VPWR VPWR sky130_fd_sc_hd__fill_1
X_13867_ _07316_ VGND VGND VPWR VPWR _01099_ sky130_fd_sc_hd__inv_2
X_12818_ net542 net85 _06293_ VGND VGND VPWR VPWR _06324_ sky130_fd_sc_hd__mux2_1
X_13798_ cpuregs\[4\]\[31\] cpuregs\[5\]\[31\] _03329_ VGND VGND VPWR VPWR _07266_
+ sky130_fd_sc_hd__mux2_1
X_16586_ clknet_leaf_5_clk _00020_ VGND VGND VPWR VPWR cpu_state\[3\] sky130_fd_sc_hd__dfxtp_2
X_15537_ clknet_leaf_77_clk _00187_ VGND VGND VPWR VPWR cpuregs\[13\]\[23\] sky130_fd_sc_hd__dfxtp_1
X_12749_ _03794_ _06269_ _06282_ _03775_ reg_pc\[31\] VGND VGND VPWR VPWR _06283_
+ sky130_fd_sc_hd__a32o_1
XTAP_1191 VGND VPWR sky130_fd_sc_hd__tapvpwrvgnd_1
XTAP_1180 VGND VPWR sky130_fd_sc_hd__tapvpwrvgnd_1
XFILLER_0_127_576 VGND VGND VPWR VPWR sky130_fd_sc_hd__fill_1
XFILLER_0_115_716 VGND VGND VPWR VPWR sky130_fd_sc_hd__fill_1
X_15468_ clknet_leaf_85_clk _00118_ VGND VGND VPWR VPWR cpuregs\[12\]\[18\] sky130_fd_sc_hd__dfxtp_1
X_14419_ _01570_ VGND VGND VPWR VPWR _01056_ sky130_fd_sc_hd__clkbuf_1
XFILLER_0_115_738 VGND VGND VPWR VPWR sky130_fd_sc_hd__fill_1
XFILLER_0_114_237 VGND VGND VPWR VPWR sky130_fd_sc_hd__fill_2
X_15399_ clknet_leaf_104_clk _00054_ VGND VGND VPWR VPWR cpuregs\[11\]\[17\] sky130_fd_sc_hd__dfxtp_1
XFILLER_0_4_457 VGND VGND VPWR VPWR sky130_fd_sc_hd__decap_6
Xhold626 cpuregs\[2\]\[8\] VGND VGND VPWR VPWR net984 sky130_fd_sc_hd__dlygate4sd3_1
Xhold604 cpuregs\[20\]\[7\] VGND VGND VPWR VPWR net962 sky130_fd_sc_hd__dlygate4sd3_1
Xhold615 cpuregs\[25\]\[9\] VGND VGND VPWR VPWR net973 sky130_fd_sc_hd__dlygate4sd3_1
Xhold637 cpuregs\[10\]\[21\] VGND VGND VPWR VPWR net995 sky130_fd_sc_hd__dlygate4sd3_1
X_09960_ _04185_ VGND VGND VPWR VPWR _00079_ sky130_fd_sc_hd__clkbuf_1
Xhold659 cpuregs\[20\]\[4\] VGND VGND VPWR VPWR net1017 sky130_fd_sc_hd__dlygate4sd3_1
XFILLER_0_12_279 VGND VGND VPWR VPWR sky130_fd_sc_hd__decap_3
Xclkbuf_leaf_6_clk clknet_4_1_0_clk VGND VGND VPWR VPWR clknet_leaf_6_clk sky130_fd_sc_hd__clkbuf_16
Xhold648 cpuregs\[14\]\[2\] VGND VGND VPWR VPWR net1006 sky130_fd_sc_hd__dlygate4sd3_1
X_08911_ reg_out\[4\] reg_next_pc\[4\] _03225_ VGND VGND VPWR VPWR _03231_ sky130_fd_sc_hd__mux2_1
XFILLER_0_21_780 VGND VGND VPWR VPWR sky130_fd_sc_hd__fill_1
XTAP_953 VGND VPWR sky130_fd_sc_hd__tapvpwrvgnd_1
XTAP_942 VGND VPWR sky130_fd_sc_hd__tapvpwrvgnd_1
XTAP_920 VGND VPWR sky130_fd_sc_hd__tapvpwrvgnd_1
XTAP_931 VGND VPWR sky130_fd_sc_hd__tapvpwrvgnd_1
X_09891_ cpuregs\[14\]\[9\] cpuregs\[15\]\[9\] _03801_ VGND VGND VPWR VPWR _04118_
+ sky130_fd_sc_hd__mux2_1
X_08842_ _03181_ VGND VGND VPWR VPWR _03193_ sky130_fd_sc_hd__inv_2
XTAP_975 VGND VPWR sky130_fd_sc_hd__tapvpwrvgnd_1
XTAP_986 VGND VPWR sky130_fd_sc_hd__tapvpwrvgnd_1
XTAP_964 VGND VPWR sky130_fd_sc_hd__tapvpwrvgnd_1
Xhold1304 count_cycle\[7\] VGND VGND VPWR VPWR net1662 sky130_fd_sc_hd__dlygate4sd3_1
X_08773_ _02567_ _03129_ VGND VGND VPWR VPWR _03130_ sky130_fd_sc_hd__nand2_1
XTAP_997 VGND VPWR sky130_fd_sc_hd__tapvpwrvgnd_1
X_07724_ net394 VGND VGND VPWR VPWR _00003_ sky130_fd_sc_hd__clkbuf_1
X_07655_ _02084_ VGND VGND VPWR VPWR _02085_ sky130_fd_sc_hd__buf_4
X_09325_ reg_pc\[20\] _03568_ VGND VGND VPWR VPWR _03573_ sky130_fd_sc_hd__and2_1
XFILLER_0_47_165 VGND VGND VPWR VPWR sky130_fd_sc_hd__decap_3
XFILLER_0_36_817 VGND VGND VPWR VPWR sky130_fd_sc_hd__fill_1
XFILLER_0_62_102 VGND VGND VPWR VPWR sky130_fd_sc_hd__fill_1
X_09256_ _03513_ VGND VGND VPWR VPWR _00047_ sky130_fd_sc_hd__clkbuf_1
X_08207_ _02221_ _02465_ _02592_ _02160_ _02593_ VGND VGND VPWR VPWR _02594_ sky130_fd_sc_hd__a32o_1
XFILLER_0_121_708 VGND VGND VPWR VPWR sky130_fd_sc_hd__decap_4
XFILLER_0_105_259 VGND VGND VPWR VPWR sky130_fd_sc_hd__fill_2
XFILLER_0_62_179 VGND VGND VPWR VPWR sky130_fd_sc_hd__decap_3
X_09187_ reg_pc\[2\] VGND VGND VPWR VPWR _03453_ sky130_fd_sc_hd__inv_2
XFILLER_0_120_207 VGND VGND VPWR VPWR sky130_fd_sc_hd__decap_3
X_08138_ reg_pc\[22\] decoded_imm\[22\] VGND VGND VPWR VPWR _02529_ sky130_fd_sc_hd__or2_1
XFILLER_0_113_281 VPWR VGND VPWR VGND sky130_ef_sc_hd__decap_12
X_08069_ _02432_ VGND VGND VPWR VPWR _02465_ sky130_fd_sc_hd__buf_2
X_10100_ reg_pc\[14\] _03776_ _04315_ _04321_ _03946_ VGND VGND VPWR VPWR _04322_
+ sky130_fd_sc_hd__a221o_1
X_11080_ net1272 _03440_ _05124_ VGND VGND VPWR VPWR _05125_ sky130_fd_sc_hd__mux2_1
X_10031_ _03862_ _04234_ _04254_ VGND VGND VPWR VPWR _04255_ sky130_fd_sc_hd__o21a_1
X_14770_ net896 _05159_ _01756_ VGND VGND VPWR VPWR _01757_ sky130_fd_sc_hd__mux2_1
X_13721_ _06348_ _07189_ _07191_ _06417_ VGND VGND VPWR VPWR _07192_ sky130_fd_sc_hd__a211o_1
X_11982_ _05654_ _05620_ _05655_ VGND VGND VPWR VPWR _05656_ sky130_fd_sc_hd__and3b_1
X_10933_ _03634_ VGND VGND VPWR VPWR _05045_ sky130_fd_sc_hd__clkbuf_4
XFILLER_0_79_780 VGND VGND VPWR VPWR sky130_fd_sc_hd__decap_4
X_13652_ cpuregs\[0\]\[26\] cpuregs\[1\]\[26\] cpuregs\[2\]\[26\] cpuregs\[3\]\[26\]
+ _06344_ _06345_ VGND VGND VPWR VPWR _07125_ sky130_fd_sc_hd__mux4_1
X_16440_ clknet_leaf_10_clk _01022_ VGND VGND VPWR VPWR decoded_imm\[7\] sky130_fd_sc_hd__dfxtp_2
X_10864_ _04998_ VGND VGND VPWR VPWR _00170_ sky130_fd_sc_hd__clkbuf_1
XPHY_252 VGND VGND VPWR VPWR sky130_fd_sc_hd__decap_3
XPHY_241 VGND VGND VPWR VPWR sky130_fd_sc_hd__decap_3
XPHY_230 VGND VGND VPWR VPWR sky130_fd_sc_hd__decap_3
X_13583_ cpuregs\[8\]\[24\] cpuregs\[9\]\[24\] _06764_ VGND VGND VPWR VPWR _07058_
+ sky130_fd_sc_hd__mux2_1
XFILLER_0_94_750 VGND VGND VPWR VPWR sky130_fd_sc_hd__decap_6
X_10795_ net966 _03511_ _04957_ VGND VGND VPWR VPWR _04958_ sky130_fd_sc_hd__mux2_1
X_12603_ net550 _06170_ VGND VGND VPWR VPWR _00737_ sky130_fd_sc_hd__nor2_1
X_16371_ clknet_leaf_6_clk _00953_ VGND VGND VPWR VPWR mem_state\[0\] sky130_fd_sc_hd__dfxtp_1
XPHY_274 VGND VGND VPWR VPWR sky130_fd_sc_hd__decap_3
XPHY_263 VGND VGND VPWR VPWR sky130_fd_sc_hd__decap_3
X_12534_ _06121_ VGND VGND VPWR VPWR _00717_ sky130_fd_sc_hd__clkbuf_1
X_15322_ _02047_ VGND VGND VPWR VPWR _01514_ sky130_fd_sc_hd__clkbuf_1
XFILLER_0_109_598 VGND VGND VPWR VPWR sky130_fd_sc_hd__fill_1
XFILLER_0_81_455 VGND VGND VPWR VPWR sky130_fd_sc_hd__fill_1
XFILLER_0_54_658 VGND VGND VPWR VPWR sky130_fd_sc_hd__decap_4
X_12465_ _05755_ _06062_ _05791_ VGND VGND VPWR VPWR _06067_ sky130_fd_sc_hd__a21o_1
XFILLER_0_112_708 VGND VGND VPWR VPWR sky130_fd_sc_hd__fill_1
X_15253_ net501 VGND VGND VPWR VPWR _02012_ sky130_fd_sc_hd__clkbuf_1
XFILLER_0_34_371 VGND VGND VPWR VPWR sky130_fd_sc_hd__fill_1
X_12396_ _05981_ VGND VGND VPWR VPWR _06004_ sky130_fd_sc_hd__clkbuf_4
X_11416_ _05318_ VGND VGND VPWR VPWR _00402_ sky130_fd_sc_hd__clkbuf_1
X_14204_ _07526_ VGND VGND VPWR VPWR _00961_ sky130_fd_sc_hd__clkbuf_1
X_15184_ _01976_ VGND VGND VPWR VPWR _01447_ sky130_fd_sc_hd__clkbuf_1
X_14135_ _07487_ VGND VGND VPWR VPWR _00931_ sky130_fd_sc_hd__clkbuf_1
X_11347_ _05014_ net1458 _05277_ VGND VGND VPWR VPWR _05282_ sky130_fd_sc_hd__mux2_1
X_11278_ net998 _05190_ _05240_ VGND VGND VPWR VPWR _05245_ sky130_fd_sc_hd__mux2_1
X_14066_ _07449_ VGND VGND VPWR VPWR _01104_ sky130_fd_sc_hd__clkbuf_1
X_10229_ _02468_ _02493_ _03651_ VGND VGND VPWR VPWR _04447_ sky130_fd_sc_hd__mux2_1
X_13017_ _06431_ _06508_ VGND VGND VPWR VPWR _06509_ sky130_fd_sc_hd__and2_1
XFILLER_0_55_67 VGND VGND VPWR VPWR sky130_fd_sc_hd__fill_1
X_16707_ clknet_leaf_74_clk _01274_ VGND VGND VPWR VPWR cpuregs\[3\]\[21\] sky130_fd_sc_hd__dfxtp_1
X_14968_ _01861_ VGND VGND VPWR VPWR _01346_ sky130_fd_sc_hd__clkbuf_1
XFILLER_0_89_544 VGND VGND VPWR VPWR sky130_fd_sc_hd__fill_1
XFILLER_0_12_9 VPWR VGND VPWR VGND sky130_ef_sc_hd__decap_12
X_14899_ _03635_ net1306 _01815_ VGND VGND VPWR VPWR _01825_ sky130_fd_sc_hd__mux2_1
XFILLER_0_89_577 VGND VGND VPWR VPWR sky130_fd_sc_hd__fill_1
X_13919_ _07326_ VGND VGND VPWR VPWR _07359_ sky130_fd_sc_hd__clkbuf_4
X_16638_ clknet_leaf_54_clk _01205_ VGND VGND VPWR VPWR cpuregs\[23\]\[16\] sky130_fd_sc_hd__dfxtp_1
XFILLER_0_29_121 VGND VGND VPWR VPWR sky130_fd_sc_hd__decap_6
X_16569_ clknet_leaf_64_clk _01146_ VGND VGND VPWR VPWR cpuregs\[24\]\[21\] sky130_fd_sc_hd__dfxtp_1
XFILLER_0_128_830 VGND VGND VPWR VPWR sky130_fd_sc_hd__fill_2
XFILLER_0_85_783 VGND VGND VPWR VPWR sky130_fd_sc_hd__fill_1
XFILLER_0_84_260 VGND VGND VPWR VPWR sky130_fd_sc_hd__fill_2
XFILLER_0_45_625 VGND VGND VPWR VPWR sky130_fd_sc_hd__fill_2
XFILLER_0_44_113 VGND VGND VPWR VPWR sky130_fd_sc_hd__decap_8
X_09110_ _03335_ _03379_ _03383_ _03389_ _03357_ VGND VGND VPWR VPWR _03390_ sky130_fd_sc_hd__a311o_1
XFILLER_0_29_165 VGND VGND VPWR VPWR sky130_fd_sc_hd__decap_3
XFILLER_0_29_176 VGND VGND VPWR VPWR sky130_fd_sc_hd__decap_6
XFILLER_0_29_187 VGND VGND VPWR VPWR sky130_fd_sc_hd__fill_1
X_09041_ _00007_ VGND VGND VPWR VPWR _03322_ sky130_fd_sc_hd__buf_6
XFILLER_0_60_617 VGND VGND VPWR VPWR sky130_fd_sc_hd__fill_1
Xhold401 cpuregs\[24\]\[25\] VGND VGND VPWR VPWR net759 sky130_fd_sc_hd__dlygate4sd3_1
XFILLER_0_111_72 VPWR VGND VPWR VGND sky130_ef_sc_hd__decap_12
Xhold434 cpuregs\[19\]\[23\] VGND VGND VPWR VPWR net792 sky130_fd_sc_hd__dlygate4sd3_1
Xhold445 cpuregs\[23\]\[26\] VGND VGND VPWR VPWR net803 sky130_fd_sc_hd__dlygate4sd3_1
Xhold412 cpuregs\[19\]\[18\] VGND VGND VPWR VPWR net770 sky130_fd_sc_hd__dlygate4sd3_1
Xhold423 cpuregs\[2\]\[1\] VGND VGND VPWR VPWR net781 sky130_fd_sc_hd__dlygate4sd3_1
XFILLER_0_20_92 VGND VGND VPWR VPWR sky130_fd_sc_hd__decap_3
Xhold467 cpuregs\[20\]\[14\] VGND VGND VPWR VPWR net825 sky130_fd_sc_hd__dlygate4sd3_1
Xhold478 cpuregs\[12\]\[9\] VGND VGND VPWR VPWR net836 sky130_fd_sc_hd__dlygate4sd3_1
Xhold456 cpuregs\[28\]\[2\] VGND VGND VPWR VPWR net814 sky130_fd_sc_hd__dlygate4sd3_1
XFILLER_0_111_785 VGND VGND VPWR VPWR sky130_fd_sc_hd__fill_1
XFILLER_0_110_251 VGND VGND VPWR VPWR sky130_fd_sc_hd__fill_1
XFILLER_0_96_85 VGND VGND VPWR VPWR sky130_fd_sc_hd__fill_1
X_09943_ _03663_ _04164_ _04168_ _03685_ VGND VGND VPWR VPWR _04169_ sky130_fd_sc_hd__o211a_1
XFILLER_0_0_460 VGND VGND VPWR VPWR sky130_fd_sc_hd__fill_2
Xhold489 cpuregs\[31\]\[2\] VGND VGND VPWR VPWR net847 sky130_fd_sc_hd__dlygate4sd3_1
X_09874_ cpuregs\[16\]\[8\] cpuregs\[17\]\[8\] cpuregs\[18\]\[8\] cpuregs\[19\]\[8\]
+ _03941_ _04028_ VGND VGND VPWR VPWR _04102_ sky130_fd_sc_hd__mux4_1
XTAP_750 VGND VPWR sky130_fd_sc_hd__tapvpwrvgnd_1
XTAP_761 VGND VPWR sky130_fd_sc_hd__tapvpwrvgnd_1
X_08825_ _02735_ _02986_ _03176_ VGND VGND VPWR VPWR _03177_ sky130_fd_sc_hd__a21o_1
Xhold1101 cpuregs\[29\]\[21\] VGND VGND VPWR VPWR net1459 sky130_fd_sc_hd__dlygate4sd3_1
Xhold1112 cpuregs\[8\]\[16\] VGND VGND VPWR VPWR net1470 sky130_fd_sc_hd__dlygate4sd3_1
Xhold1123 cpuregs\[8\]\[4\] VGND VGND VPWR VPWR net1481 sky130_fd_sc_hd__dlygate4sd3_1
XTAP_772 VGND VPWR sky130_fd_sc_hd__tapvpwrvgnd_1
XTAP_794 VGND VPWR sky130_fd_sc_hd__tapvpwrvgnd_1
XTAP_783 VGND VPWR sky130_fd_sc_hd__tapvpwrvgnd_1
Xhold1134 cpuregs\[16\]\[6\] VGND VGND VPWR VPWR net1492 sky130_fd_sc_hd__dlygate4sd3_1
Xhold1167 cpuregs\[1\]\[0\] VGND VGND VPWR VPWR net1525 sky130_fd_sc_hd__dlygate4sd3_1
Xhold1145 cpuregs\[29\]\[8\] VGND VGND VPWR VPWR net1503 sky130_fd_sc_hd__dlygate4sd3_1
Xhold1156 mem_rdata_q\[1\] VGND VGND VPWR VPWR net1514 sky130_fd_sc_hd__dlygate4sd3_1
X_08756_ _03002_ _03015_ _03016_ VGND VGND VPWR VPWR _03113_ sky130_fd_sc_hd__o21ai_1
Xhold1189 cpuregs\[3\]\[30\] VGND VGND VPWR VPWR net1547 sky130_fd_sc_hd__dlygate4sd3_1
Xhold1178 cpuregs\[21\]\[11\] VGND VGND VPWR VPWR net1536 sky130_fd_sc_hd__dlygate4sd3_1
XTAP_1916 VGND VPWR sky130_fd_sc_hd__tapvpwrvgnd_1
XTAP_1905 VGND VPWR sky130_fd_sc_hd__tapvpwrvgnd_1
XFILLER_0_95_514 VGND VGND VPWR VPWR sky130_fd_sc_hd__fill_1
X_08687_ _02480_ net246 _02879_ VGND VGND VPWR VPWR _03050_ sky130_fd_sc_hd__a21oi_1
XFILLER_0_67_205 VGND VGND VPWR VPWR sky130_fd_sc_hd__fill_2
X_07707_ mem_wordsize\[2\] VGND VGND VPWR VPWR _02133_ sky130_fd_sc_hd__clkbuf_4
XFILLER_0_138_605 VGND VGND VPWR VPWR sky130_fd_sc_hd__fill_2
XTAP_1949 VGND VPWR sky130_fd_sc_hd__tapvpwrvgnd_1
XTAP_1927 VGND VPWR sky130_fd_sc_hd__tapvpwrvgnd_1
XTAP_1938 VGND VPWR sky130_fd_sc_hd__tapvpwrvgnd_1
X_09308_ net899 _03558_ _03512_ VGND VGND VPWR VPWR _03559_ sky130_fd_sc_hd__mux2_1
XFILLER_0_63_422 VGND VGND VPWR VPWR sky130_fd_sc_hd__decap_3
XFILLER_0_36_636 VGND VGND VPWR VPWR sky130_fd_sc_hd__fill_2
XFILLER_0_134_811 VGND VGND VPWR VPWR sky130_fd_sc_hd__fill_1
X_10580_ _02567_ _03652_ _03653_ VGND VGND VPWR VPWR _04788_ sky130_fd_sc_hd__o21ai_1
XFILLER_0_8_582 VGND VGND VPWR VPWR sky130_fd_sc_hd__decap_6
XFILLER_0_23_308 VGND VGND VPWR VPWR sky130_fd_sc_hd__decap_8
X_09239_ net890 _03498_ _03446_ VGND VGND VPWR VPWR _03499_ sky130_fd_sc_hd__mux2_1
XFILLER_0_133_354 VGND VGND VPWR VPWR sky130_fd_sc_hd__fill_1
X_12250_ decoded_imm_j\[10\] _05712_ VGND VGND VPWR VPWR _05870_ sky130_fd_sc_hd__nand2_1
XFILLER_0_16_371 VGND VGND VPWR VPWR sky130_fd_sc_hd__fill_1
X_11201_ net774 _05196_ _05182_ VGND VGND VPWR VPWR _05197_ sky130_fd_sc_hd__mux2_1
X_12181_ decoded_imm_j\[5\] _05702_ VGND VGND VPWR VPWR _05806_ sky130_fd_sc_hd__nand2_1
X_11132_ net1343 _03610_ _05146_ VGND VGND VPWR VPWR _05152_ sky130_fd_sc_hd__mux2_1
Xhold990 cpuregs\[9\]\[29\] VGND VGND VPWR VPWR net1348 sky130_fd_sc_hd__dlygate4sd3_1
X_11063_ _05115_ VGND VGND VPWR VPWR _00252_ sky130_fd_sc_hd__clkbuf_1
X_15940_ clknet_leaf_145_clk _00590_ VGND VGND VPWR VPWR count_instr\[9\] sky130_fd_sc_hd__dfxtp_1
X_10014_ _03901_ _04237_ _03870_ VGND VGND VPWR VPWR _04238_ sky130_fd_sc_hd__a21o_1
X_15871_ clknet_leaf_142_clk _00521_ VGND VGND VPWR VPWR cpuregs\[20\]\[5\] sky130_fd_sc_hd__dfxtp_1
X_14822_ net828 _05213_ _01778_ VGND VGND VPWR VPWR _01784_ sky130_fd_sc_hd__mux2_1
X_14753_ _01747_ VGND VGND VPWR VPWR _01245_ sky130_fd_sc_hd__clkbuf_1
XFILLER_0_98_374 VGND VGND VPWR VPWR sky130_fd_sc_hd__decap_6
XFILLER_0_98_363 VGND VGND VPWR VPWR sky130_fd_sc_hd__fill_1
XFILLER_0_58_205 VPWR VGND VPWR VGND sky130_ef_sc_hd__decap_12
X_11965_ _05642_ _05620_ _05643_ VGND VGND VPWR VPWR _05644_ sky130_fd_sc_hd__and3b_1
X_13704_ cpuregs\[10\]\[28\] cpuregs\[11\]\[28\] _03347_ VGND VGND VPWR VPWR _07175_
+ sky130_fd_sc_hd__mux2_1
X_10916_ _05033_ net1168 _05027_ VGND VGND VPWR VPWR _05034_ sky130_fd_sc_hd__mux2_1
X_14684_ net760 _05211_ _01706_ VGND VGND VPWR VPWR _01711_ sky130_fd_sc_hd__mux2_1
XFILLER_0_58_249 VGND VGND VPWR VPWR sky130_fd_sc_hd__decap_3
XFILLER_0_132_27 VGND VGND VPWR VPWR sky130_fd_sc_hd__fill_1
X_13635_ _06387_ _07108_ VGND VGND VPWR VPWR _07109_ sky130_fd_sc_hd__and2_1
X_16423_ clknet_leaf_25_clk net1631 VGND VGND VPWR VPWR decoded_imm\[24\] sky130_fd_sc_hd__dfxtp_4
X_11896_ _05593_ VGND VGND VPWR VPWR _00607_ sky130_fd_sc_hd__clkbuf_1
XFILLER_0_132_38 VPWR VGND VPWR VGND sky130_ef_sc_hd__decap_12
X_10847_ _03450_ VGND VGND VPWR VPWR _04987_ sky130_fd_sc_hd__clkbuf_4
XFILLER_0_137_682 VGND VGND VPWR VPWR sky130_fd_sc_hd__fill_1
XFILLER_0_137_671 VGND VGND VPWR VPWR sky130_fd_sc_hd__fill_1
X_13566_ cpuregs\[16\]\[23\] cpuregs\[17\]\[23\] cpuregs\[18\]\[23\] cpuregs\[19\]\[23\]
+ _06945_ _06979_ VGND VGND VPWR VPWR _07042_ sky130_fd_sc_hd__mux4_1
X_16354_ clknet_leaf_94_clk _00936_ VGND VGND VPWR VPWR cpuregs\[1\]\[19\] sky130_fd_sc_hd__dfxtp_1
XFILLER_0_82_753 VGND VGND VPWR VPWR sky130_fd_sc_hd__decap_3
X_10778_ net642 _03456_ _04946_ VGND VGND VPWR VPWR _04949_ sky130_fd_sc_hd__mux2_1
XFILLER_0_136_192 VGND VGND VPWR VPWR sky130_fd_sc_hd__decap_4
X_13497_ cpuregs\[0\]\[21\] cpuregs\[1\]\[21\] cpuregs\[2\]\[21\] cpuregs\[3\]\[21\]
+ _06740_ _06708_ VGND VGND VPWR VPWR _06975_ sky130_fd_sc_hd__mux4_1
X_15305_ net497 VGND VGND VPWR VPWR _02038_ sky130_fd_sc_hd__clkbuf_1
XFILLER_0_82_786 VGND VGND VPWR VPWR sky130_fd_sc_hd__fill_1
XFILLER_0_81_274 VGND VGND VPWR VPWR sky130_fd_sc_hd__decap_6
XFILLER_0_14_319 VGND VGND VPWR VPWR sky130_fd_sc_hd__decap_8
X_12517_ _06109_ VGND VGND VPWR VPWR _00712_ sky130_fd_sc_hd__clkbuf_1
X_16285_ clknet_leaf_149_clk _00870_ VGND VGND VPWR VPWR instr_add sky130_fd_sc_hd__dfxtp_1
XFILLER_0_124_365 VGND VGND VPWR VPWR sky130_fd_sc_hd__fill_2
X_12448_ _05811_ _06049_ _06050_ _06051_ VGND VGND VPWR VPWR _06052_ sky130_fd_sc_hd__a22o_1
X_15236_ _02003_ VGND VGND VPWR VPWR _01472_ sky130_fd_sc_hd__clkbuf_1
XFILLER_0_124_387 VGND VGND VPWR VPWR sky130_fd_sc_hd__fill_2
X_15167_ net1165 _03621_ _01959_ VGND VGND VPWR VPWR _01967_ sky130_fd_sc_hd__mux2_1
X_12379_ _05687_ _05987_ _05988_ _05768_ VGND VGND VPWR VPWR _00695_ sky130_fd_sc_hd__o211a_1
XFILLER_0_2_769 VPWR VGND VPWR VGND sky130_ef_sc_hd__decap_12
XFILLER_0_22_363 VGND VGND VPWR VPWR sky130_fd_sc_hd__fill_1
X_15098_ _01930_ VGND VGND VPWR VPWR _01407_ sky130_fd_sc_hd__clkbuf_1
X_14118_ _07478_ VGND VGND VPWR VPWR _00923_ sky130_fd_sc_hd__clkbuf_1
X_14049_ mem_rdata_q\[7\] net30 _07422_ VGND VGND VPWR VPWR _07441_ sky130_fd_sc_hd__mux2_1
X_08610_ _02940_ _02949_ _02978_ VGND VGND VPWR VPWR _02979_ sky130_fd_sc_hd__nor3_1
X_09590_ _00012_ VGND VGND VPWR VPWR _03824_ sky130_fd_sc_hd__buf_8
X_08541_ _02310_ _02664_ _02915_ VGND VGND VPWR VPWR _02916_ sky130_fd_sc_hd__and3_1
XFILLER_0_77_558 VGND VGND VPWR VPWR sky130_fd_sc_hd__fill_2
XFILLER_0_77_525 VGND VGND VPWR VPWR sky130_fd_sc_hd__decap_6
X_08472_ _02850_ net97 _02748_ VGND VGND VPWR VPWR _02852_ sky130_fd_sc_hd__and3_1
XFILLER_0_17_102 VGND VGND VPWR VPWR sky130_fd_sc_hd__decap_4
XFILLER_0_127_181 VGND VGND VPWR VPWR sky130_fd_sc_hd__fill_1
XFILLER_0_93_3 VGND VGND VPWR VPWR sky130_fd_sc_hd__decap_3
XFILLER_0_17_157 VGND VGND VPWR VPWR sky130_fd_sc_hd__decap_6
XFILLER_0_33_617 VGND VGND VPWR VPWR sky130_fd_sc_hd__fill_1
X_09024_ _02149_ _02836_ VGND VGND VPWR VPWR _03306_ sky130_fd_sc_hd__nand2_1
Xhold220 count_cycle\[14\] VGND VGND VPWR VPWR net578 sky130_fd_sc_hd__dlygate4sd3_1
Xhold253 cpuregs\[27\]\[28\] VGND VGND VPWR VPWR net611 sky130_fd_sc_hd__dlygate4sd3_1
Xhold231 cpuregs\[27\]\[26\] VGND VGND VPWR VPWR net589 sky130_fd_sc_hd__dlygate4sd3_1
Xhold242 cpuregs\[28\]\[29\] VGND VGND VPWR VPWR net600 sky130_fd_sc_hd__dlygate4sd3_1
Xhold275 cpuregs\[28\]\[25\] VGND VGND VPWR VPWR net633 sky130_fd_sc_hd__dlygate4sd3_1
Xhold286 cpuregs\[20\]\[25\] VGND VGND VPWR VPWR net644 sky130_fd_sc_hd__dlygate4sd3_1
Xhold264 cpuregs\[19\]\[30\] VGND VGND VPWR VPWR net622 sky130_fd_sc_hd__dlygate4sd3_1
XFILLER_0_1_780 VGND VGND VPWR VPWR sky130_fd_sc_hd__decap_4
XFILLER_0_40_182 VGND VGND VPWR VPWR sky130_fd_sc_hd__fill_1
Xhold297 cpuregs\[15\]\[30\] VGND VGND VPWR VPWR net655 sky130_fd_sc_hd__dlygate4sd3_1
X_09926_ decoded_imm\[10\] net172 VGND VGND VPWR VPWR _04152_ sky130_fd_sc_hd__or2_1
XFILLER_0_0_290 VGND VGND VPWR VPWR sky130_fd_sc_hd__fill_2
XTAP_591 VGND VPWR sky130_fd_sc_hd__tapvpwrvgnd_1
XTAP_580 VGND VPWR sky130_fd_sc_hd__tapvpwrvgnd_1
X_09857_ cpuregs\[14\]\[8\] cpuregs\[15\]\[8\] _03898_ VGND VGND VPWR VPWR _04085_
+ sky130_fd_sc_hd__mux2_1
X_08808_ _03160_ _03161_ VGND VGND VPWR VPWR _03162_ sky130_fd_sc_hd__or2b_1
X_09788_ cpuregs\[2\]\[6\] cpuregs\[3\]\[6\] _03977_ VGND VGND VPWR VPWR _04018_ sky130_fd_sc_hd__mux2_1
X_08739_ _02536_ net217 _02915_ _02840_ VGND VGND VPWR VPWR _03098_ sky130_fd_sc_hd__a31o_1
XANTENNA_104 net192 VGND VGND VPWR VPWR sky130_fd_sc_hd__diode_2
XANTENNA_115 clknet_0_clk VGND VGND VPWR VPWR sky130_fd_sc_hd__diode_2
XANTENNA_126 _04742_ VGND VGND VPWR VPWR sky130_fd_sc_hd__diode_2
XTAP_1724 VGND VPWR sky130_fd_sc_hd__tapvpwrvgnd_1
XTAP_1713 VGND VPWR sky130_fd_sc_hd__tapvpwrvgnd_1
XTAP_1702 VGND VPWR sky130_fd_sc_hd__tapvpwrvgnd_1
XFILLER_0_95_311 VGND VGND VPWR VPWR sky130_fd_sc_hd__fill_2
X_11750_ _05008_ net1022 _05494_ VGND VGND VPWR VPWR _05496_ sky130_fd_sc_hd__mux2_1
XANTENNA_137 net77 VGND VGND VPWR VPWR sky130_fd_sc_hd__diode_2
XANTENNA_148 net177 VGND VGND VPWR VPWR sky130_fd_sc_hd__diode_2
XTAP_1757 VGND VPWR sky130_fd_sc_hd__tapvpwrvgnd_1
XTAP_1735 VGND VPWR sky130_fd_sc_hd__tapvpwrvgnd_1
XTAP_1746 VGND VPWR sky130_fd_sc_hd__tapvpwrvgnd_1
XANTENNA_159 net120 VGND VGND VPWR VPWR sky130_fd_sc_hd__diode_2
X_10701_ _04903_ _04905_ VGND VGND VPWR VPWR _04906_ sky130_fd_sc_hd__nor2_4
XTAP_1779 VGND VPWR sky130_fd_sc_hd__tapvpwrvgnd_1
XTAP_1768 VGND VPWR sky130_fd_sc_hd__tapvpwrvgnd_1
XFILLER_0_95_399 VGND VGND VPWR VPWR sky130_fd_sc_hd__fill_1
XFILLER_0_83_539 VGND VGND VPWR VPWR sky130_fd_sc_hd__decap_6
X_11681_ _05459_ VGND VGND VPWR VPWR _00526_ sky130_fd_sc_hd__clkbuf_1
XFILLER_0_48_271 VGND VGND VPWR VPWR sky130_fd_sc_hd__decap_4
XFILLER_0_119_682 VGND VGND VPWR VPWR sky130_fd_sc_hd__fill_1
X_10632_ cpuregs\[8\]\[29\] cpuregs\[9\]\[29\] cpuregs\[10\]\[29\] cpuregs\[11\]\[29\]
+ _03798_ _03811_ VGND VGND VPWR VPWR _04839_ sky130_fd_sc_hd__mux4_1
X_13420_ cpuregs\[12\]\[19\] cpuregs\[13\]\[19\] cpuregs\[14\]\[19\] cpuregs\[15\]\[19\]
+ _06696_ _06728_ VGND VGND VPWR VPWR _06900_ sky130_fd_sc_hd__mux4_1
X_10563_ cpuregs\[20\]\[27\] cpuregs\[21\]\[27\] _03767_ VGND VGND VPWR VPWR _04772_
+ sky130_fd_sc_hd__mux2_1
X_13351_ _06833_ VGND VGND VPWR VPWR _00822_ sky130_fd_sc_hd__clkbuf_1
XFILLER_0_91_572 VGND VGND VPWR VPWR sky130_fd_sc_hd__decap_3
XFILLER_0_106_365 VGND VGND VPWR VPWR sky130_fd_sc_hd__fill_2
X_12302_ _05899_ _05909_ VGND VGND VPWR VPWR _05918_ sky130_fd_sc_hd__nand2_1
XFILLER_0_51_447 VGND VGND VPWR VPWR sky130_fd_sc_hd__fill_1
X_16070_ clknet_leaf_151_clk _00720_ VGND VGND VPWR VPWR count_cycle\[13\] sky130_fd_sc_hd__dfxtp_1
X_10494_ cpuregs\[22\]\[25\] cpuregs\[23\]\[25\] _03755_ VGND VGND VPWR VPWR _04705_
+ sky130_fd_sc_hd__mux2_1
X_15021_ _03591_ net660 _01887_ VGND VGND VPWR VPWR _01890_ sky130_fd_sc_hd__mux2_1
XFILLER_0_106_376 VGND VGND VPWR VPWR sky130_fd_sc_hd__decap_3
X_13282_ _03312_ VGND VGND VPWR VPWR _06766_ sky130_fd_sc_hd__buf_4
XFILLER_0_16_190 VGND VGND VPWR VPWR sky130_fd_sc_hd__decap_6
XFILLER_0_133_195 VGND VGND VPWR VPWR sky130_fd_sc_hd__decap_6
X_12233_ decoded_imm_j\[7\] _05706_ _05839_ _05841_ VGND VGND VPWR VPWR _05854_ sky130_fd_sc_hd__a31oi_1
X_12164_ _05785_ VGND VGND VPWR VPWR _05790_ sky130_fd_sc_hd__clkbuf_4
XFILLER_0_31_182 VGND VGND VPWR VPWR sky130_fd_sc_hd__decap_8
X_16972_ clknet_leaf_71_clk _01536_ VGND VGND VPWR VPWR cpuregs\[10\]\[27\] sky130_fd_sc_hd__dfxtp_1
X_12095_ _03575_ reg_next_pc\[20\] _03223_ VGND VGND VPWR VPWR _05736_ sky130_fd_sc_hd__mux2_2
X_11115_ net1506 _03558_ _05135_ VGND VGND VPWR VPWR _05143_ sky130_fd_sc_hd__mux2_1
X_15923_ clknet_leaf_64_clk _00573_ VGND VGND VPWR VPWR cpuregs\[17\]\[25\] sky130_fd_sc_hd__dfxtp_1
X_11046_ _05106_ VGND VGND VPWR VPWR _00244_ sky130_fd_sc_hd__clkbuf_1
X_15854_ clknet_leaf_49_clk _00504_ VGND VGND VPWR VPWR cpuregs\[25\]\[20\] sky130_fd_sc_hd__dfxtp_1
XFILLER_0_87_823 VGND VGND VPWR VPWR sky130_fd_sc_hd__fill_1
X_15785_ clknet_leaf_55_clk _00435_ VGND VGND VPWR VPWR cpuregs\[26\]\[15\] sky130_fd_sc_hd__dfxtp_1
X_14805_ net893 _05196_ _01767_ VGND VGND VPWR VPWR _01775_ sky130_fd_sc_hd__mux2_1
XFILLER_0_98_182 VGND VGND VPWR VPWR sky130_fd_sc_hd__fill_2
X_14736_ _01738_ VGND VGND VPWR VPWR _01237_ sky130_fd_sc_hd__clkbuf_1
X_12997_ cpuregs\[22\]\[6\] cpuregs\[23\]\[6\] _06450_ VGND VGND VPWR VPWR _06490_
+ sky130_fd_sc_hd__mux2_1
XFILLER_0_52_46 VGND VGND VPWR VPWR sky130_fd_sc_hd__fill_1
X_11948_ _02085_ VGND VGND VPWR VPWR _05631_ sky130_fd_sc_hd__buf_4
X_14667_ net780 _05194_ _01695_ VGND VGND VPWR VPWR _01702_ sky130_fd_sc_hd__mux2_1
X_11879_ count_instr\[22\] count_instr\[21\] net378 VGND VGND VPWR VPWR _05581_ sky130_fd_sc_hd__and3_1
X_13618_ cpuregs\[4\]\[25\] cpuregs\[5\]\[25\] _06906_ VGND VGND VPWR VPWR _07092_
+ sky130_fd_sc_hd__mux2_1
X_14598_ _01665_ VGND VGND VPWR VPWR _01172_ sky130_fd_sc_hd__clkbuf_1
X_16406_ clknet_leaf_17_clk _00988_ VGND VGND VPWR VPWR net168 sky130_fd_sc_hd__dfxtp_2
X_13549_ _07025_ net217 _06960_ VGND VGND VPWR VPWR _07026_ sky130_fd_sc_hd__mux2_1
XFILLER_0_109_192 VGND VGND VPWR VPWR sky130_fd_sc_hd__decap_4
XFILLER_0_109_181 VGND VGND VPWR VPWR sky130_fd_sc_hd__decap_4
XFILLER_0_27_477 VGND VGND VPWR VPWR sky130_fd_sc_hd__fill_2
X_16337_ clknet_leaf_112_clk _00919_ VGND VGND VPWR VPWR cpuregs\[1\]\[2\] sky130_fd_sc_hd__dfxtp_1
XFILLER_0_124_173 VGND VGND VPWR VPWR sky130_fd_sc_hd__decap_3
XFILLER_0_112_302 VGND VGND VPWR VPWR sky130_fd_sc_hd__decap_6
X_16268_ clknet_leaf_6_clk _00853_ VGND VGND VPWR VPWR instr_jalr sky130_fd_sc_hd__dfxtp_2
X_15219_ _01994_ VGND VGND VPWR VPWR _01464_ sky130_fd_sc_hd__clkbuf_1
X_16199_ clknet_leaf_137_clk _00816_ VGND VGND VPWR VPWR net204 sky130_fd_sc_hd__dfxtp_2
XFILLER_0_140_699 VGND VGND VPWR VPWR sky130_fd_sc_hd__fill_1
XFILLER_0_140_688 VGND VGND VPWR VPWR sky130_fd_sc_hd__fill_2
XFILLER_0_22_193 VGND VGND VPWR VPWR sky130_fd_sc_hd__decap_3
X_07972_ reg_pc\[11\] decoded_imm\[11\] VGND VGND VPWR VPWR _02374_ sky130_fd_sc_hd__nand2_1
X_09711_ cpuregs\[12\]\[4\] cpuregs\[13\]\[4\] cpuregs\[14\]\[4\] cpuregs\[15\]\[4\]
+ _03941_ _03942_ VGND VGND VPWR VPWR _03943_ sky130_fd_sc_hd__mux4_1
X_09642_ _03665_ VGND VGND VPWR VPWR _03875_ sky130_fd_sc_hd__buf_8
X_09573_ _03796_ _03800_ _03805_ _03806_ VGND VGND VPWR VPWR _03807_ sky130_fd_sc_hd__o211a_1
X_08524_ _02294_ _02899_ VGND VGND VPWR VPWR _02900_ sky130_fd_sc_hd__or2_1
XTAP_1009 VGND VPWR sky130_fd_sc_hd__tapvpwrvgnd_1
XFILLER_0_93_826 VGND VGND VPWR VPWR sky130_fd_sc_hd__fill_2
XFILLER_0_77_388 VGND VGND VPWR VPWR sky130_fd_sc_hd__decap_4
X_08455_ _02828_ _02832_ _02835_ VGND VGND VPWR VPWR _02836_ sky130_fd_sc_hd__or3b_2
XFILLER_0_135_427 VGND VGND VPWR VPWR sky130_fd_sc_hd__fill_2
X_08386_ _02468_ _02765_ _02766_ VGND VGND VPWR VPWR _02767_ sky130_fd_sc_hd__o21ai_1
XFILLER_0_92_347 VGND VGND VPWR VPWR sky130_fd_sc_hd__decap_4
XFILLER_0_9_165 VGND VGND VPWR VPWR sky130_fd_sc_hd__decap_3
XFILLER_0_18_477 VGND VGND VPWR VPWR sky130_fd_sc_hd__decap_4
XFILLER_0_116_674 VGND VGND VPWR VPWR sky130_fd_sc_hd__fill_1
XFILLER_0_115_140 VPWR VGND VPWR VGND sky130_ef_sc_hd__decap_12
XFILLER_0_130_110 VGND VGND VPWR VPWR sky130_fd_sc_hd__decap_6
XFILLER_0_33_458 VGND VGND VPWR VPWR sky130_fd_sc_hd__fill_2
XFILLER_0_115_195 VPWR VGND VPWR VGND sky130_ef_sc_hd__decap_12
X_09007_ _03297_ VGND VGND VPWR VPWR _00032_ sky130_fd_sc_hd__clkbuf_1
XFILLER_0_13_160 VGND VGND VPWR VPWR sky130_fd_sc_hd__fill_1
XFILLER_0_131_699 VGND VGND VPWR VPWR sky130_fd_sc_hd__fill_1
XFILLER_0_13_182 VGND VGND VPWR VPWR sky130_fd_sc_hd__fill_1
X_09909_ cpuregs\[20\]\[9\] cpuregs\[21\]\[9\] _03824_ VGND VGND VPWR VPWR _04136_
+ sky130_fd_sc_hd__mux2_1
X_12920_ _02171_ _03360_ VGND VGND VPWR VPWR _06414_ sky130_fd_sc_hd__and2_1
XTAP_2200 VGND VPWR sky130_fd_sc_hd__tapvpwrvgnd_1
X_12851_ cpuregs\[16\]\[0\] cpuregs\[17\]\[0\] _06349_ VGND VGND VPWR VPWR _06350_
+ sky130_fd_sc_hd__mux2_1
XTAP_2244 VGND VPWR sky130_fd_sc_hd__tapvpwrvgnd_1
XTAP_2222 VGND VPWR sky130_fd_sc_hd__tapvpwrvgnd_1
XTAP_2233 VGND VPWR sky130_fd_sc_hd__tapvpwrvgnd_1
XTAP_2211 VGND VPWR sky130_fd_sc_hd__tapvpwrvgnd_1
X_11802_ cpu_state\[1\] count_instr\[1\] count_instr\[0\] decoder_trigger VGND VGND
+ VPWR VPWR _05525_ sky130_fd_sc_hd__and4_2
XTAP_2277 VGND VPWR sky130_fd_sc_hd__tapvpwrvgnd_1
XTAP_2266 VGND VPWR sky130_fd_sc_hd__tapvpwrvgnd_1
XTAP_2255 VGND VPWR sky130_fd_sc_hd__tapvpwrvgnd_1
X_12782_ _06305_ VGND VGND VPWR VPWR _00781_ sky130_fd_sc_hd__clkbuf_1
X_15570_ clknet_leaf_59_clk _00220_ VGND VGND VPWR VPWR cpuregs\[2\]\[24\] sky130_fd_sc_hd__dfxtp_1
XFILLER_0_96_642 VGND VGND VPWR VPWR sky130_fd_sc_hd__fill_2
XTAP_1532 VGND VPWR sky130_fd_sc_hd__tapvpwrvgnd_1
XTAP_1521 VGND VPWR sky130_fd_sc_hd__tapvpwrvgnd_1
XTAP_1510 VGND VPWR sky130_fd_sc_hd__tapvpwrvgnd_1
XFILLER_0_138_232 VPWR VGND VPWR VGND sky130_ef_sc_hd__decap_12
XTAP_2299 VGND VPWR sky130_fd_sc_hd__tapvpwrvgnd_1
XTAP_2288 VGND VPWR sky130_fd_sc_hd__tapvpwrvgnd_1
XFILLER_0_113_29 VGND VGND VPWR VPWR sky130_fd_sc_hd__fill_2
XTAP_1576 VGND VPWR sky130_fd_sc_hd__tapvpwrvgnd_1
XTAP_1565 VGND VPWR sky130_fd_sc_hd__tapvpwrvgnd_1
XTAP_1554 VGND VPWR sky130_fd_sc_hd__tapvpwrvgnd_1
XTAP_1543 VGND VPWR sky130_fd_sc_hd__tapvpwrvgnd_1
X_14521_ net820 _05184_ _01623_ VGND VGND VPWR VPWR _01625_ sky130_fd_sc_hd__mux2_1
X_11733_ _04991_ net1512 _05483_ VGND VGND VPWR VPWR _05487_ sky130_fd_sc_hd__mux2_1
XPHY_50 VGND VGND VPWR VPWR sky130_fd_sc_hd__decap_3
XFILLER_0_28_208 VGND VGND VPWR VPWR sky130_fd_sc_hd__fill_1
XPHY_61 VGND VGND VPWR VPWR sky130_fd_sc_hd__decap_3
XPHY_72 VGND VGND VPWR VPWR sky130_fd_sc_hd__decap_3
XPHY_83 VGND VGND VPWR VPWR sky130_fd_sc_hd__decap_3
XTAP_1598 VGND VPWR sky130_fd_sc_hd__tapvpwrvgnd_1
XTAP_1587 VGND VPWR sky130_fd_sc_hd__tapvpwrvgnd_1
X_14452_ _01588_ VGND VGND VPWR VPWR _01071_ sky130_fd_sc_hd__clkbuf_1
XPHY_94 VGND VGND VPWR VPWR sky130_fd_sc_hd__decap_3
X_11664_ _05450_ VGND VGND VPWR VPWR _00518_ sky130_fd_sc_hd__clkbuf_1
X_10615_ _03929_ _04820_ _04822_ VGND VGND VPWR VPWR _04823_ sky130_fd_sc_hd__a21o_1
X_13403_ _06849_ _06883_ VGND VGND VPWR VPWR _06884_ sky130_fd_sc_hd__or2_1
XFILLER_0_52_701 VGND VGND VPWR VPWR sky130_fd_sc_hd__fill_2
X_14383_ _05005_ net954 _01551_ VGND VGND VPWR VPWR _01552_ sky130_fd_sc_hd__mux2_1
XFILLER_0_51_222 VGND VGND VPWR VPWR sky130_fd_sc_hd__fill_2
X_16122_ clknet_leaf_13_clk _07618_ VGND VGND VPWR VPWR reg_out\[0\] sky130_fd_sc_hd__dfxtp_1
X_11595_ _04989_ net932 _05411_ VGND VGND VPWR VPWR _05414_ sky130_fd_sc_hd__mux2_1
X_10546_ _04751_ _04752_ _04753_ VGND VGND VPWR VPWR _04755_ sky130_fd_sc_hd__nand3_1
X_13334_ _06638_ _06812_ _06814_ _06739_ _06816_ VGND VGND VPWR VPWR _06817_ sky130_fd_sc_hd__o311a_1
XFILLER_0_51_233 VGND VGND VPWR VPWR sky130_fd_sc_hd__decap_6
XFILLER_0_12_609 VGND VGND VPWR VPWR sky130_fd_sc_hd__decap_4
X_16053_ clknet_leaf_37_clk _00703_ VGND VGND VPWR VPWR reg_next_pc\[28\] sky130_fd_sc_hd__dfxtp_1
X_10477_ _04669_ _04677_ VGND VGND VPWR VPWR _04688_ sky130_fd_sc_hd__nand2_1
X_13265_ _06447_ _06747_ _06749_ _06453_ VGND VGND VPWR VPWR _06750_ sky130_fd_sc_hd__a211o_1
XFILLER_0_122_699 VGND VGND VPWR VPWR sky130_fd_sc_hd__fill_1
X_15004_ _03538_ net933 _01876_ VGND VGND VPWR VPWR _01881_ sky130_fd_sc_hd__mux2_1
X_12216_ _05763_ net939 _05835_ _05838_ _05768_ VGND VGND VPWR VPWR _00682_ sky130_fd_sc_hd__o221a_1
X_13196_ cpuregs\[22\]\[12\] cpuregs\[23\]\[12\] _06450_ VGND VGND VPWR VPWR _06683_
+ sky130_fd_sc_hd__mux2_1
X_12147_ _05773_ _05693_ _05774_ _05686_ VGND VGND VPWR VPWR _05775_ sky130_fd_sc_hd__a211o_1
X_12078_ _05519_ _05723_ VGND VGND VPWR VPWR _05724_ sky130_fd_sc_hd__nand2_1
X_16955_ clknet_leaf_107_clk _01519_ VGND VGND VPWR VPWR cpuregs\[10\]\[10\] sky130_fd_sc_hd__dfxtp_1
X_15906_ clknet_leaf_145_clk _00556_ VGND VGND VPWR VPWR cpuregs\[17\]\[8\] sky130_fd_sc_hd__dfxtp_1
X_11029_ _05097_ VGND VGND VPWR VPWR _00236_ sky130_fd_sc_hd__clkbuf_1
X_16886_ clknet_leaf_112_clk _01450_ VGND VGND VPWR VPWR cpuregs\[8\]\[5\] sky130_fd_sc_hd__dfxtp_1
X_15837_ clknet_leaf_130_clk _00487_ VGND VGND VPWR VPWR cpuregs\[25\]\[3\] sky130_fd_sc_hd__dfxtp_1
X_15768_ clknet_leaf_92_clk _00418_ VGND VGND VPWR VPWR cpuregs\[15\]\[30\] sky130_fd_sc_hd__dfxtp_1
X_15699_ clknet_leaf_65_clk _00349_ VGND VGND VPWR VPWR cpuregs\[27\]\[25\] sky130_fd_sc_hd__dfxtp_1
XFILLER_0_86_174 VGND VGND VPWR VPWR sky130_fd_sc_hd__decap_3
X_14719_ _01729_ VGND VGND VPWR VPWR _01229_ sky130_fd_sc_hd__clkbuf_1
XFILLER_0_74_336 VGND VGND VPWR VPWR sky130_fd_sc_hd__fill_1
X_08240_ count_instr\[61\] _02203_ VGND VGND VPWR VPWR _02624_ sky130_fd_sc_hd__and2_1
XFILLER_0_117_427 VGND VGND VPWR VPWR sky130_fd_sc_hd__fill_2
X_08171_ _02530_ _02541_ _02542_ VGND VGND VPWR VPWR _02560_ sky130_fd_sc_hd__o21ai_2
XANTENNA_48 net56 VGND VGND VPWR VPWR sky130_fd_sc_hd__diode_2
XANTENNA_26 _04125_ VGND VGND VPWR VPWR sky130_fd_sc_hd__diode_2
XANTENNA_15 _03773_ VGND VGND VPWR VPWR sky130_fd_sc_hd__diode_2
XANTENNA_37 net3 VGND VGND VPWR VPWR sky130_fd_sc_hd__diode_2
XFILLER_0_7_647 VGND VGND VPWR VPWR sky130_fd_sc_hd__fill_2
XFILLER_0_27_230 VGND VGND VPWR VPWR sky130_fd_sc_hd__fill_1
XANTENNA_59 net72 VGND VGND VPWR VPWR sky130_fd_sc_hd__diode_2
XFILLER_0_12_93 VGND VGND VPWR VPWR sky130_fd_sc_hd__fill_2
XFILLER_0_15_458 VGND VGND VPWR VPWR sky130_fd_sc_hd__decap_3
XFILLER_0_43_767 VGND VGND VPWR VPWR sky130_fd_sc_hd__fill_1
Xoutput100 net100 VGND VGND VPWR VPWR mem_la_wdata[12] sky130_fd_sc_hd__clkbuf_4
XFILLER_0_112_121 VGND VGND VPWR VPWR sky130_fd_sc_hd__fill_1
Xoutput133 net133 VGND VGND VPWR VPWR mem_la_wstrb[3] sky130_fd_sc_hd__clkbuf_4
Xoutput111 net111 VGND VGND VPWR VPWR mem_la_wdata[22] sky130_fd_sc_hd__clkbuf_4
Xoutput122 net122 VGND VGND VPWR VPWR mem_la_wdata[3] sky130_fd_sc_hd__clkbuf_4
Xoutput155 net155 VGND VGND VPWR VPWR mem_wdata[28] sky130_fd_sc_hd__clkbuf_4
Xoutput166 net166 VGND VGND VPWR VPWR mem_wdata[9] sky130_fd_sc_hd__clkbuf_4
Xoutput177 net177 VGND VGND VPWR VPWR pcpi_rs1[15] sky130_fd_sc_hd__clkbuf_4
Xoutput144 net144 VGND VGND VPWR VPWR mem_wdata[18] sky130_fd_sc_hd__clkbuf_4
Xoutput199 net199 VGND VGND VPWR VPWR pcpi_rs1[6] sky130_fd_sc_hd__clkbuf_4
Xoutput188 net188 VGND VGND VPWR VPWR pcpi_rs1[25] sky130_fd_sc_hd__clkbuf_4
X_07955_ reg_pc\[9\] decoded_imm\[9\] _02357_ VGND VGND VPWR VPWR _02358_ sky130_fd_sc_hd__a21oi_1
X_07886_ net198 VGND VGND VPWR VPWR _02294_ sky130_fd_sc_hd__buf_2
X_09625_ decoded_imm\[3\] net196 VGND VGND VPWR VPWR _03858_ sky130_fd_sc_hd__nand2_1
XFILLER_0_77_141 VGND VGND VPWR VPWR sky130_fd_sc_hd__fill_1
X_09556_ decoded_imm\[2\] net193 VGND VGND VPWR VPWR _03790_ sky130_fd_sc_hd__nand2_1
X_09487_ _00013_ VGND VGND VPWR VPWR _03722_ sky130_fd_sc_hd__clkinv_4
X_08507_ net97 net108 net122 net252 VGND VGND VPWR VPWR _02884_ sky130_fd_sc_hd__or4_4
XFILLER_0_136_725 VGND VGND VPWR VPWR sky130_fd_sc_hd__fill_1
X_08438_ net190 net222 VGND VGND VPWR VPWR _02819_ sky130_fd_sc_hd__and2b_1
XFILLER_0_65_325 VGND VGND VPWR VPWR sky130_fd_sc_hd__decap_4
XFILLER_0_108_449 VGND VGND VPWR VPWR sky130_fd_sc_hd__fill_1
XFILLER_0_135_257 VGND VGND VPWR VPWR sky130_fd_sc_hd__decap_6
Xwire238 _07356_ VGND VGND VPWR VPWR net238 sky130_fd_sc_hd__buf_1
X_08369_ _02134_ _02748_ VGND VGND VPWR VPWR _02750_ sky130_fd_sc_hd__nand2_1
X_10400_ _04611_ _04612_ VGND VGND VPWR VPWR _04613_ sky130_fd_sc_hd__or2b_1
XFILLER_0_116_471 VGND VGND VPWR VPWR sky130_fd_sc_hd__decap_4
X_11380_ _05047_ net1008 _05265_ VGND VGND VPWR VPWR _05299_ sky130_fd_sc_hd__mux2_1
X_10331_ _04512_ _04516_ _04544_ VGND VGND VPWR VPWR _04546_ sky130_fd_sc_hd__a21o_1
XFILLER_0_131_463 VGND VGND VPWR VPWR sky130_fd_sc_hd__fill_1
XFILLER_0_104_699 VGND VGND VPWR VPWR sky130_fd_sc_hd__fill_1
X_10262_ _02426_ _02480_ _02548_ _02509_ _03365_ _03652_ VGND VGND VPWR VPWR _04479_
+ sky130_fd_sc_hd__mux4_1
X_13050_ _06537_ _06538_ _06540_ VGND VGND VPWR VPWR _06541_ sky130_fd_sc_hd__a21o_1
X_12001_ _05668_ _05661_ _05669_ VGND VGND VPWR VPWR _05670_ sky130_fd_sc_hd__and3b_1
X_10193_ _03722_ _04411_ _03674_ VGND VGND VPWR VPWR _04412_ sky130_fd_sc_hd__a21o_1
X_16740_ clknet_leaf_90_clk _01304_ VGND VGND VPWR VPWR cpuregs\[4\]\[19\] sky130_fd_sc_hd__dfxtp_1
X_13952_ mem_rdata_q\[28\] mem_rdata_q\[27\] mem_rdata_q\[26\] mem_rdata_q\[25\] VGND
+ VGND VPWR VPWR _07380_ sky130_fd_sc_hd__or4_1
X_12903_ _03337_ _06400_ _03317_ VGND VGND VPWR VPWR _06401_ sky130_fd_sc_hd__a21o_1
XFILLER_0_17_49 VGND VGND VPWR VPWR sky130_fd_sc_hd__fill_1
X_16671_ clknet_leaf_94_clk _01238_ VGND VGND VPWR VPWR cpuregs\[29\]\[17\] sky130_fd_sc_hd__dfxtp_1
X_13883_ _07327_ _07333_ VGND VGND VPWR VPWR _07334_ sky130_fd_sc_hd__nor2_1
XTAP_2052 VGND VPWR sky130_fd_sc_hd__tapvpwrvgnd_1
XTAP_2041 VGND VPWR sky130_fd_sc_hd__tapvpwrvgnd_1
XTAP_2030 VGND VPWR sky130_fd_sc_hd__tapvpwrvgnd_1
XFILLER_0_69_642 VGND VGND VPWR VPWR sky130_fd_sc_hd__decap_4
X_15622_ clknet_leaf_135_clk _00272_ VGND VGND VPWR VPWR cpuregs\[31\]\[12\] sky130_fd_sc_hd__dfxtp_1
X_12834_ mem_do_rinst _06332_ VGND VGND VPWR VPWR _06336_ sky130_fd_sc_hd__nor2_1
XFILLER_0_124_39 VGND VGND VPWR VPWR sky130_fd_sc_hd__decap_3
XTAP_2085 VGND VPWR sky130_fd_sc_hd__tapvpwrvgnd_1
XTAP_2074 VGND VPWR sky130_fd_sc_hd__tapvpwrvgnd_1
XTAP_2063 VGND VPWR sky130_fd_sc_hd__tapvpwrvgnd_1
XTAP_1340 VGND VPWR sky130_fd_sc_hd__tapvpwrvgnd_1
XFILLER_0_68_141 VGND VGND VPWR VPWR sky130_fd_sc_hd__decap_4
X_12765_ _06296_ VGND VGND VPWR VPWR _00773_ sky130_fd_sc_hd__clkbuf_1
X_15553_ clknet_leaf_112_clk _00203_ VGND VGND VPWR VPWR cpuregs\[2\]\[7\] sky130_fd_sc_hd__dfxtp_1
X_11716_ _05477_ VGND VGND VPWR VPWR _00543_ sky130_fd_sc_hd__clkbuf_1
XTAP_2096 VGND VPWR sky130_fd_sc_hd__tapvpwrvgnd_1
XFILLER_0_83_111 VGND VGND VPWR VPWR sky130_fd_sc_hd__fill_1
XTAP_1384 VGND VPWR sky130_fd_sc_hd__tapvpwrvgnd_1
XTAP_1373 VGND VPWR sky130_fd_sc_hd__tapvpwrvgnd_1
XTAP_1351 VGND VPWR sky130_fd_sc_hd__tapvpwrvgnd_1
XTAP_1362 VGND VPWR sky130_fd_sc_hd__tapvpwrvgnd_1
X_14504_ net1217 _05167_ _01612_ VGND VGND VPWR VPWR _01616_ sky130_fd_sc_hd__mux2_1
XFILLER_0_83_166 VGND VGND VPWR VPWR sky130_fd_sc_hd__fill_2
XTAP_1395 VGND VPWR sky130_fd_sc_hd__tapvpwrvgnd_1
X_12696_ count_cycle\[57\] _06234_ VGND VGND VPWR VPWR _06237_ sky130_fd_sc_hd__or2_1
X_15484_ clknet_leaf_132_clk _00134_ VGND VGND VPWR VPWR cpuregs\[30\]\[2\] sky130_fd_sc_hd__dfxtp_1
X_11647_ _05041_ net1537 _05433_ VGND VGND VPWR VPWR _05441_ sky130_fd_sc_hd__mux2_1
Xinput13 mem_rdata[20] VGND VGND VPWR VPWR net13 sky130_fd_sc_hd__buf_4
X_14435_ _01579_ VGND VGND VPWR VPWR _01063_ sky130_fd_sc_hd__clkbuf_1
XFILLER_0_37_594 VGND VGND VPWR VPWR sky130_fd_sc_hd__fill_1
X_11578_ _05404_ VGND VGND VPWR VPWR _00478_ sky130_fd_sc_hd__clkbuf_1
Xinput24 mem_rdata[30] VGND VGND VPWR VPWR net24 sky130_fd_sc_hd__clkbuf_4
XFILLER_0_24_233 VGND VGND VPWR VPWR sky130_fd_sc_hd__fill_1
X_14366_ _04989_ net753 _07616_ VGND VGND VPWR VPWR _01543_ sky130_fd_sc_hd__mux2_1
Xhold819 cpuregs\[14\]\[26\] VGND VGND VPWR VPWR net1177 sky130_fd_sc_hd__dlygate4sd3_1
X_10529_ _03897_ _04736_ _04738_ VGND VGND VPWR VPWR _04739_ sky130_fd_sc_hd__a21o_1
X_13317_ _06780_ _06782_ _06790_ _06799_ _06800_ VGND VGND VPWR VPWR _06801_ sky130_fd_sc_hd__a311o_1
Xhold808 cpuregs\[11\]\[12\] VGND VGND VPWR VPWR net1166 sky130_fd_sc_hd__dlygate4sd3_1
X_16105_ clknet_leaf_151_clk _00755_ VGND VGND VPWR VPWR count_cycle\[48\] sky130_fd_sc_hd__dfxtp_1
X_17085_ net108 VGND VGND VPWR VPWR net214 sky130_fd_sc_hd__buf_1
XFILLER_0_122_474 VGND VGND VPWR VPWR sky130_fd_sc_hd__fill_2
X_16036_ clknet_leaf_27_clk _00686_ VGND VGND VPWR VPWR reg_next_pc\[11\] sky130_fd_sc_hd__dfxtp_1
X_14297_ mem_rdata_q\[27\] _07576_ VGND VGND VPWR VPWR _07579_ sky130_fd_sc_hd__and2_1
X_13248_ _06537_ _06730_ _06732_ VGND VGND VPWR VPWR _06733_ sky130_fd_sc_hd__a21o_1
X_13179_ cpuregs\[10\]\[12\] cpuregs\[11\]\[12\] _06424_ VGND VGND VPWR VPWR _06666_
+ sky130_fd_sc_hd__mux2_1
XFILLER_0_74_33 VGND VGND VPWR VPWR sky130_fd_sc_hd__fill_2
X_07740_ instr_rdcycle _02126_ cpu_state\[2\] VGND VGND VPWR VPWR _02161_ sky130_fd_sc_hd__o21a_1
X_16938_ clknet_leaf_73_clk _01502_ VGND VGND VPWR VPWR cpuregs\[0\]\[25\] sky130_fd_sc_hd__dfxtp_1
XFILLER_0_74_77 VGND VGND VPWR VPWR sky130_fd_sc_hd__decap_6
X_16869_ clknet_leaf_48_clk _01433_ VGND VGND VPWR VPWR cpuregs\[22\]\[20\] sky130_fd_sc_hd__dfxtp_1
X_07671_ net34 _02091_ VGND VGND VPWR VPWR _02101_ sky130_fd_sc_hd__nand2_4
X_09410_ net1089 _03646_ _03445_ VGND VGND VPWR VPWR _03647_ sky130_fd_sc_hd__mux2_1
X_09341_ reg_pc\[21\] reg_pc\[20\] _03568_ reg_pc\[22\] VGND VGND VPWR VPWR _03587_
+ sky130_fd_sc_hd__a31o_1
XFILLER_0_59_196 VPWR VGND VPWR VGND sky130_ef_sc_hd__decap_12
XFILLER_0_114_83 VGND VGND VPWR VPWR sky130_fd_sc_hd__fill_1
X_09272_ reg_out\[13\] alu_out_q\[13\] _03436_ VGND VGND VPWR VPWR _03527_ sky130_fd_sc_hd__mux2_1
XFILLER_0_75_689 VGND VGND VPWR VPWR sky130_fd_sc_hd__fill_1
XFILLER_0_35_509 VGND VGND VPWR VPWR sky130_fd_sc_hd__fill_1
XFILLER_0_7_444 VGND VGND VPWR VPWR sky130_fd_sc_hd__fill_1
X_08223_ count_instr\[60\] _02203_ VGND VGND VPWR VPWR _02608_ sky130_fd_sc_hd__and2_1
X_08154_ _02530_ _02533_ _02543_ VGND VGND VPWR VPWR _02544_ sky130_fd_sc_hd__a21oi_1
XFILLER_0_55_391 VGND VGND VPWR VPWR sky130_fd_sc_hd__fill_1
X_08085_ net180 VGND VGND VPWR VPWR _02480_ sky130_fd_sc_hd__buf_2
XFILLER_0_31_726 VGND VGND VPWR VPWR sky130_fd_sc_hd__fill_2
XFILLER_0_101_614 VGND VGND VPWR VPWR sky130_fd_sc_hd__fill_2
XFILLER_0_100_102 VGND VGND VPWR VPWR sky130_fd_sc_hd__fill_1
XFILLER_0_2_160 VGND VGND VPWR VPWR sky130_fd_sc_hd__fill_1
X_08987_ reg_out\[28\] reg_next_pc\[28\] _03270_ VGND VGND VPWR VPWR _03283_ sky130_fd_sc_hd__mux2_1
Xclkbuf_4_5_0_clk clknet_0_clk VGND VGND VPWR VPWR clknet_4_5_0_clk sky130_fd_sc_hd__clkbuf_8
X_07938_ _02207_ _02340_ _02284_ _02342_ VGND VGND VPWR VPWR _02343_ sky130_fd_sc_hd__a22o_1
XFILLER_0_97_214 VGND VGND VPWR VPWR sky130_fd_sc_hd__fill_2
X_07869_ _02274_ _02277_ _02148_ VGND VGND VPWR VPWR _02278_ sky130_fd_sc_hd__o21ai_1
XFILLER_0_97_258 VGND VGND VPWR VPWR sky130_fd_sc_hd__fill_2
X_10880_ _05009_ VGND VGND VPWR VPWR _00175_ sky130_fd_sc_hd__clkbuf_1
X_09608_ _03738_ _03833_ _03841_ _03806_ VGND VGND VPWR VPWR _03842_ sky130_fd_sc_hd__o211a_1
X_09539_ instr_lui is_lui_auipc_jal VGND VGND VPWR VPWR _03774_ sky130_fd_sc_hd__and2b_2
XFILLER_0_109_736 VGND VGND VPWR VPWR sky130_fd_sc_hd__fill_2
XFILLER_0_93_464 VGND VGND VPWR VPWR sky130_fd_sc_hd__fill_2
X_12550_ count_cycle\[14\] _06127_ count_cycle\[15\] VGND VGND VPWR VPWR _06133_ sky130_fd_sc_hd__a21o_1
XFILLER_0_19_561 VGND VGND VPWR VPWR sky130_fd_sc_hd__fill_1
X_12481_ _05802_ _06067_ _05757_ VGND VGND VPWR VPWR _06082_ sky130_fd_sc_hd__a21oi_1
X_11501_ _05363_ VGND VGND VPWR VPWR _00442_ sky130_fd_sc_hd__clkbuf_1
XFILLER_0_53_317 VPWR VGND VPWR VGND sky130_ef_sc_hd__decap_12
X_14220_ net140 net102 _07530_ VGND VGND VPWR VPWR _07535_ sky130_fd_sc_hd__mux2_1
X_11432_ net841 _05207_ _05324_ VGND VGND VPWR VPWR _05327_ sky130_fd_sc_hd__mux2_1
XFILLER_0_123_249 VGND VGND VPWR VPWR sky130_fd_sc_hd__decap_6
X_14151_ _05031_ net1110 _07493_ VGND VGND VPWR VPWR _07496_ sky130_fd_sc_hd__mux2_1
XFILLER_0_34_586 VGND VGND VPWR VPWR sky130_fd_sc_hd__fill_2
XFILLER_0_132_783 VGND VGND VPWR VPWR sky130_fd_sc_hd__decap_8
X_11363_ _05290_ VGND VGND VPWR VPWR _00377_ sky130_fd_sc_hd__clkbuf_1
X_13102_ cpuregs\[28\]\[9\] cpuregs\[29\]\[9\] _06349_ VGND VGND VPWR VPWR _06592_
+ sky130_fd_sc_hd__mux2_1
X_11294_ _05253_ VGND VGND VPWR VPWR _00345_ sky130_fd_sc_hd__clkbuf_1
X_10314_ _03744_ _04525_ _04529_ _03885_ VGND VGND VPWR VPWR _04530_ sky130_fd_sc_hd__o211a_1
X_14082_ _07457_ VGND VGND VPWR VPWR _00908_ sky130_fd_sc_hd__clkbuf_1
X_10245_ _03863_ _04456_ _04462_ VGND VGND VPWR VPWR _04463_ sky130_fd_sc_hd__or3_2
XTAP_409 VGND VPWR sky130_fd_sc_hd__tapvpwrvgnd_1
X_13033_ _03329_ VGND VGND VPWR VPWR _06525_ sky130_fd_sc_hd__clkbuf_8
X_10176_ cpuregs\[16\]\[16\] cpuregs\[17\]\[16\] cpuregs\[18\]\[16\] cpuregs\[19\]\[16\]
+ _03938_ _04028_ VGND VGND VPWR VPWR _04396_ sky130_fd_sc_hd__mux4_1
XFILLER_0_28_15 VPWR VGND VPWR VGND sky130_ef_sc_hd__decap_12
X_14984_ _01870_ VGND VGND VPWR VPWR _01353_ sky130_fd_sc_hd__clkbuf_1
X_13935_ _07332_ _07368_ VGND VGND VPWR VPWR _07369_ sky130_fd_sc_hd__and2_1
X_16723_ clknet_leaf_101_clk _01287_ VGND VGND VPWR VPWR cpuregs\[4\]\[2\] sky130_fd_sc_hd__dfxtp_1
X_13866_ _05811_ VGND VGND VPWR VPWR _07320_ sky130_fd_sc_hd__clkbuf_4
X_16654_ clknet_leaf_125_clk _01221_ VGND VGND VPWR VPWR cpuregs\[29\]\[0\] sky130_fd_sc_hd__dfxtp_1
X_12817_ _06323_ VGND VGND VPWR VPWR _00798_ sky130_fd_sc_hd__clkbuf_1
X_15605_ clknet_leaf_66_clk _00255_ VGND VGND VPWR VPWR cpuregs\[28\]\[27\] sky130_fd_sc_hd__dfxtp_1
XFILLER_0_96_280 VGND VGND VPWR VPWR sky130_fd_sc_hd__fill_1
X_13797_ _06430_ _07260_ _07264_ _03335_ VGND VGND VPWR VPWR _07265_ sky130_fd_sc_hd__o211a_1
X_16585_ clknet_leaf_7_clk _00019_ VGND VGND VPWR VPWR cpu_state\[2\] sky130_fd_sc_hd__dfxtp_4
X_15536_ clknet_leaf_79_clk _00186_ VGND VGND VPWR VPWR cpuregs\[13\]\[22\] sky130_fd_sc_hd__dfxtp_1
X_12748_ _04103_ _06271_ _06275_ _06281_ _03817_ VGND VGND VPWR VPWR _06282_ sky130_fd_sc_hd__a311o_1
XTAP_1192 VGND VPWR sky130_fd_sc_hd__tapvpwrvgnd_1
XTAP_1181 VGND VPWR sky130_fd_sc_hd__tapvpwrvgnd_1
XTAP_1170 VGND VPWR sky130_fd_sc_hd__tapvpwrvgnd_1
XFILLER_0_44_306 VGND VGND VPWR VPWR sky130_fd_sc_hd__fill_2
X_15467_ clknet_leaf_103_clk _00117_ VGND VGND VPWR VPWR cpuregs\[12\]\[17\] sky130_fd_sc_hd__dfxtp_1
X_12679_ count_cycle\[51\] count_cycle\[52\] _06219_ VGND VGND VPWR VPWR _06225_ sky130_fd_sc_hd__and3_1
X_14418_ _05041_ net1277 _01562_ VGND VGND VPWR VPWR _01570_ sky130_fd_sc_hd__mux2_1
XFILLER_0_114_205 VGND VGND VPWR VPWR sky130_fd_sc_hd__decap_3
X_15398_ clknet_leaf_86_clk _00053_ VGND VGND VPWR VPWR cpuregs\[11\]\[16\] sky130_fd_sc_hd__dfxtp_1
XFILLER_0_12_203 VGND VGND VPWR VPWR sky130_fd_sc_hd__fill_1
XFILLER_0_123_750 VGND VGND VPWR VPWR sky130_fd_sc_hd__decap_8
Xhold605 cpuregs\[25\]\[17\] VGND VGND VPWR VPWR net963 sky130_fd_sc_hd__dlygate4sd3_1
Xhold627 cpuregs\[31\]\[12\] VGND VGND VPWR VPWR net985 sky130_fd_sc_hd__dlygate4sd3_1
Xhold616 cpuregs\[31\]\[10\] VGND VGND VPWR VPWR net974 sky130_fd_sc_hd__dlygate4sd3_1
X_14349_ _06025_ decoded_imm_j\[4\] _07567_ net475 _07388_ VGND VGND VPWR VPWR _07608_
+ sky130_fd_sc_hd__a221o_1
Xhold649 cpuregs\[17\]\[25\] VGND VGND VPWR VPWR net1007 sky130_fd_sc_hd__dlygate4sd3_1
Xhold638 cpuregs\[30\]\[13\] VGND VGND VPWR VPWR net996 sky130_fd_sc_hd__dlygate4sd3_1
XFILLER_0_40_556 VGND VGND VPWR VPWR sky130_fd_sc_hd__fill_2
X_16019_ clknet_leaf_32_clk _00669_ VGND VGND VPWR VPWR reg_pc\[25\] sky130_fd_sc_hd__dfxtp_2
XFILLER_0_100_85 VGND VGND VPWR VPWR sky130_fd_sc_hd__decap_8
X_08910_ _03230_ VGND VGND VPWR VPWR net89 sky130_fd_sc_hd__clkbuf_2
X_09890_ cpuregs\[8\]\[9\] cpuregs\[9\]\[9\] cpuregs\[10\]\[9\] cpuregs\[11\]\[9\]
+ _03798_ _03811_ VGND VGND VPWR VPWR _04117_ sky130_fd_sc_hd__mux4_1
XTAP_910 VGND VPWR sky130_fd_sc_hd__tapvpwrvgnd_1
X_08841_ _03190_ _03191_ VGND VGND VPWR VPWR _03192_ sky130_fd_sc_hd__nor2_1
XTAP_943 VGND VPWR sky130_fd_sc_hd__tapvpwrvgnd_1
XFILLER_0_0_686 VGND VGND VPWR VPWR sky130_fd_sc_hd__fill_2
XTAP_921 VGND VPWR sky130_fd_sc_hd__tapvpwrvgnd_1
XTAP_932 VGND VPWR sky130_fd_sc_hd__tapvpwrvgnd_1
XTAP_976 VGND VPWR sky130_fd_sc_hd__tapvpwrvgnd_1
XTAP_987 VGND VPWR sky130_fd_sc_hd__tapvpwrvgnd_1
XTAP_965 VGND VPWR sky130_fd_sc_hd__tapvpwrvgnd_1
XTAP_954 VGND VPWR sky130_fd_sc_hd__tapvpwrvgnd_1
Xhold1305 is_slli_srli_srai VGND VGND VPWR VPWR net1663 sky130_fd_sc_hd__dlygate4sd3_1
X_08772_ net219 _03128_ VGND VGND VPWR VPWR _03129_ sky130_fd_sc_hd__xnor2_1
XTAP_998 VGND VPWR sky130_fd_sc_hd__tapvpwrvgnd_1
XFILLER_0_79_225 VGND VGND VPWR VPWR sky130_fd_sc_hd__fill_1
X_07723_ net393 instr_sltiu instr_bltu VGND VGND VPWR VPWR _02146_ sky130_fd_sc_hd__or3_1
X_07654_ net34 VGND VGND VPWR VPWR _02084_ sky130_fd_sc_hd__inv_2
XFILLER_0_79_269 VGND VGND VPWR VPWR sky130_fd_sc_hd__decap_4
XFILLER_0_75_431 VGND VGND VPWR VPWR sky130_fd_sc_hd__fill_1
XFILLER_0_75_420 VGND VGND VPWR VPWR sky130_fd_sc_hd__fill_2
XFILLER_0_47_100 VPWR VGND VPWR VGND sky130_ef_sc_hd__decap_12
X_09324_ _03572_ VGND VGND VPWR VPWR _00056_ sky130_fd_sc_hd__clkbuf_1
X_09255_ net630 _03511_ _03512_ VGND VGND VPWR VPWR _03513_ sky130_fd_sc_hd__mux2_1
X_08206_ net189 VGND VGND VPWR VPWR _02593_ sky130_fd_sc_hd__clkbuf_4
XFILLER_0_90_445 VGND VGND VPWR VPWR sky130_fd_sc_hd__decap_3
XFILLER_0_16_531 VGND VGND VPWR VPWR sky130_fd_sc_hd__fill_1
X_09186_ _03452_ VGND VGND VPWR VPWR _00038_ sky130_fd_sc_hd__clkbuf_1
X_08137_ _02505_ _02527_ VGND VGND VPWR VPWR _02528_ sky130_fd_sc_hd__and2_1
XFILLER_0_120_219 VGND VGND VPWR VPWR sky130_fd_sc_hd__decap_4
X_08068_ _02462_ _02463_ VGND VGND VPWR VPWR _02464_ sky130_fd_sc_hd__xor2_1
XFILLER_0_113_293 VPWR VGND VPWR VGND sky130_ef_sc_hd__decap_12
X_10030_ reg_pc\[12\] _03776_ _04247_ _04253_ _03946_ VGND VGND VPWR VPWR _04254_
+ sky130_fd_sc_hd__a221o_1
X_11981_ count_instr\[47\] _05645_ _05652_ count_instr\[50\] VGND VGND VPWR VPWR _05655_
+ sky130_fd_sc_hd__a31o_1
X_10932_ _05044_ VGND VGND VPWR VPWR _00192_ sky130_fd_sc_hd__clkbuf_1
X_13720_ _07013_ _07190_ VGND VGND VPWR VPWR _07191_ sky130_fd_sc_hd__and2_1
X_13651_ _06457_ _07123_ VGND VGND VPWR VPWR _07124_ sky130_fd_sc_hd__and2_1
X_10863_ _04997_ net1399 _04985_ VGND VGND VPWR VPWR _04998_ sky130_fd_sc_hd__mux2_1
X_16370_ clknet_leaf_36_clk _00952_ VGND VGND VPWR VPWR net65 sky130_fd_sc_hd__dfxtp_1
XPHY_242 VGND VGND VPWR VPWR sky130_fd_sc_hd__decap_3
XPHY_231 VGND VGND VPWR VPWR sky130_fd_sc_hd__decap_3
XPHY_220 VGND VGND VPWR VPWR sky130_fd_sc_hd__decap_3
X_13582_ cpuregs\[12\]\[24\] cpuregs\[13\]\[24\] cpuregs\[14\]\[24\] cpuregs\[15\]\[24\]
+ _07027_ _06392_ VGND VGND VPWR VPWR _07057_ sky130_fd_sc_hd__mux4_1
X_10794_ _04945_ VGND VGND VPWR VPWR _04957_ sky130_fd_sc_hd__buf_4
X_12602_ net538 count_cycle\[30\] _06165_ _05631_ VGND VGND VPWR VPWR _06170_ sky130_fd_sc_hd__a31o_1
XPHY_275 VGND VGND VPWR VPWR sky130_fd_sc_hd__decap_3
XPHY_264 VGND VGND VPWR VPWR sky130_fd_sc_hd__decap_3
XPHY_253 VGND VGND VPWR VPWR sky130_fd_sc_hd__decap_3
X_12533_ _06119_ _05661_ _06120_ VGND VGND VPWR VPWR _06121_ sky130_fd_sc_hd__and3b_1
X_15321_ _03478_ net1208 _02041_ VGND VGND VPWR VPWR _02047_ sky130_fd_sc_hd__mux2_1
XFILLER_0_54_648 VGND VGND VPWR VPWR sky130_fd_sc_hd__fill_1
X_15252_ _02011_ VGND VGND VPWR VPWR _01480_ sky130_fd_sc_hd__clkbuf_1
X_12464_ _05755_ _06062_ VGND VGND VPWR VPWR _06066_ sky130_fd_sc_hd__nor2_1
XFILLER_0_81_478 VGND VGND VPWR VPWR sky130_fd_sc_hd__fill_1
X_14203_ net500 _02664_ _07519_ VGND VGND VPWR VPWR _07526_ sky130_fd_sc_hd__mux2_1
XFILLER_0_34_361 VGND VGND VPWR VPWR sky130_fd_sc_hd__decap_3
X_12395_ _05981_ _05743_ VGND VGND VPWR VPWR _06003_ sky130_fd_sc_hd__xnor2_1
X_11415_ net907 _05190_ _05313_ VGND VGND VPWR VPWR _05318_ sky130_fd_sc_hd__mux2_1
X_15183_ _03456_ net1457 _01973_ VGND VGND VPWR VPWR _01976_ sky130_fd_sc_hd__mux2_1
X_14134_ _05014_ net1055 _07482_ VGND VGND VPWR VPWR _07487_ sky130_fd_sc_hd__mux2_1
X_11346_ _05281_ VGND VGND VPWR VPWR _00369_ sky130_fd_sc_hd__clkbuf_1
X_14065_ net1153 net3 _03292_ VGND VGND VPWR VPWR _07449_ sky130_fd_sc_hd__mux2_1
XFILLER_0_39_25 VGND VGND VPWR VPWR sky130_fd_sc_hd__decap_4
X_11277_ _05244_ VGND VGND VPWR VPWR _00337_ sky130_fd_sc_hd__clkbuf_1
X_13016_ cpuregs\[4\]\[7\] cpuregs\[5\]\[7\] _06383_ VGND VGND VPWR VPWR _06508_ sky130_fd_sc_hd__mux2_1
X_10228_ _04441_ _04444_ _04445_ VGND VGND VPWR VPWR _04446_ sky130_fd_sc_hd__o21a_1
X_10159_ _02081_ _04374_ _04375_ _04378_ _02241_ VGND VGND VPWR VPWR _04379_ sky130_fd_sc_hd__a32o_1
X_14967_ _03635_ net1323 _01851_ VGND VGND VPWR VPWR _01861_ sky130_fd_sc_hd__mux2_1
X_16706_ clknet_leaf_82_clk _01273_ VGND VGND VPWR VPWR cpuregs\[3\]\[20\] sky130_fd_sc_hd__dfxtp_1
X_14898_ _01824_ VGND VGND VPWR VPWR _01313_ sky130_fd_sc_hd__clkbuf_1
X_13918_ net422 _07358_ _07335_ _02172_ VGND VGND VPWR VPWR _00855_ sky130_fd_sc_hd__a22o_1
X_16637_ clknet_leaf_53_clk _01204_ VGND VGND VPWR VPWR cpuregs\[23\]\[15\] sky130_fd_sc_hd__dfxtp_1
XFILLER_0_71_23 VGND VGND VPWR VPWR sky130_fd_sc_hd__fill_2
XFILLER_0_29_111 VGND VGND VPWR VPWR sky130_fd_sc_hd__fill_1
X_13849_ _03295_ _01094_ _01093_ VGND VGND VPWR VPWR _07309_ sky130_fd_sc_hd__nand3_1
X_16568_ clknet_leaf_49_clk _01145_ VGND VGND VPWR VPWR cpuregs\[24\]\[20\] sky130_fd_sc_hd__dfxtp_1
XFILLER_0_45_615 VGND VGND VPWR VPWR sky130_fd_sc_hd__fill_1
X_15519_ clknet_leaf_131_clk _00169_ VGND VGND VPWR VPWR cpuregs\[13\]\[5\] sky130_fd_sc_hd__dfxtp_1
X_16499_ clknet_leaf_52_clk _01081_ VGND VGND VPWR VPWR cpuregs\[19\]\[20\] sky130_fd_sc_hd__dfxtp_1
XFILLER_0_4_200 VGND VGND VPWR VPWR sky130_fd_sc_hd__decap_3
X_09040_ _03317_ VGND VGND VPWR VPWR _03321_ sky130_fd_sc_hd__clkbuf_4
XFILLER_0_72_467 VGND VGND VPWR VPWR sky130_fd_sc_hd__fill_1
XFILLER_0_4_233 VGND VGND VPWR VPWR sky130_fd_sc_hd__fill_1
Xhold402 cpuregs\[23\]\[24\] VGND VGND VPWR VPWR net760 sky130_fd_sc_hd__dlygate4sd3_1
Xhold435 cpuregs\[24\]\[19\] VGND VGND VPWR VPWR net793 sky130_fd_sc_hd__dlygate4sd3_1
Xhold413 cpuregs\[4\]\[13\] VGND VGND VPWR VPWR net771 sky130_fd_sc_hd__dlygate4sd3_1
Xhold424 cpuregs\[3\]\[3\] VGND VGND VPWR VPWR net782 sky130_fd_sc_hd__dlygate4sd3_1
Xhold468 cpuregs\[4\]\[19\] VGND VGND VPWR VPWR net826 sky130_fd_sc_hd__dlygate4sd3_1
Xhold446 cpuregs\[12\]\[13\] VGND VGND VPWR VPWR net804 sky130_fd_sc_hd__dlygate4sd3_1
X_09942_ _03897_ _04165_ _04167_ VGND VGND VPWR VPWR _04168_ sky130_fd_sc_hd__a21o_1
Xhold457 cpuregs\[26\]\[9\] VGND VGND VPWR VPWR net815 sky130_fd_sc_hd__dlygate4sd3_1
XFILLER_0_110_274 VGND VGND VPWR VPWR sky130_fd_sc_hd__fill_2
Xhold479 cpuregs\[15\]\[6\] VGND VGND VPWR VPWR net837 sky130_fd_sc_hd__dlygate4sd3_1
X_09873_ cpuregs\[20\]\[8\] cpuregs\[21\]\[8\] cpuregs\[22\]\[8\] cpuregs\[23\]\[8\]
+ _04100_ _03939_ VGND VGND VPWR VPWR _04101_ sky130_fd_sc_hd__mux4_1
XTAP_740 VGND VPWR sky130_fd_sc_hd__tapvpwrvgnd_1
XTAP_751 VGND VPWR sky130_fd_sc_hd__tapvpwrvgnd_1
X_08824_ _02632_ net224 _02915_ _03031_ VGND VGND VPWR VPWR _03176_ sky130_fd_sc_hd__a31o_1
Xhold1102 cpuregs\[24\]\[28\] VGND VGND VPWR VPWR net1460 sky130_fd_sc_hd__dlygate4sd3_1
Xhold1113 cpuregs\[31\]\[27\] VGND VGND VPWR VPWR net1471 sky130_fd_sc_hd__dlygate4sd3_1
Xhold1124 cpuregs\[15\]\[3\] VGND VGND VPWR VPWR net1482 sky130_fd_sc_hd__dlygate4sd3_1
XTAP_762 VGND VPWR sky130_fd_sc_hd__tapvpwrvgnd_1
XTAP_773 VGND VPWR sky130_fd_sc_hd__tapvpwrvgnd_1
XTAP_795 VGND VPWR sky130_fd_sc_hd__tapvpwrvgnd_1
XTAP_784 VGND VPWR sky130_fd_sc_hd__tapvpwrvgnd_1
Xhold1146 cpuregs\[2\]\[29\] VGND VGND VPWR VPWR net1504 sky130_fd_sc_hd__dlygate4sd3_1
X_08755_ _03004_ _03017_ VGND VGND VPWR VPWR _03112_ sky130_fd_sc_hd__nand2_1
Xhold1157 cpuregs\[3\]\[20\] VGND VGND VPWR VPWR net1515 sky130_fd_sc_hd__dlygate4sd3_1
Xhold1135 cpuregs\[2\]\[2\] VGND VGND VPWR VPWR net1493 sky130_fd_sc_hd__dlygate4sd3_1
Xhold1179 cpuregs\[25\]\[27\] VGND VGND VPWR VPWR net1537 sky130_fd_sc_hd__dlygate4sd3_1
Xhold1168 cpuregs\[15\]\[26\] VGND VGND VPWR VPWR net1526 sky130_fd_sc_hd__dlygate4sd3_1
X_07706_ net171 VGND VGND VPWR VPWR _02132_ sky130_fd_sc_hd__clkbuf_4
XFILLER_0_136_81 VGND VGND VPWR VPWR sky130_fd_sc_hd__decap_3
X_08686_ _03046_ _03048_ VGND VGND VPWR VPWR _03049_ sky130_fd_sc_hd__xnor2_1
XTAP_1906 VGND VPWR sky130_fd_sc_hd__tapvpwrvgnd_1
XTAP_1928 VGND VPWR sky130_fd_sc_hd__tapvpwrvgnd_1
XTAP_1939 VGND VPWR sky130_fd_sc_hd__tapvpwrvgnd_1
XTAP_1917 VGND VPWR sky130_fd_sc_hd__tapvpwrvgnd_1
XFILLER_0_95_559 VGND VGND VPWR VPWR sky130_fd_sc_hd__fill_1
XFILLER_0_137_105 VGND VGND VPWR VPWR sky130_fd_sc_hd__decap_6
XFILLER_0_82_209 VPWR VGND VPWR VGND sky130_ef_sc_hd__decap_12
X_09307_ _03557_ VGND VGND VPWR VPWR _03558_ sky130_fd_sc_hd__buf_2
XFILLER_0_63_412 VGND VGND VPWR VPWR sky130_fd_sc_hd__fill_2
XFILLER_0_90_231 VGND VGND VPWR VPWR sky130_fd_sc_hd__decap_6
XFILLER_0_90_253 VGND VGND VPWR VPWR sky130_fd_sc_hd__decap_4
XFILLER_0_63_467 VGND VGND VPWR VPWR sky130_fd_sc_hd__fill_1
X_09238_ _03497_ VGND VGND VPWR VPWR _03498_ sky130_fd_sc_hd__clkbuf_4
XFILLER_0_35_158 VGND VGND VPWR VPWR sky130_fd_sc_hd__decap_3
X_09169_ _03436_ VGND VGND VPWR VPWR _03437_ sky130_fd_sc_hd__buf_4
X_11200_ _03557_ VGND VGND VPWR VPWR _05196_ sky130_fd_sc_hd__clkbuf_4
X_12180_ decoded_imm_j\[5\] _05702_ VGND VGND VPWR VPWR _05805_ sky130_fd_sc_hd__or2_1
X_11131_ _05151_ VGND VGND VPWR VPWR _00284_ sky130_fd_sc_hd__clkbuf_1
XFILLER_0_31_386 VGND VGND VPWR VPWR sky130_fd_sc_hd__fill_1
XFILLER_0_101_263 VPWR VGND VPWR VGND sky130_ef_sc_hd__decap_12
Xhold980 cpuregs\[1\]\[18\] VGND VGND VPWR VPWR net1338 sky130_fd_sc_hd__dlygate4sd3_1
Xhold991 cpuregs\[19\]\[0\] VGND VGND VPWR VPWR net1349 sky130_fd_sc_hd__dlygate4sd3_1
XFILLER_0_8_3 VPWR VGND VPWR VGND sky130_ef_sc_hd__decap_12
X_11062_ net1010 _03603_ _05110_ VGND VGND VPWR VPWR _05115_ sky130_fd_sc_hd__mux2_1
X_10013_ cpuregs\[12\]\[12\] cpuregs\[13\]\[12\] _03976_ VGND VGND VPWR VPWR _04237_
+ sky130_fd_sc_hd__mux2_1
X_15870_ clknet_leaf_126_clk _00520_ VGND VGND VPWR VPWR cpuregs\[20\]\[4\] sky130_fd_sc_hd__dfxtp_1
X_14821_ _01783_ VGND VGND VPWR VPWR _01277_ sky130_fd_sc_hd__clkbuf_1
XFILLER_0_99_810 VGND VGND VPWR VPWR sky130_fd_sc_hd__fill_2
X_14752_ _05035_ net1397 _01742_ VGND VGND VPWR VPWR _01747_ sky130_fd_sc_hd__mux2_1
X_11964_ count_instr\[44\] _05637_ count_instr\[45\] VGND VGND VPWR VPWR _05643_ sky130_fd_sc_hd__a21o_1
X_13703_ cpuregs\[8\]\[28\] cpuregs\[9\]\[28\] _03343_ VGND VGND VPWR VPWR _07174_
+ sky130_fd_sc_hd__mux2_1
X_10915_ _03596_ VGND VGND VPWR VPWR _05033_ sky130_fd_sc_hd__buf_4
X_14683_ _01710_ VGND VGND VPWR VPWR _01212_ sky130_fd_sc_hd__clkbuf_1
XFILLER_0_58_217 VGND VGND VPWR VPWR sky130_fd_sc_hd__decap_6
X_11895_ _05591_ _05576_ _05592_ VGND VGND VPWR VPWR _05593_ sky130_fd_sc_hd__and3b_1
X_13634_ cpuregs\[30\]\[25\] cpuregs\[31\]\[25\] _06510_ VGND VGND VPWR VPWR _07108_
+ sky130_fd_sc_hd__mux2_1
XFILLER_0_73_209 VGND VGND VPWR VPWR sky130_fd_sc_hd__decap_4
X_16422_ clknet_leaf_24_clk _01004_ VGND VGND VPWR VPWR decoded_imm\[25\] sky130_fd_sc_hd__dfxtp_2
X_10846_ _04986_ VGND VGND VPWR VPWR _00164_ sky130_fd_sc_hd__clkbuf_1
XFILLER_0_39_431 VPWR VGND VPWR VGND sky130_ef_sc_hd__decap_12
X_16353_ clknet_leaf_84_clk _00935_ VGND VGND VPWR VPWR cpuregs\[1\]\[18\] sky130_fd_sc_hd__dfxtp_1
XFILLER_0_66_272 VGND VGND VPWR VPWR sky130_fd_sc_hd__decap_3
X_15304_ _02037_ VGND VGND VPWR VPWR _01506_ sky130_fd_sc_hd__clkbuf_1
X_13565_ _06962_ _07033_ _07040_ VGND VGND VPWR VPWR _07041_ sky130_fd_sc_hd__or3_2
X_10777_ _04948_ VGND VGND VPWR VPWR _00133_ sky130_fd_sc_hd__clkbuf_1
X_13496_ _06773_ _06973_ VGND VGND VPWR VPWR _06974_ sky130_fd_sc_hd__and2_1
X_12516_ _06107_ _05661_ _06108_ VGND VGND VPWR VPWR _06109_ sky130_fd_sc_hd__and3b_1
X_16284_ clknet_leaf_4_clk _00869_ VGND VGND VPWR VPWR instr_srli sky130_fd_sc_hd__dfxtp_2
XFILLER_0_42_629 VGND VGND VPWR VPWR sky130_fd_sc_hd__fill_1
XFILLER_0_140_804 VGND VGND VPWR VPWR sky130_fd_sc_hd__decap_4
X_12447_ _05751_ _06034_ VGND VGND VPWR VPWR _06051_ sky130_fd_sc_hd__or2_1
X_15235_ _03622_ net1109 _01995_ VGND VGND VPWR VPWR _02003_ sky130_fd_sc_hd__mux2_1
X_15166_ _01966_ VGND VGND VPWR VPWR _01439_ sky130_fd_sc_hd__clkbuf_1
XFILLER_0_1_225 VGND VGND VPWR VPWR sky130_fd_sc_hd__fill_2
X_12378_ _05519_ net951 VGND VGND VPWR VPWR _05988_ sky130_fd_sc_hd__or2_1
XFILLER_0_50_673 VGND VGND VPWR VPWR sky130_fd_sc_hd__fill_1
X_14117_ _04997_ net1035 _07471_ VGND VGND VPWR VPWR _07478_ sky130_fd_sc_hd__mux2_1
X_15097_ net1240 _05215_ _01923_ VGND VGND VPWR VPWR _01930_ sky130_fd_sc_hd__mux2_1
X_11329_ _05272_ VGND VGND VPWR VPWR _00361_ sky130_fd_sc_hd__clkbuf_1
X_14048_ _07440_ VGND VGND VPWR VPWR _00896_ sky130_fd_sc_hd__clkbuf_1
XFILLER_0_66_34 VPWR VGND VPWR VGND sky130_ef_sc_hd__decap_12
X_15999_ clknet_leaf_11_clk _00649_ VGND VGND VPWR VPWR reg_pc\[5\] sky130_fd_sc_hd__dfxtp_2
X_08540_ _02838_ VGND VGND VPWR VPWR _02915_ sky130_fd_sc_hd__clkbuf_4
X_08471_ _02850_ _02751_ _02748_ VGND VGND VPWR VPWR _02851_ sky130_fd_sc_hd__a21oi_1
XFILLER_0_119_105 VGND VGND VPWR VPWR sky130_fd_sc_hd__fill_2
XFILLER_0_106_73 VGND VGND VPWR VPWR sky130_fd_sc_hd__fill_1
XFILLER_0_58_795 VGND VGND VPWR VPWR sky130_fd_sc_hd__fill_1
XFILLER_0_45_412 VGND VGND VPWR VPWR sky130_fd_sc_hd__decap_4
XFILLER_0_86_3 VGND VGND VPWR VPWR sky130_fd_sc_hd__fill_2
X_09023_ _03305_ VGND VGND VPWR VPWR _00036_ sky130_fd_sc_hd__clkbuf_1
XFILLER_0_130_325 VGND VGND VPWR VPWR sky130_fd_sc_hd__fill_2
XFILLER_0_130_303 VGND VGND VPWR VPWR sky130_fd_sc_hd__decap_4
Xhold210 is_jalr_addi_slti_sltiu_xori_ori_andi VGND VGND VPWR VPWR net568 sky130_fd_sc_hd__dlygate4sd3_1
Xhold232 cpuregs\[28\]\[1\] VGND VGND VPWR VPWR net590 sky130_fd_sc_hd__dlygate4sd3_1
Xhold243 net147 VGND VGND VPWR VPWR net601 sky130_fd_sc_hd__dlygate4sd3_1
XFILLER_0_13_364 VGND VGND VPWR VPWR sky130_fd_sc_hd__decap_4
Xhold221 instr_jalr VGND VGND VPWR VPWR net579 sky130_fd_sc_hd__dlygate4sd3_1
Xhold254 cpuregs\[20\]\[22\] VGND VGND VPWR VPWR net612 sky130_fd_sc_hd__dlygate4sd3_1
Xhold287 cpuregs\[19\]\[24\] VGND VGND VPWR VPWR net645 sky130_fd_sc_hd__dlygate4sd3_1
Xhold265 cpuregs\[31\]\[16\] VGND VGND VPWR VPWR net623 sky130_fd_sc_hd__dlygate4sd3_1
Xhold276 cpuregs\[10\]\[12\] VGND VGND VPWR VPWR net634 sky130_fd_sc_hd__dlygate4sd3_1
Xhold298 cpuregs\[27\]\[24\] VGND VGND VPWR VPWR net656 sky130_fd_sc_hd__dlygate4sd3_1
X_09925_ _04151_ VGND VGND VPWR VPWR _00078_ sky130_fd_sc_hd__clkbuf_1
XTAP_570 VGND VPWR sky130_fd_sc_hd__tapvpwrvgnd_1
X_09856_ cpuregs\[8\]\[8\] cpuregs\[9\]\[8\] cpuregs\[10\]\[8\] cpuregs\[11\]\[8\]
+ _03876_ _03895_ VGND VGND VPWR VPWR _04084_ sky130_fd_sc_hd__mux4_1
X_08807_ _02605_ _03159_ VGND VGND VPWR VPWR _03161_ sky130_fd_sc_hd__or2_1
XTAP_592 VGND VPWR sky130_fd_sc_hd__tapvpwrvgnd_1
XTAP_581 VGND VPWR sky130_fd_sc_hd__tapvpwrvgnd_1
X_09787_ cpuregs\[4\]\[6\] cpuregs\[5\]\[6\] cpuregs\[6\]\[6\] cpuregs\[7\]\[6\] _03667_
+ _03670_ VGND VGND VPWR VPWR _04017_ sky130_fd_sc_hd__mux4_1
X_08738_ _03090_ _03095_ VGND VGND VPWR VPWR _03097_ sky130_fd_sc_hd__nand2_1
XANTENNA_105 net192 VGND VGND VPWR VPWR sky130_fd_sc_hd__diode_2
XANTENNA_116 clknet_0_clk VGND VGND VPWR VPWR sky130_fd_sc_hd__diode_2
X_08669_ _02713_ _02895_ _03032_ VGND VGND VPWR VPWR _03033_ sky130_fd_sc_hd__a21o_1
XANTENNA_149 net179 VGND VGND VPWR VPWR sky130_fd_sc_hd__diode_2
XTAP_1725 VGND VPWR sky130_fd_sc_hd__tapvpwrvgnd_1
XTAP_1714 VGND VPWR sky130_fd_sc_hd__tapvpwrvgnd_1
XTAP_1703 VGND VPWR sky130_fd_sc_hd__tapvpwrvgnd_1
XANTENNA_138 net88 VGND VGND VPWR VPWR sky130_fd_sc_hd__diode_2
XANTENNA_127 _06457_ VGND VGND VPWR VPWR sky130_fd_sc_hd__diode_2
XTAP_1758 VGND VPWR sky130_fd_sc_hd__tapvpwrvgnd_1
XTAP_1736 VGND VPWR sky130_fd_sc_hd__tapvpwrvgnd_1
XTAP_1747 VGND VPWR sky130_fd_sc_hd__tapvpwrvgnd_1
X_10700_ _04904_ VGND VGND VPWR VPWR _04905_ sky130_fd_sc_hd__buf_4
XTAP_1769 VGND VPWR sky130_fd_sc_hd__tapvpwrvgnd_1
XFILLER_0_83_529 VGND VGND VPWR VPWR sky130_fd_sc_hd__fill_2
X_11680_ net1385 _05181_ _05458_ VGND VGND VPWR VPWR _05459_ sky130_fd_sc_hd__mux2_1
XFILLER_0_48_261 VGND VGND VPWR VPWR sky130_fd_sc_hd__fill_2
X_10631_ _04787_ _04836_ _04837_ _03365_ VGND VGND VPWR VPWR _04838_ sky130_fd_sc_hd__a2bb2o_1
X_10562_ cpuregs\[22\]\[27\] cpuregs\[23\]\[27\] _03750_ VGND VGND VPWR VPWR _04771_
+ sky130_fd_sc_hd__mux2_1
X_13350_ _06832_ _02716_ _06629_ VGND VGND VPWR VPWR _06833_ sky130_fd_sc_hd__mux2_1
X_12301_ _05915_ _05916_ VGND VGND VPWR VPWR _05917_ sky130_fd_sc_hd__nand2_1
X_13281_ cpuregs\[8\]\[15\] cpuregs\[9\]\[15\] _06764_ VGND VGND VPWR VPWR _06765_
+ sky130_fd_sc_hd__mux2_1
XFILLER_0_17_670 VGND VGND VPWR VPWR sky130_fd_sc_hd__fill_2
X_10493_ cpuregs\[16\]\[25\] cpuregs\[17\]\[25\] cpuregs\[18\]\[25\] cpuregs\[19\]\[25\]
+ _03875_ _03726_ VGND VGND VPWR VPWR _04704_ sky130_fd_sc_hd__mux4_1
XFILLER_0_134_697 VGND VGND VPWR VPWR sky130_fd_sc_hd__decap_3
X_15020_ _01889_ VGND VGND VPWR VPWR _01370_ sky130_fd_sc_hd__clkbuf_1
XFILLER_0_106_399 VGND VGND VPWR VPWR sky130_fd_sc_hd__decap_4
XFILLER_0_106_388 VGND VGND VPWR VPWR sky130_fd_sc_hd__decap_3
X_12232_ _05773_ _05849_ _05710_ VGND VGND VPWR VPWR _05853_ sky130_fd_sc_hd__o21ba_1
XFILLER_0_20_813 VGND VGND VPWR VPWR sky130_fd_sc_hd__fill_1
X_12163_ _05763_ net544 _05784_ _05789_ _05768_ VGND VGND VPWR VPWR _00678_ sky130_fd_sc_hd__o221a_1
X_12094_ _05687_ VGND VGND VPWR VPWR _05735_ sky130_fd_sc_hd__clkbuf_4
X_16971_ clknet_leaf_81_clk _01535_ VGND VGND VPWR VPWR cpuregs\[10\]\[26\] sky130_fd_sc_hd__dfxtp_1
X_11114_ _05142_ VGND VGND VPWR VPWR _00276_ sky130_fd_sc_hd__clkbuf_1
X_15922_ clknet_leaf_53_clk _00572_ VGND VGND VPWR VPWR cpuregs\[17\]\[24\] sky130_fd_sc_hd__dfxtp_1
X_11045_ net832 _03552_ _05099_ VGND VGND VPWR VPWR _05106_ sky130_fd_sc_hd__mux2_1
X_15853_ clknet_leaf_96_clk _00503_ VGND VGND VPWR VPWR cpuregs\[25\]\[19\] sky130_fd_sc_hd__dfxtp_1
X_14804_ _01774_ VGND VGND VPWR VPWR _01269_ sky130_fd_sc_hd__clkbuf_1
X_15784_ clknet_leaf_18_clk _00434_ VGND VGND VPWR VPWR cpuregs\[26\]\[14\] sky130_fd_sc_hd__dfxtp_1
X_12996_ cpuregs\[20\]\[6\] cpuregs\[21\]\[6\] _06448_ VGND VGND VPWR VPWR _06489_
+ sky130_fd_sc_hd__mux2_1
X_14735_ _05018_ net1447 _01731_ VGND VGND VPWR VPWR _01738_ sky130_fd_sc_hd__mux2_1
X_11947_ _05630_ VGND VGND VPWR VPWR _00621_ sky130_fd_sc_hd__clkbuf_1
XFILLER_0_86_345 VGND VGND VPWR VPWR sky130_fd_sc_hd__decap_8
XFILLER_0_86_334 VGND VGND VPWR VPWR sky130_fd_sc_hd__decap_8
X_14666_ _01701_ VGND VGND VPWR VPWR _01204_ sky130_fd_sc_hd__clkbuf_1
XFILLER_0_52_58 VGND VGND VPWR VPWR sky130_fd_sc_hd__fill_1
X_11878_ net523 _05575_ _05580_ VGND VGND VPWR VPWR _00602_ sky130_fd_sc_hd__o21a_1
X_13617_ _06866_ _07086_ _07090_ _06873_ VGND VGND VPWR VPWR _07091_ sky130_fd_sc_hd__o211a_1
X_10829_ _04975_ VGND VGND VPWR VPWR _00158_ sky130_fd_sc_hd__clkbuf_1
X_14597_ _05016_ net1634 _01659_ VGND VGND VPWR VPWR _01665_ sky130_fd_sc_hd__mux2_1
XFILLER_0_67_592 VGND VGND VPWR VPWR sky130_fd_sc_hd__fill_2
X_16405_ clknet_leaf_17_clk _00987_ VGND VGND VPWR VPWR net167 sky130_fd_sc_hd__dfxtp_2
XFILLER_0_7_818 VPWR VGND VPWR VGND sky130_ef_sc_hd__decap_12
XFILLER_0_27_445 VGND VGND VPWR VPWR sky130_fd_sc_hd__decap_3
X_13548_ _06762_ _07009_ _07024_ _06802_ decoded_imm\[22\] VGND VGND VPWR VPWR _07025_
+ sky130_fd_sc_hd__a32o_1
XFILLER_0_54_253 VPWR VGND VPWR VGND sky130_ef_sc_hd__decap_12
X_16336_ clknet_leaf_119_clk _00918_ VGND VGND VPWR VPWR cpuregs\[1\]\[1\] sky130_fd_sc_hd__dfxtp_1
XFILLER_0_124_130 VGND VGND VPWR VPWR sky130_fd_sc_hd__decap_4
XFILLER_0_54_286 VGND VGND VPWR VPWR sky130_fd_sc_hd__fill_2
X_16267_ clknet_leaf_140_clk _00852_ VGND VGND VPWR VPWR instr_bgeu sky130_fd_sc_hd__dfxtp_1
X_13479_ _06780_ _06947_ _06951_ _06957_ _06800_ VGND VGND VPWR VPWR _06958_ sky130_fd_sc_hd__a311o_1
X_15218_ _03571_ net882 _01984_ VGND VGND VPWR VPWR _01994_ sky130_fd_sc_hd__mux2_1
XFILLER_0_23_662 VGND VGND VPWR VPWR sky130_fd_sc_hd__fill_2
X_16198_ clknet_leaf_138_clk _00815_ VGND VGND VPWR VPWR net234 sky130_fd_sc_hd__dfxtp_1
X_15149_ _01957_ VGND VGND VPWR VPWR _01431_ sky130_fd_sc_hd__clkbuf_1
X_07971_ reg_pc\[11\] decoded_imm\[11\] VGND VGND VPWR VPWR _02373_ sky130_fd_sc_hd__or2_1
X_09710_ _03726_ VGND VGND VPWR VPWR _03942_ sky130_fd_sc_hd__clkbuf_8
X_09641_ _03739_ _03866_ _03872_ _03873_ VGND VGND VPWR VPWR _03874_ sky130_fd_sc_hd__o211a_1
X_09572_ _00015_ VGND VGND VPWR VPWR _03806_ sky130_fd_sc_hd__buf_4
X_08523_ net250 _02898_ VGND VGND VPWR VPWR _02899_ sky130_fd_sc_hd__xnor2_1
XFILLER_0_93_805 VGND VGND VPWR VPWR sky130_fd_sc_hd__fill_1
XFILLER_0_77_356 VGND VGND VPWR VPWR sky130_fd_sc_hd__decap_8
XFILLER_0_9_100 VGND VGND VPWR VPWR sky130_fd_sc_hd__fill_1
XFILLER_0_9_122 VGND VGND VPWR VPWR sky130_fd_sc_hd__decap_8
XFILLER_0_9_111 VGND VGND VPWR VPWR sky130_fd_sc_hd__fill_1
X_08454_ instr_bgeu instr_bge _02833_ _02834_ VGND VGND VPWR VPWR _02835_ sky130_fd_sc_hd__o31a_1
XFILLER_0_37_209 VGND VGND VPWR VPWR sky130_fd_sc_hd__decap_8
XFILLER_0_133_93 VPWR VGND VPWR VGND sky130_ef_sc_hd__decap_12
X_08385_ net178 _02715_ _02716_ VGND VGND VPWR VPWR _02766_ sky130_fd_sc_hd__or3b_1
XFILLER_0_46_754 VGND VGND VPWR VPWR sky130_fd_sc_hd__fill_2
XFILLER_0_45_253 VGND VGND VPWR VPWR sky130_fd_sc_hd__fill_2
XFILLER_0_131_612 VGND VGND VPWR VPWR sky130_fd_sc_hd__decap_4
X_09006_ decoded_imm_j\[15\] _01108_ _03296_ VGND VGND VPWR VPWR _03297_ sky130_fd_sc_hd__mux2_1
XFILLER_0_115_185 VGND VGND VPWR VPWR sky130_fd_sc_hd__decap_4
XFILLER_0_20_109 VPWR VGND VPWR VGND sky130_ef_sc_hd__decap_12
X_09908_ cpuregs\[22\]\[9\] cpuregs\[23\]\[9\] _03750_ VGND VGND VPWR VPWR _04135_
+ sky130_fd_sc_hd__mux2_1
X_09839_ decoded_imm\[7\] net200 VGND VGND VPWR VPWR _04068_ sky130_fd_sc_hd__or2_1
XTAP_2201 VGND VPWR sky130_fd_sc_hd__tapvpwrvgnd_1
X_12850_ _03342_ VGND VGND VPWR VPWR _06349_ sky130_fd_sc_hd__clkbuf_8
XTAP_2223 VGND VPWR sky130_fd_sc_hd__tapvpwrvgnd_1
XTAP_2234 VGND VPWR sky130_fd_sc_hd__tapvpwrvgnd_1
XTAP_2212 VGND VPWR sky130_fd_sc_hd__tapvpwrvgnd_1
X_11801_ _05524_ VGND VGND VPWR VPWR _00581_ sky130_fd_sc_hd__clkbuf_1
XTAP_2278 VGND VPWR sky130_fd_sc_hd__tapvpwrvgnd_1
XTAP_2267 VGND VPWR sky130_fd_sc_hd__tapvpwrvgnd_1
XTAP_2256 VGND VPWR sky130_fd_sc_hd__tapvpwrvgnd_1
XTAP_2245 VGND VPWR sky130_fd_sc_hd__tapvpwrvgnd_1
X_12781_ net499 net67 _06302_ VGND VGND VPWR VPWR _06305_ sky130_fd_sc_hd__mux2_1
XTAP_1533 VGND VPWR sky130_fd_sc_hd__tapvpwrvgnd_1
XTAP_1522 VGND VPWR sky130_fd_sc_hd__tapvpwrvgnd_1
XTAP_1511 VGND VPWR sky130_fd_sc_hd__tapvpwrvgnd_1
XTAP_1500 VGND VPWR sky130_fd_sc_hd__tapvpwrvgnd_1
XPHY_40 VGND VGND VPWR VPWR sky130_fd_sc_hd__decap_3
X_14520_ _01624_ VGND VGND VPWR VPWR _01135_ sky130_fd_sc_hd__clkbuf_1
XTAP_2289 VGND VPWR sky130_fd_sc_hd__tapvpwrvgnd_1
XFILLER_0_113_19 VGND VGND VPWR VPWR sky130_fd_sc_hd__fill_2
XFILLER_0_96_698 VGND VGND VPWR VPWR sky130_fd_sc_hd__fill_2
XTAP_1566 VGND VPWR sky130_fd_sc_hd__tapvpwrvgnd_1
XTAP_1555 VGND VPWR sky130_fd_sc_hd__tapvpwrvgnd_1
XTAP_1544 VGND VPWR sky130_fd_sc_hd__tapvpwrvgnd_1
XPHY_51 VGND VGND VPWR VPWR sky130_fd_sc_hd__decap_3
XPHY_62 VGND VGND VPWR VPWR sky130_fd_sc_hd__decap_3
XPHY_73 VGND VGND VPWR VPWR sky130_fd_sc_hd__decap_3
X_11732_ _05486_ VGND VGND VPWR VPWR _00550_ sky130_fd_sc_hd__clkbuf_1
XTAP_1599 VGND VPWR sky130_fd_sc_hd__tapvpwrvgnd_1
XTAP_1588 VGND VPWR sky130_fd_sc_hd__tapvpwrvgnd_1
XTAP_1577 VGND VPWR sky130_fd_sc_hd__tapvpwrvgnd_1
XFILLER_0_83_348 VGND VGND VPWR VPWR sky130_fd_sc_hd__decap_3
X_14451_ net682 _05181_ _01587_ VGND VGND VPWR VPWR _01588_ sky130_fd_sc_hd__mux2_1
XPHY_95 VGND VGND VPWR VPWR sky130_fd_sc_hd__decap_3
X_11663_ net1468 _05165_ _05447_ VGND VGND VPWR VPWR _05450_ sky130_fd_sc_hd__mux2_1
XPHY_84 VGND VGND VPWR VPWR sky130_fd_sc_hd__decap_3
X_10614_ _03900_ _04821_ _03839_ VGND VGND VPWR VPWR _04822_ sky130_fd_sc_hd__a21o_1
X_13402_ cpuregs\[16\]\[18\] cpuregs\[17\]\[18\] cpuregs\[18\]\[18\] cpuregs\[19\]\[18\]
+ _06614_ _06648_ VGND VGND VPWR VPWR _06883_ sky130_fd_sc_hd__mux4_1
X_14382_ _07615_ VGND VGND VPWR VPWR _01551_ sky130_fd_sc_hd__buf_4
XFILLER_0_36_253 VGND VGND VPWR VPWR sky130_fd_sc_hd__fill_1
X_16121_ clknet_leaf_42_clk _00771_ VGND VGND VPWR VPWR net195 sky130_fd_sc_hd__dfxtp_2
XFILLER_0_106_141 VGND VGND VPWR VPWR sky130_fd_sc_hd__fill_1
X_13333_ _06580_ _06815_ VGND VGND VPWR VPWR _06816_ sky130_fd_sc_hd__or2_1
X_11594_ _05413_ VGND VGND VPWR VPWR _00485_ sky130_fd_sc_hd__clkbuf_1
X_10545_ _04751_ _04752_ _04753_ VGND VGND VPWR VPWR _04754_ sky130_fd_sc_hd__a21o_1
XFILLER_0_52_757 VGND VGND VPWR VPWR sky130_fd_sc_hd__fill_1
Xclkbuf_leaf_130_clk clknet_4_8_0_clk VGND VGND VPWR VPWR clknet_leaf_130_clk sky130_fd_sc_hd__clkbuf_16
X_16052_ clknet_leaf_35_clk _00702_ VGND VGND VPWR VPWR reg_next_pc\[27\] sky130_fd_sc_hd__dfxtp_1
X_10476_ _04685_ _04686_ VGND VGND VPWR VPWR _04687_ sky130_fd_sc_hd__nand2_1
X_13264_ _06682_ _06748_ VGND VGND VPWR VPWR _06749_ sky130_fd_sc_hd__and2_1
XFILLER_0_51_278 VGND VGND VPWR VPWR sky130_fd_sc_hd__fill_2
X_13195_ _06387_ VGND VGND VPWR VPWR _06682_ sky130_fd_sc_hd__clkbuf_4
X_12215_ _02166_ _05836_ _05837_ _05790_ _05707_ VGND VGND VPWR VPWR _05838_ sky130_fd_sc_hd__a32o_1
X_15003_ _01880_ VGND VGND VPWR VPWR _01362_ sky130_fd_sc_hd__clkbuf_1
X_12146_ _02154_ _05693_ VGND VGND VPWR VPWR _05774_ sky130_fd_sc_hd__nor2_1
XFILLER_0_138_38 VGND VGND VPWR VPWR sky130_fd_sc_hd__fill_2
XFILLER_0_47_14 VGND VGND VPWR VPWR sky130_fd_sc_hd__decap_4
X_12077_ reg_next_pc\[15\] _03222_ _05722_ VGND VGND VPWR VPWR _05723_ sky130_fd_sc_hd__a21oi_4
X_16954_ clknet_leaf_109_clk _01518_ VGND VGND VPWR VPWR cpuregs\[10\]\[9\] sky130_fd_sc_hd__dfxtp_1
X_16885_ clknet_leaf_123_clk _01449_ VGND VGND VPWR VPWR cpuregs\[8\]\[4\] sky130_fd_sc_hd__dfxtp_1
X_11028_ net667 _03498_ _05088_ VGND VGND VPWR VPWR _05097_ sky130_fd_sc_hd__mux2_1
X_15905_ clknet_leaf_128_clk _00555_ VGND VGND VPWR VPWR cpuregs\[17\]\[7\] sky130_fd_sc_hd__dfxtp_1
XFILLER_0_78_109 VGND VGND VPWR VPWR sky130_fd_sc_hd__decap_3
XFILLER_0_2_27 VGND VGND VPWR VPWR sky130_fd_sc_hd__fill_1
X_15836_ clknet_leaf_131_clk _00486_ VGND VGND VPWR VPWR cpuregs\[25\]\[2\] sky130_fd_sc_hd__dfxtp_1
X_15767_ clknet_leaf_70_clk _00417_ VGND VGND VPWR VPWR cpuregs\[15\]\[29\] sky130_fd_sc_hd__dfxtp_1
XFILLER_0_59_345 VGND VGND VPWR VPWR sky130_fd_sc_hd__fill_2
XFILLER_0_59_334 VGND VGND VPWR VPWR sky130_fd_sc_hd__fill_2
X_12979_ _06472_ VGND VGND VPWR VPWR _00811_ sky130_fd_sc_hd__clkbuf_1
X_15698_ clknet_leaf_62_clk _00348_ VGND VGND VPWR VPWR cpuregs\[27\]\[24\] sky130_fd_sc_hd__dfxtp_1
X_14718_ _05001_ net1503 _01720_ VGND VGND VPWR VPWR _01729_ sky130_fd_sc_hd__mux2_1
XFILLER_0_86_197 VGND VGND VPWR VPWR sky130_fd_sc_hd__decap_8
XFILLER_0_74_326 VGND VGND VPWR VPWR sky130_fd_sc_hd__fill_2
X_14649_ _01692_ VGND VGND VPWR VPWR _01196_ sky130_fd_sc_hd__clkbuf_1
X_08170_ _02517_ _02527_ _02556_ VGND VGND VPWR VPWR _02559_ sky130_fd_sc_hd__nor3_1
XANTENNA_27 _04247_ VGND VGND VPWR VPWR sky130_fd_sc_hd__diode_2
XANTENNA_38 net4 VGND VGND VPWR VPWR sky130_fd_sc_hd__diode_2
XANTENNA_16 _03795_ VGND VGND VPWR VPWR sky130_fd_sc_hd__diode_2
XANTENNA_49 net56 VGND VGND VPWR VPWR sky130_fd_sc_hd__diode_2
XFILLER_0_6_136 VGND VGND VPWR VPWR sky130_fd_sc_hd__decap_4
XFILLER_0_113_612 VGND VGND VPWR VPWR sky130_fd_sc_hd__decap_4
X_16319_ clknet_leaf_27_clk _00904_ VGND VGND VPWR VPWR decoded_imm_j\[17\] sky130_fd_sc_hd__dfxtp_2
XFILLER_0_3_821 VGND VGND VPWR VPWR sky130_fd_sc_hd__fill_2
Xclkbuf_leaf_121_clk clknet_4_10_0_clk VGND VGND VPWR VPWR clknet_leaf_121_clk sky130_fd_sc_hd__clkbuf_16
XFILLER_0_27_297 VPWR VGND VPWR VGND sky130_ef_sc_hd__decap_12
XFILLER_0_112_111 VGND VGND VPWR VPWR sky130_fd_sc_hd__fill_2
XFILLER_0_70_587 VGND VGND VPWR VPWR sky130_fd_sc_hd__fill_1
Xoutput101 net101 VGND VGND VPWR VPWR mem_la_wdata[13] sky130_fd_sc_hd__clkbuf_4
XFILLER_0_42_289 VGND VGND VPWR VPWR sky130_fd_sc_hd__fill_1
XFILLER_0_140_475 VGND VGND VPWR VPWR sky130_fd_sc_hd__fill_1
Xoutput112 net112 VGND VGND VPWR VPWR mem_la_wdata[23] sky130_fd_sc_hd__clkbuf_4
XFILLER_0_88_98 VGND VGND VPWR VPWR sky130_fd_sc_hd__decap_3
Xoutput134 net134 VGND VGND VPWR VPWR mem_valid sky130_fd_sc_hd__buf_2
Xoutput123 net251 VGND VGND VPWR VPWR mem_la_wdata[4] sky130_fd_sc_hd__clkbuf_4
Xoutput156 net156 VGND VGND VPWR VPWR mem_wdata[29] sky130_fd_sc_hd__clkbuf_4
Xoutput145 net145 VGND VGND VPWR VPWR mem_wdata[19] sky130_fd_sc_hd__clkbuf_4
Xoutput167 net167 VGND VGND VPWR VPWR mem_wstrb[0] sky130_fd_sc_hd__clkbuf_4
Xoutput178 net178 VGND VGND VPWR VPWR pcpi_rs1[16] sky130_fd_sc_hd__clkbuf_4
Xoutput189 net189 VGND VGND VPWR VPWR pcpi_rs1[26] sky130_fd_sc_hd__clkbuf_4
X_07954_ reg_pc\[8\] decoded_imm\[8\] _02347_ VGND VGND VPWR VPWR _02357_ sky130_fd_sc_hd__and3_1
XFILLER_0_49_3 VGND VGND VPWR VPWR sky130_fd_sc_hd__fill_2
XFILLER_0_10_197 VGND VGND VPWR VPWR sky130_fd_sc_hd__fill_2
X_07885_ _02291_ _02289_ _02290_ _02147_ VGND VGND VPWR VPWR _02293_ sky130_fd_sc_hd__o31a_1
X_09624_ decoded_imm\[3\] net196 VGND VGND VPWR VPWR _03857_ sky130_fd_sc_hd__nor2_1
XFILLER_0_78_665 VGND VGND VPWR VPWR sky130_fd_sc_hd__decap_4
X_09555_ decoded_imm\[2\] net193 VGND VGND VPWR VPWR _03789_ sky130_fd_sc_hd__nor2_1
XFILLER_0_66_816 VGND VGND VPWR VPWR sky130_fd_sc_hd__decap_4
X_08506_ _02873_ VGND VGND VPWR VPWR _02883_ sky130_fd_sc_hd__inv_2
X_09486_ cpuregs\[24\]\[1\] cpuregs\[25\]\[1\] cpuregs\[26\]\[1\] cpuregs\[27\]\[1\]
+ _03680_ _03720_ VGND VGND VPWR VPWR _03721_ sky130_fd_sc_hd__mux4_1
X_08437_ _02731_ _02816_ _02817_ VGND VGND VPWR VPWR _02818_ sky130_fd_sc_hd__a21o_1
XFILLER_0_135_225 VGND VGND VPWR VPWR sky130_fd_sc_hd__fill_1
XFILLER_0_80_307 VGND VGND VPWR VPWR sky130_fd_sc_hd__fill_1
XFILLER_0_18_242 VGND VGND VPWR VPWR sky130_fd_sc_hd__fill_1
XFILLER_0_18_253 VGND VGND VPWR VPWR sky130_fd_sc_hd__fill_1
X_08368_ _02134_ _02748_ VGND VGND VPWR VPWR _02749_ sky130_fd_sc_hd__or2_1
X_08299_ net173 net205 VGND VGND VPWR VPWR _02680_ sky130_fd_sc_hd__nand2_1
XFILLER_0_33_234 VGND VGND VPWR VPWR sky130_fd_sc_hd__decap_4
Xclkbuf_leaf_112_clk clknet_4_10_0_clk VGND VGND VPWR VPWR clknet_leaf_112_clk sky130_fd_sc_hd__clkbuf_16
X_10330_ _04512_ _04516_ _04544_ VGND VGND VPWR VPWR _04545_ sky130_fd_sc_hd__nand3_1
XFILLER_0_103_133 VPWR VGND VPWR VGND sky130_ef_sc_hd__decap_12
XFILLER_0_33_278 VGND VGND VPWR VPWR sky130_fd_sc_hd__fill_2
XFILLER_0_33_289 VGND VGND VPWR VPWR sky130_fd_sc_hd__fill_2
XFILLER_0_103_155 VGND VGND VPWR VPWR sky130_fd_sc_hd__fill_1
X_10261_ _04475_ _04476_ _02152_ VGND VGND VPWR VPWR _04478_ sky130_fd_sc_hd__a21o_1
XFILLER_0_42_790 VGND VGND VPWR VPWR sky130_fd_sc_hd__fill_2
XFILLER_0_103_177 VGND VGND VPWR VPWR sky130_fd_sc_hd__fill_1
X_12000_ count_instr\[54\] _05664_ count_instr\[55\] VGND VGND VPWR VPWR _05669_ sky130_fd_sc_hd__a21o_1
X_10192_ cpuregs\[12\]\[17\] cpuregs\[13\]\[17\] _03664_ VGND VGND VPWR VPWR _04411_
+ sky130_fd_sc_hd__mux2_1
X_13951_ net470 _07358_ _07362_ _02189_ VGND VGND VPWR VPWR _00867_ sky130_fd_sc_hd__a22o_1
X_12902_ cpuregs\[18\]\[1\] cpuregs\[19\]\[1\] _03322_ VGND VGND VPWR VPWR _06400_
+ sky130_fd_sc_hd__mux2_1
X_16670_ clknet_leaf_94_clk _01237_ VGND VGND VPWR VPWR cpuregs\[29\]\[16\] sky130_fd_sc_hd__dfxtp_1
X_13882_ mem_rdata_q\[13\] mem_rdata_q\[12\] VGND VGND VPWR VPWR _07333_ sky130_fd_sc_hd__or2b_1
XFILLER_0_124_29 VGND VGND VPWR VPWR sky130_fd_sc_hd__fill_1
XTAP_2042 VGND VPWR sky130_fd_sc_hd__tapvpwrvgnd_1
XTAP_2020 VGND VPWR sky130_fd_sc_hd__tapvpwrvgnd_1
XTAP_2031 VGND VPWR sky130_fd_sc_hd__tapvpwrvgnd_1
X_15621_ clknet_leaf_100_clk _00271_ VGND VGND VPWR VPWR cpuregs\[31\]\[11\] sky130_fd_sc_hd__dfxtp_1
X_12833_ cpu_state\[2\] _06333_ _06334_ VGND VGND VPWR VPWR _06335_ sky130_fd_sc_hd__a21oi_1
XTAP_2086 VGND VPWR sky130_fd_sc_hd__tapvpwrvgnd_1
XTAP_2075 VGND VPWR sky130_fd_sc_hd__tapvpwrvgnd_1
XTAP_2064 VGND VPWR sky130_fd_sc_hd__tapvpwrvgnd_1
XTAP_2053 VGND VPWR sky130_fd_sc_hd__tapvpwrvgnd_1
XTAP_1341 VGND VPWR sky130_fd_sc_hd__tapvpwrvgnd_1
XTAP_1330 VGND VPWR sky130_fd_sc_hd__tapvpwrvgnd_1
X_12764_ net58 net89 _06294_ VGND VGND VPWR VPWR _06296_ sky130_fd_sc_hd__mux2_1
X_15552_ clknet_leaf_115_clk _00202_ VGND VGND VPWR VPWR cpuregs\[2\]\[6\] sky130_fd_sc_hd__dfxtp_1
X_11715_ net1023 _05217_ _05469_ VGND VGND VPWR VPWR _05477_ sky130_fd_sc_hd__mux2_1
XTAP_2097 VGND VPWR sky130_fd_sc_hd__tapvpwrvgnd_1
XTAP_1374 VGND VPWR sky130_fd_sc_hd__tapvpwrvgnd_1
XTAP_1352 VGND VPWR sky130_fd_sc_hd__tapvpwrvgnd_1
XTAP_1363 VGND VPWR sky130_fd_sc_hd__tapvpwrvgnd_1
X_15483_ clknet_leaf_126_clk _00133_ VGND VGND VPWR VPWR cpuregs\[30\]\[1\] sky130_fd_sc_hd__dfxtp_1
X_14503_ _01615_ VGND VGND VPWR VPWR _01127_ sky130_fd_sc_hd__clkbuf_1
XFILLER_0_127_737 VGND VGND VPWR VPWR sky130_fd_sc_hd__fill_1
XFILLER_0_126_225 VGND VGND VPWR VPWR sky130_fd_sc_hd__fill_1
XFILLER_0_126_203 VGND VGND VPWR VPWR sky130_fd_sc_hd__fill_1
XTAP_1396 VGND VPWR sky130_fd_sc_hd__tapvpwrvgnd_1
XTAP_1385 VGND VPWR sky130_fd_sc_hd__tapvpwrvgnd_1
X_12695_ _06236_ VGND VGND VPWR VPWR _00763_ sky130_fd_sc_hd__clkbuf_1
X_11646_ _05440_ VGND VGND VPWR VPWR _00510_ sky130_fd_sc_hd__clkbuf_1
XFILLER_0_80_830 VGND VGND VPWR VPWR sky130_fd_sc_hd__fill_2
XFILLER_0_71_329 VGND VGND VPWR VPWR sky130_fd_sc_hd__fill_1
X_14434_ net1545 _05165_ _01576_ VGND VGND VPWR VPWR _01579_ sky130_fd_sc_hd__mux2_1
Xinput14 mem_rdata[21] VGND VGND VPWR VPWR net14 sky130_fd_sc_hd__clkbuf_4
X_11577_ _05039_ net1163 _05397_ VGND VGND VPWR VPWR _05404_ sky130_fd_sc_hd__mux2_1
Xclkbuf_leaf_103_clk clknet_4_11_0_clk VGND VGND VPWR VPWR clknet_leaf_103_clk sky130_fd_sc_hd__clkbuf_16
XFILLER_0_52_554 VGND VGND VPWR VPWR sky130_fd_sc_hd__fill_2
X_14365_ _01542_ VGND VGND VPWR VPWR _01030_ sky130_fd_sc_hd__clkbuf_1
Xinput25 mem_rdata[31] VGND VGND VPWR VPWR net25 sky130_fd_sc_hd__clkbuf_4
Xhold809 cpuregs\[23\]\[25\] VGND VGND VPWR VPWR net1167 sky130_fd_sc_hd__dlygate4sd3_1
X_13316_ _06341_ VGND VGND VPWR VPWR _06800_ sky130_fd_sc_hd__clkbuf_4
X_10528_ _03901_ _04737_ _03731_ VGND VGND VPWR VPWR _04738_ sky130_fd_sc_hd__a21o_1
X_14296_ _07569_ _07573_ _07578_ _07575_ net1602 VGND VGND VPWR VPWR _01001_ sky130_fd_sc_hd__o32a_1
X_16104_ clknet_leaf_151_clk _00754_ VGND VGND VPWR VPWR count_cycle\[47\] sky130_fd_sc_hd__dfxtp_1
XFILLER_0_12_418 VGND VGND VPWR VPWR sky130_fd_sc_hd__fill_2
XFILLER_0_24_278 VGND VGND VPWR VPWR sky130_fd_sc_hd__decap_4
X_17084_ net97 VGND VGND VPWR VPWR net203 sky130_fd_sc_hd__clkbuf_2
X_16035_ clknet_leaf_26_clk _00685_ VGND VGND VPWR VPWR reg_next_pc\[10\] sky130_fd_sc_hd__dfxtp_1
X_13247_ _06699_ _06731_ _06667_ VGND VGND VPWR VPWR _06732_ sky130_fd_sc_hd__a21o_1
X_10459_ _04669_ _04670_ VGND VGND VPWR VPWR _04671_ sky130_fd_sc_hd__nand2_1
X_13178_ cpuregs\[8\]\[12\] cpuregs\[9\]\[12\] _06422_ VGND VGND VPWR VPWR _06665_
+ sky130_fd_sc_hd__mux2_1
X_12129_ _05686_ _05759_ VGND VGND VPWR VPWR _05760_ sky130_fd_sc_hd__or2_1
X_16937_ clknet_leaf_59_clk _01501_ VGND VGND VPWR VPWR cpuregs\[0\]\[24\] sky130_fd_sc_hd__dfxtp_1
X_16868_ clknet_leaf_55_clk _01432_ VGND VGND VPWR VPWR cpuregs\[22\]\[19\] sky130_fd_sc_hd__dfxtp_1
X_07670_ instr_sb instr_sh instr_sw _02099_ VGND VGND VPWR VPWR _02100_ sky130_fd_sc_hd__or4b_1
X_15819_ clknet_leaf_95_clk _00469_ VGND VGND VPWR VPWR cpuregs\[16\]\[17\] sky130_fd_sc_hd__dfxtp_1
X_16799_ clknet_leaf_105_clk _01363_ VGND VGND VPWR VPWR cpuregs\[6\]\[14\] sky130_fd_sc_hd__dfxtp_1
X_09340_ reg_out\[22\] alu_out_q\[22\] _03436_ VGND VGND VPWR VPWR _03586_ sky130_fd_sc_hd__mux2_1
XFILLER_0_90_44 VGND VGND VPWR VPWR sky130_fd_sc_hd__fill_1
XFILLER_0_59_142 VGND VGND VPWR VPWR sky130_fd_sc_hd__decap_4
X_09271_ _03526_ VGND VGND VPWR VPWR _00049_ sky130_fd_sc_hd__clkbuf_1
X_08222_ _02286_ _02598_ _02607_ VGND VGND VPWR VPWR _07637_ sky130_fd_sc_hd__o21a_1
XFILLER_0_7_401 VGND VGND VPWR VPWR sky130_fd_sc_hd__fill_1
X_08153_ _02541_ _02542_ VGND VGND VPWR VPWR _02543_ sky130_fd_sc_hd__or2b_1
XFILLER_0_16_757 VGND VGND VPWR VPWR sky130_fd_sc_hd__decap_4
X_08084_ net10 _02466_ _02428_ VGND VGND VPWR VPWR _02479_ sky130_fd_sc_hd__a21o_1
XFILLER_0_31_738 VGND VGND VPWR VPWR sky130_fd_sc_hd__fill_1
X_08986_ _03282_ VGND VGND VPWR VPWR net83 sky130_fd_sc_hd__buf_4
X_07937_ count_instr\[8\] _02270_ count_cycle\[8\] _02202_ _02341_ VGND VGND VPWR
+ VPWR _02342_ sky130_fd_sc_hd__a221o_1
X_07868_ _02275_ _02276_ VGND VGND VPWR VPWR _02277_ sky130_fd_sc_hd__nand2_1
X_07799_ _02132_ mem_wordsize\[1\] VGND VGND VPWR VPWR _02212_ sky130_fd_sc_hd__and2_2
X_09607_ _03834_ _03836_ _03840_ VGND VGND VPWR VPWR _03841_ sky130_fd_sc_hd__a21o_1
X_09538_ _03763_ _03772_ _03747_ VGND VGND VPWR VPWR _03773_ sky130_fd_sc_hd__a21o_2
X_11500_ net632 _05207_ _05360_ VGND VGND VPWR VPWR _05363_ sky130_fd_sc_hd__mux2_1
XFILLER_0_93_454 VGND VGND VPWR VPWR sky130_fd_sc_hd__decap_4
X_09469_ net171 decoded_imm\[0\] VGND VGND VPWR VPWR _03705_ sky130_fd_sc_hd__nand2_1
X_12480_ _05792_ _06073_ _06080_ _05520_ VGND VGND VPWR VPWR _06081_ sky130_fd_sc_hd__o211a_1
XFILLER_0_65_167 VGND VGND VPWR VPWR sky130_fd_sc_hd__fill_1
XFILLER_0_53_329 VGND VGND VPWR VPWR sky130_fd_sc_hd__fill_1
XFILLER_0_19_584 VGND VGND VPWR VPWR sky130_fd_sc_hd__fill_1
XFILLER_0_136_589 VGND VGND VPWR VPWR sky130_fd_sc_hd__fill_1
X_11431_ _05326_ VGND VGND VPWR VPWR _00409_ sky130_fd_sc_hd__clkbuf_1
XFILLER_0_80_148 VGND VGND VPWR VPWR sky130_fd_sc_hd__decap_4
XFILLER_0_46_381 VGND VGND VPWR VPWR sky130_fd_sc_hd__fill_2
XFILLER_0_34_521 VGND VGND VPWR VPWR sky130_fd_sc_hd__fill_1
X_14150_ _07495_ VGND VGND VPWR VPWR _00938_ sky130_fd_sc_hd__clkbuf_1
X_11362_ _05029_ net1561 _05288_ VGND VGND VPWR VPWR _05290_ sky130_fd_sc_hd__mux2_1
XFILLER_0_34_576 VGND VGND VPWR VPWR sky130_fd_sc_hd__fill_1
XFILLER_0_104_442 VGND VGND VPWR VPWR sky130_fd_sc_hd__fill_1
X_10313_ _03897_ _04526_ _04528_ VGND VGND VPWR VPWR _04529_ sky130_fd_sc_hd__a21o_1
X_13101_ cpuregs\[24\]\[9\] cpuregs\[25\]\[9\] cpuregs\[26\]\[9\] cpuregs\[27\]\[9\]
+ _06525_ _06558_ VGND VGND VPWR VPWR _06591_ sky130_fd_sc_hd__mux4_1
X_11293_ net684 _05205_ _05251_ VGND VGND VPWR VPWR _05253_ sky130_fd_sc_hd__mux2_1
X_14081_ decoded_imm_j\[2\] _01115_ _03295_ VGND VGND VPWR VPWR _07457_ sky130_fd_sc_hd__mux2_1
X_10244_ _03744_ _04457_ _04461_ _03885_ VGND VGND VPWR VPWR _04462_ sky130_fd_sc_hd__o211a_1
X_13032_ _06447_ _06521_ _06523_ _06453_ VGND VGND VPWR VPWR _06524_ sky130_fd_sc_hd__a211o_1
X_10175_ cpuregs\[20\]\[16\] cpuregs\[21\]\[16\] cpuregs\[22\]\[16\] cpuregs\[23\]\[16\]
+ _04100_ _03939_ VGND VGND VPWR VPWR _04395_ sky130_fd_sc_hd__mux4_1
XFILLER_0_28_27 VGND VGND VPWR VPWR sky130_fd_sc_hd__fill_1
X_14983_ _03472_ net1303 _01865_ VGND VGND VPWR VPWR _01870_ sky130_fd_sc_hd__mux2_1
XFILLER_0_89_738 VGND VGND VPWR VPWR sky130_fd_sc_hd__decap_4
X_16722_ clknet_leaf_120_clk _01286_ VGND VGND VPWR VPWR cpuregs\[4\]\[1\] sky130_fd_sc_hd__dfxtp_1
X_13934_ instr_slti _07367_ _07361_ _07364_ VGND VGND VPWR VPWR _07368_ sky130_fd_sc_hd__a22o_1
X_16653_ clknet_leaf_55_clk _01220_ VGND VGND VPWR VPWR cpuregs\[23\]\[31\] sky130_fd_sc_hd__dfxtp_1
XFILLER_0_44_59 VGND VGND VPWR VPWR sky130_fd_sc_hd__fill_1
X_13865_ net389 _07306_ _07312_ _07319_ VGND VGND VPWR VPWR _00845_ sky130_fd_sc_hd__a22o_1
X_12816_ net53 net84 _06313_ VGND VGND VPWR VPWR _06323_ sky130_fd_sc_hd__mux2_1
X_15604_ clknet_leaf_69_clk _00254_ VGND VGND VPWR VPWR cpuregs\[28\]\[26\] sky130_fd_sc_hd__dfxtp_1
XFILLER_0_97_760 VGND VGND VPWR VPWR sky130_fd_sc_hd__decap_3
XFILLER_0_57_613 VGND VGND VPWR VPWR sky130_fd_sc_hd__decap_3
XFILLER_0_84_421 VGND VGND VPWR VPWR sky130_fd_sc_hd__decap_3
X_13796_ _06431_ _07261_ _07263_ VGND VGND VPWR VPWR _07264_ sky130_fd_sc_hd__a21o_1
XFILLER_0_29_337 VGND VGND VPWR VPWR sky130_fd_sc_hd__fill_2
X_16584_ clknet_leaf_5_clk _00018_ VGND VGND VPWR VPWR cpu_state\[1\] sky130_fd_sc_hd__dfxtp_2
X_15535_ clknet_leaf_79_clk _00185_ VGND VGND VPWR VPWR cpuregs\[13\]\[21\] sky130_fd_sc_hd__dfxtp_1
X_12747_ _03662_ _06276_ _06280_ _03684_ VGND VGND VPWR VPWR _06281_ sky130_fd_sc_hd__o211a_1
XTAP_1182 VGND VPWR sky130_fd_sc_hd__tapvpwrvgnd_1
XTAP_1160 VGND VPWR sky130_fd_sc_hd__tapvpwrvgnd_1
XTAP_1171 VGND VPWR sky130_fd_sc_hd__tapvpwrvgnd_1
XFILLER_0_60_14 VGND VGND VPWR VPWR sky130_fd_sc_hd__decap_4
X_15466_ clknet_leaf_86_clk _00116_ VGND VGND VPWR VPWR cpuregs\[12\]\[16\] sky130_fd_sc_hd__dfxtp_1
XTAP_1193 VGND VPWR sky130_fd_sc_hd__tapvpwrvgnd_1
X_12678_ _06224_ VGND VGND VPWR VPWR _00758_ sky130_fd_sc_hd__clkbuf_1
X_14417_ _01569_ VGND VGND VPWR VPWR _01055_ sky130_fd_sc_hd__clkbuf_1
XFILLER_0_114_217 VPWR VGND VPWR VGND sky130_ef_sc_hd__decap_12
X_11629_ _05431_ VGND VGND VPWR VPWR _00502_ sky130_fd_sc_hd__clkbuf_1
XFILLER_0_72_649 VGND VGND VPWR VPWR sky130_fd_sc_hd__fill_1
XFILLER_0_25_532 VGND VGND VPWR VPWR sky130_fd_sc_hd__fill_1
X_15397_ clknet_leaf_86_clk _00052_ VGND VGND VPWR VPWR cpuregs\[11\]\[15\] sky130_fd_sc_hd__dfxtp_1
XFILLER_0_8_15 VGND VGND VPWR VPWR sky130_fd_sc_hd__fill_1
Xhold606 cpuregs\[6\]\[25\] VGND VGND VPWR VPWR net964 sky130_fd_sc_hd__dlygate4sd3_1
Xhold617 cpuregs\[25\]\[26\] VGND VGND VPWR VPWR net975 sky130_fd_sc_hd__dlygate4sd3_1
X_14348_ mem_rdata_q\[24\] _07460_ VGND VGND VPWR VPWR _07607_ sky130_fd_sc_hd__and2_1
Xhold639 cpuregs\[4\]\[28\] VGND VGND VPWR VPWR net997 sky130_fd_sc_hd__dlygate4sd3_1
Xhold628 cpuregs\[23\]\[9\] VGND VGND VPWR VPWR net986 sky130_fd_sc_hd__dlygate4sd3_1
X_14279_ _06405_ decoded_imm_j\[1\] is_slli_srli_srai VGND VGND VPWR VPWR _07566_
+ sky130_fd_sc_hd__mux2_1
X_16018_ clknet_leaf_35_clk _00668_ VGND VGND VPWR VPWR reg_pc\[24\] sky130_fd_sc_hd__dfxtp_2
XFILLER_0_0_643 VGND VGND VPWR VPWR sky130_fd_sc_hd__fill_1
XTAP_900 VGND VPWR sky130_fd_sc_hd__tapvpwrvgnd_1
X_08840_ _02646_ _03189_ VGND VGND VPWR VPWR _03191_ sky130_fd_sc_hd__nor2_1
XFILLER_0_85_11 VGND VGND VPWR VPWR sky130_fd_sc_hd__fill_2
XTAP_944 VGND VPWR sky130_fd_sc_hd__tapvpwrvgnd_1
XFILLER_0_0_698 VGND VGND VPWR VPWR sky130_fd_sc_hd__fill_2
XTAP_911 VGND VPWR sky130_fd_sc_hd__tapvpwrvgnd_1
XTAP_922 VGND VPWR sky130_fd_sc_hd__tapvpwrvgnd_1
XTAP_933 VGND VPWR sky130_fd_sc_hd__tapvpwrvgnd_1
XFILLER_0_85_55 VGND VGND VPWR VPWR sky130_fd_sc_hd__fill_1
XTAP_977 VGND VPWR sky130_fd_sc_hd__tapvpwrvgnd_1
XTAP_966 VGND VPWR sky130_fd_sc_hd__tapvpwrvgnd_1
XTAP_955 VGND VPWR sky130_fd_sc_hd__tapvpwrvgnd_1
Xhold1306 count_instr\[48\] VGND VGND VPWR VPWR net1664 sky130_fd_sc_hd__dlygate4sd3_1
X_08771_ _02122_ _03127_ VGND VGND VPWR VPWR _03128_ sky130_fd_sc_hd__nor2_1
XTAP_999 VGND VPWR sky130_fd_sc_hd__tapvpwrvgnd_1
XTAP_988 VGND VPWR sky130_fd_sc_hd__tapvpwrvgnd_1
XFILLER_0_18_82 VGND VGND VPWR VPWR sky130_fd_sc_hd__fill_2
X_07722_ net565 VGND VGND VPWR VPWR _00002_ sky130_fd_sc_hd__clkbuf_1
X_07653_ _02082_ VGND VGND VPWR VPWR _02083_ sky130_fd_sc_hd__clkbuf_8
X_09323_ net732 _03571_ _03512_ VGND VGND VPWR VPWR _03572_ sky130_fd_sc_hd__mux2_1
XFILLER_0_63_605 VGND VGND VPWR VPWR sky130_fd_sc_hd__fill_2
XFILLER_0_47_123 VGND VGND VPWR VPWR sky130_fd_sc_hd__fill_1
XFILLER_0_90_402 VGND VGND VPWR VPWR sky130_fd_sc_hd__fill_2
XFILLER_0_75_487 VGND VGND VPWR VPWR sky130_fd_sc_hd__fill_1
X_09254_ _03445_ VGND VGND VPWR VPWR _03512_ sky130_fd_sc_hd__buf_4
XFILLER_0_63_627 VGND VGND VPWR VPWR sky130_fd_sc_hd__fill_1
XFILLER_0_133_526 VGND VGND VPWR VPWR sky130_fd_sc_hd__fill_1
XFILLER_0_106_718 VGND VGND VPWR VPWR sky130_fd_sc_hd__fill_1
X_08205_ net19 _02447_ _02428_ VGND VGND VPWR VPWR _02592_ sky130_fd_sc_hd__a21o_1
XFILLER_0_44_830 VGND VGND VPWR VPWR sky130_fd_sc_hd__fill_2
XFILLER_0_7_253 VGND VGND VPWR VPWR sky130_fd_sc_hd__fill_2
X_09185_ net1387 _03451_ _03446_ VGND VGND VPWR VPWR _03452_ sky130_fd_sc_hd__mux2_1
XFILLER_0_28_370 VGND VGND VPWR VPWR sky130_fd_sc_hd__fill_1
XFILLER_0_133_559 VGND VGND VPWR VPWR sky130_fd_sc_hd__fill_1
XFILLER_0_105_239 VGND VGND VPWR VPWR sky130_fd_sc_hd__decap_3
X_08136_ _02526_ VGND VGND VPWR VPWR _02527_ sky130_fd_sc_hd__inv_2
XFILLER_0_71_671 VGND VGND VPWR VPWR sky130_fd_sc_hd__fill_1
XFILLER_0_7_297 VGND VGND VPWR VPWR sky130_fd_sc_hd__fill_2
XFILLER_0_31_502 VGND VGND VPWR VPWR sky130_fd_sc_hd__fill_2
XFILLER_0_43_351 VGND VGND VPWR VPWR sky130_fd_sc_hd__fill_1
X_08067_ reg_pc\[16\] decoded_imm\[16\] _02443_ VGND VGND VPWR VPWR _02463_ sky130_fd_sc_hd__a21oi_1
XFILLER_0_31_546 VGND VGND VPWR VPWR sky130_fd_sc_hd__decap_4
XFILLER_0_31_557 VGND VGND VPWR VPWR sky130_fd_sc_hd__decap_3
X_08969_ reg_out\[22\] reg_next_pc\[22\] _03270_ VGND VGND VPWR VPWR _03271_ sky130_fd_sc_hd__mux2_1
X_11980_ count_instr\[50\] count_instr\[47\] _05645_ _05652_ VGND VGND VPWR VPWR _05654_
+ sky130_fd_sc_hd__and4_1
X_10931_ _05043_ net1498 _05027_ VGND VGND VPWR VPWR _05044_ sky130_fd_sc_hd__mux2_1
X_13650_ cpuregs\[6\]\[26\] cpuregs\[7\]\[26\] _06842_ VGND VGND VPWR VPWR _07123_
+ sky130_fd_sc_hd__mux2_1
XPHY_210 VGND VGND VPWR VPWR sky130_fd_sc_hd__decap_3
XFILLER_0_14_29 VGND VGND VPWR VPWR sky130_fd_sc_hd__decap_4
X_10862_ _03483_ VGND VGND VPWR VPWR _04997_ sky130_fd_sc_hd__clkbuf_4
XPHY_243 VGND VGND VPWR VPWR sky130_fd_sc_hd__decap_3
XPHY_232 VGND VGND VPWR VPWR sky130_fd_sc_hd__decap_3
X_13581_ _07056_ VGND VGND VPWR VPWR _00829_ sky130_fd_sc_hd__clkbuf_1
XPHY_221 VGND VGND VPWR VPWR sky130_fd_sc_hd__decap_3
X_12601_ count_cycle\[29\] _06165_ net549 VGND VGND VPWR VPWR _06169_ sky130_fd_sc_hd__a21oi_1
X_10793_ _04956_ VGND VGND VPWR VPWR _00141_ sky130_fd_sc_hd__clkbuf_1
XPHY_276 VGND VGND VPWR VPWR sky130_fd_sc_hd__decap_3
XPHY_265 VGND VGND VPWR VPWR sky130_fd_sc_hd__decap_3
XPHY_254 VGND VGND VPWR VPWR sky130_fd_sc_hd__decap_3
X_12532_ count_cycle\[7\] _06110_ _06118_ count_cycle\[10\] VGND VGND VPWR VPWR _06120_
+ sky130_fd_sc_hd__a31o_1
X_15320_ _02046_ VGND VGND VPWR VPWR _01513_ sky130_fd_sc_hd__clkbuf_1
XFILLER_0_26_307 VGND VGND VPWR VPWR sky130_fd_sc_hd__fill_1
XFILLER_0_38_156 VGND VGND VPWR VPWR sky130_fd_sc_hd__fill_2
XFILLER_0_124_515 VGND VGND VPWR VPWR sky130_fd_sc_hd__fill_1
X_12463_ _05852_ net438 _05526_ _06065_ VGND VGND VPWR VPWR _00702_ sky130_fd_sc_hd__o211a_1
X_15251_ net489 VGND VGND VPWR VPWR _02011_ sky130_fd_sc_hd__clkbuf_1
X_11414_ _05317_ VGND VGND VPWR VPWR _00401_ sky130_fd_sc_hd__clkbuf_1
XFILLER_0_50_811 VGND VGND VPWR VPWR sky130_fd_sc_hd__fill_1
X_14202_ _07525_ VGND VGND VPWR VPWR _00960_ sky130_fd_sc_hd__clkbuf_1
X_12394_ _05852_ net434 _05816_ _06002_ VGND VGND VPWR VPWR _00696_ sky130_fd_sc_hd__o211a_1
X_15182_ _01975_ VGND VGND VPWR VPWR _01446_ sky130_fd_sc_hd__clkbuf_1
XFILLER_0_104_261 VGND VGND VPWR VPWR sky130_fd_sc_hd__decap_3
X_11345_ _05012_ net1585 _05277_ VGND VGND VPWR VPWR _05281_ sky130_fd_sc_hd__mux2_1
X_14133_ _07486_ VGND VGND VPWR VPWR _00930_ sky130_fd_sc_hd__clkbuf_1
XFILLER_0_10_719 VGND VGND VPWR VPWR sky130_fd_sc_hd__fill_2
X_11276_ net677 _05188_ _05240_ VGND VGND VPWR VPWR _05244_ sky130_fd_sc_hd__mux2_1
X_14064_ _07448_ VGND VGND VPWR VPWR _00900_ sky130_fd_sc_hd__clkbuf_1
XFILLER_0_120_776 VGND VGND VPWR VPWR sky130_fd_sc_hd__fill_1
X_10227_ _04441_ _04444_ _02152_ VGND VGND VPWR VPWR _04445_ sky130_fd_sc_hd__a21oi_1
X_13015_ _06417_ _06502_ _06506_ _06428_ VGND VGND VPWR VPWR _06507_ sky130_fd_sc_hd__o211a_1
X_10158_ _04376_ _04377_ _02156_ VGND VGND VPWR VPWR _04378_ sky130_fd_sc_hd__mux2_1
X_14966_ _01860_ VGND VGND VPWR VPWR _01345_ sky130_fd_sc_hd__clkbuf_1
X_10089_ cpuregs\[0\]\[14\] cpuregs\[1\]\[14\] _03980_ VGND VGND VPWR VPWR _04311_
+ sky130_fd_sc_hd__mux2_1
X_16705_ clknet_leaf_93_clk _01272_ VGND VGND VPWR VPWR cpuregs\[3\]\[19\] sky130_fd_sc_hd__dfxtp_1
X_13917_ net408 _07358_ _07329_ _02172_ VGND VGND VPWR VPWR _00854_ sky130_fd_sc_hd__a22o_1
X_14897_ _03629_ net997 _01815_ VGND VGND VPWR VPWR _01824_ sky130_fd_sc_hd__mux2_1
XFILLER_0_77_719 VGND VGND VPWR VPWR sky130_fd_sc_hd__decap_3
XFILLER_0_76_218 VPWR VGND VPWR VGND sky130_ef_sc_hd__decap_12
X_16636_ clknet_leaf_18_clk _01203_ VGND VGND VPWR VPWR cpuregs\[23\]\[14\] sky130_fd_sc_hd__dfxtp_1
X_13848_ _07308_ VGND VGND VPWR VPWR _01093_ sky130_fd_sc_hd__clkbuf_1
X_13779_ cpuregs\[22\]\[30\] cpuregs\[23\]\[30\] _06386_ VGND VGND VPWR VPWR _07248_
+ sky130_fd_sc_hd__mux2_1
X_16567_ clknet_leaf_93_clk _01144_ VGND VGND VPWR VPWR cpuregs\[24\]\[19\] sky130_fd_sc_hd__dfxtp_1
XFILLER_0_57_432 VGND VGND VPWR VPWR sky130_fd_sc_hd__decap_3
XFILLER_0_85_785 VGND VGND VPWR VPWR sky130_fd_sc_hd__fill_2
XFILLER_0_44_104 VGND VGND VPWR VPWR sky130_fd_sc_hd__decap_4
X_15518_ clknet_leaf_124_clk _00168_ VGND VGND VPWR VPWR cpuregs\[13\]\[4\] sky130_fd_sc_hd__dfxtp_1
XFILLER_0_115_515 VGND VGND VPWR VPWR sky130_fd_sc_hd__fill_1
X_16498_ clknet_leaf_56_clk _01080_ VGND VGND VPWR VPWR cpuregs\[19\]\[19\] sky130_fd_sc_hd__dfxtp_1
X_15449_ clknet_leaf_51_clk _00099_ VGND VGND VPWR VPWR net194 sky130_fd_sc_hd__dfxtp_4
Xclkbuf_4_4_0_clk clknet_0_clk VGND VGND VPWR VPWR clknet_4_4_0_clk sky130_fd_sc_hd__clkbuf_8
XFILLER_0_25_340 VGND VGND VPWR VPWR sky130_fd_sc_hd__fill_1
XFILLER_0_111_52 VGND VGND VPWR VPWR sky130_fd_sc_hd__fill_1
XFILLER_0_88_7 VGND VGND VPWR VPWR sky130_fd_sc_hd__fill_2
Xhold403 cpuregs\[25\]\[24\] VGND VGND VPWR VPWR net761 sky130_fd_sc_hd__dlygate4sd3_1
XFILLER_0_102_209 VGND VGND VPWR VPWR sky130_fd_sc_hd__fill_1
Xhold425 cpuregs\[28\]\[15\] VGND VGND VPWR VPWR net783 sky130_fd_sc_hd__dlygate4sd3_1
Xhold436 cpuregs\[26\]\[18\] VGND VGND VPWR VPWR net794 sky130_fd_sc_hd__dlygate4sd3_1
Xhold414 cpuregs\[24\]\[17\] VGND VGND VPWR VPWR net772 sky130_fd_sc_hd__dlygate4sd3_1
XFILLER_0_20_83 VGND VGND VPWR VPWR sky130_fd_sc_hd__fill_1
XFILLER_0_96_43 VGND VGND VPWR VPWR sky130_fd_sc_hd__fill_1
XFILLER_0_96_21 VGND VGND VPWR VPWR sky130_fd_sc_hd__decap_3
Xhold458 cpuregs\[7\]\[14\] VGND VGND VPWR VPWR net816 sky130_fd_sc_hd__dlygate4sd3_1
Xhold469 mem_rdata_q\[20\] VGND VGND VPWR VPWR net827 sky130_fd_sc_hd__buf_1
X_09941_ _03901_ _04166_ _03796_ VGND VGND VPWR VPWR _04167_ sky130_fd_sc_hd__a21o_1
Xhold447 cpuregs\[8\]\[8\] VGND VGND VPWR VPWR net805 sky130_fd_sc_hd__dlygate4sd3_1
XFILLER_0_110_242 VGND VGND VPWR VPWR sky130_fd_sc_hd__decap_3
XTAP_730 VGND VPWR sky130_fd_sc_hd__tapvpwrvgnd_1
XTAP_741 VGND VPWR sky130_fd_sc_hd__tapvpwrvgnd_1
XTAP_752 VGND VPWR sky130_fd_sc_hd__tapvpwrvgnd_1
X_09872_ _03819_ VGND VGND VPWR VPWR _04100_ sky130_fd_sc_hd__clkbuf_8
X_08823_ _02737_ _03167_ _03175_ _03020_ VGND VGND VPWR VPWR alu_out\[28\] sky130_fd_sc_hd__a22o_1
Xhold1103 cpuregs\[9\]\[22\] VGND VGND VPWR VPWR net1461 sky130_fd_sc_hd__dlygate4sd3_1
Xhold1114 cpuregs\[13\]\[18\] VGND VGND VPWR VPWR net1472 sky130_fd_sc_hd__dlygate4sd3_1
XTAP_763 VGND VPWR sky130_fd_sc_hd__tapvpwrvgnd_1
XTAP_774 VGND VPWR sky130_fd_sc_hd__tapvpwrvgnd_1
XTAP_785 VGND VPWR sky130_fd_sc_hd__tapvpwrvgnd_1
X_08754_ _02975_ _03110_ _02994_ VGND VGND VPWR VPWR _03111_ sky130_fd_sc_hd__a21o_1
Xhold1158 cpuregs\[25\]\[18\] VGND VGND VPWR VPWR net1516 sky130_fd_sc_hd__dlygate4sd3_1
Xhold1125 cpuregs\[2\]\[31\] VGND VGND VPWR VPWR net1483 sky130_fd_sc_hd__dlygate4sd3_1
Xhold1147 cpuregs\[29\]\[10\] VGND VGND VPWR VPWR net1505 sky130_fd_sc_hd__dlygate4sd3_1
Xhold1136 cpuregs\[16\]\[0\] VGND VGND VPWR VPWR net1494 sky130_fd_sc_hd__dlygate4sd3_1
XTAP_796 VGND VPWR sky130_fd_sc_hd__tapvpwrvgnd_1
Xhold1169 cpuregs\[29\]\[6\] VGND VGND VPWR VPWR net1527 sky130_fd_sc_hd__dlygate4sd3_1
X_07705_ _02117_ _00001_ _02120_ _02130_ VGND VGND VPWR VPWR _02131_ sky130_fd_sc_hd__or4_2
X_08685_ _03027_ _03038_ _03047_ VGND VGND VPWR VPWR _03048_ sky130_fd_sc_hd__a21oi_1
XTAP_1907 VGND VPWR sky130_fd_sc_hd__tapvpwrvgnd_1
Xclkbuf_leaf_92_clk clknet_4_12_0_clk VGND VGND VPWR VPWR clknet_leaf_92_clk sky130_fd_sc_hd__clkbuf_16
XTAP_1929 VGND VPWR sky130_fd_sc_hd__tapvpwrvgnd_1
XTAP_1918 VGND VPWR sky130_fd_sc_hd__tapvpwrvgnd_1
XFILLER_0_48_421 VGND VGND VPWR VPWR sky130_fd_sc_hd__decap_3
XFILLER_0_48_454 VGND VGND VPWR VPWR sky130_fd_sc_hd__fill_1
X_09306_ _03554_ _03555_ _03449_ _03556_ VGND VGND VPWR VPWR _03557_ sky130_fd_sc_hd__a2bb2o_2
XFILLER_0_0_93 VGND VGND VPWR VPWR sky130_fd_sc_hd__fill_2
XFILLER_0_35_104 VGND VGND VPWR VPWR sky130_fd_sc_hd__fill_1
XFILLER_0_134_813 VPWR VGND VPWR VGND sky130_ef_sc_hd__decap_12
X_09237_ _03434_ _03493_ _03495_ _03496_ VGND VGND VPWR VPWR _03497_ sky130_fd_sc_hd__a22o_2
XFILLER_0_118_386 VGND VGND VPWR VPWR sky130_fd_sc_hd__decap_4
XFILLER_0_91_788 VGND VGND VPWR VPWR sky130_fd_sc_hd__fill_2
XFILLER_0_90_265 VGND VGND VPWR VPWR sky130_fd_sc_hd__fill_1
XFILLER_0_35_148 VGND VGND VPWR VPWR sky130_fd_sc_hd__fill_2
X_09168_ _03435_ VGND VGND VPWR VPWR _03436_ sky130_fd_sc_hd__buf_4
XFILLER_0_50_107 VGND VGND VPWR VPWR sky130_fd_sc_hd__fill_1
X_08119_ count_instr\[52\] _02233_ _02235_ _02511_ VGND VGND VPWR VPWR _02512_ sky130_fd_sc_hd__a211o_1
X_09099_ _03377_ _03378_ VGND VGND VPWR VPWR _03379_ sky130_fd_sc_hd__or2_1
X_11130_ net1229 _03603_ _05146_ VGND VGND VPWR VPWR _05151_ sky130_fd_sc_hd__mux2_1
XFILLER_0_101_220 VGND VGND VPWR VPWR sky130_fd_sc_hd__decap_4
Xhold970 cpuregs\[11\]\[4\] VGND VGND VPWR VPWR net1328 sky130_fd_sc_hd__dlygate4sd3_1
Xhold981 cpuregs\[15\]\[8\] VGND VGND VPWR VPWR net1339 sky130_fd_sc_hd__dlygate4sd3_1
Xhold992 cpuregs\[4\]\[25\] VGND VGND VPWR VPWR net1350 sky130_fd_sc_hd__dlygate4sd3_1
X_11061_ _05114_ VGND VGND VPWR VPWR _00251_ sky130_fd_sc_hd__clkbuf_1
XFILLER_0_101_275 VGND VGND VPWR VPWR sky130_fd_sc_hd__fill_1
X_10012_ cpuregs\[14\]\[12\] cpuregs\[15\]\[12\] _03898_ VGND VGND VPWR VPWR _04236_
+ sky130_fd_sc_hd__mux2_1
X_14820_ net1050 _05211_ _01778_ VGND VGND VPWR VPWR _01783_ sky130_fd_sc_hd__mux2_1
XFILLER_0_99_822 VGND VGND VPWR VPWR sky130_fd_sc_hd__fill_2
XFILLER_0_98_321 VGND VGND VPWR VPWR sky130_fd_sc_hd__fill_1
X_14751_ _01746_ VGND VGND VPWR VPWR _01244_ sky130_fd_sc_hd__clkbuf_1
Xclkbuf_leaf_83_clk clknet_4_14_0_clk VGND VGND VPWR VPWR clknet_leaf_83_clk sky130_fd_sc_hd__clkbuf_16
XFILLER_0_98_354 VGND VGND VPWR VPWR sky130_fd_sc_hd__fill_2
X_11963_ count_instr\[45\] count_instr\[44\] _05637_ VGND VGND VPWR VPWR _05642_ sky130_fd_sc_hd__and3_1
X_13702_ cpuregs\[12\]\[28\] cpuregs\[13\]\[28\] cpuregs\[14\]\[28\] cpuregs\[15\]\[28\]
+ _07027_ _06392_ VGND VGND VPWR VPWR _07173_ sky130_fd_sc_hd__mux4_1
X_14682_ net1407 _05209_ _01706_ VGND VGND VPWR VPWR _01710_ sky130_fd_sc_hd__mux2_1
X_10914_ _05032_ VGND VGND VPWR VPWR _00186_ sky130_fd_sc_hd__clkbuf_1
X_11894_ _05585_ _05589_ count_instr\[26\] VGND VGND VPWR VPWR _05592_ sky130_fd_sc_hd__a21o_1
X_13633_ cpuregs\[28\]\[25\] cpuregs\[29\]\[25\] _07018_ VGND VGND VPWR VPWR _07107_
+ sky130_fd_sc_hd__mux2_1
XFILLER_0_79_590 VGND VGND VPWR VPWR sky130_fd_sc_hd__fill_1
X_16421_ clknet_leaf_25_clk _01003_ VGND VGND VPWR VPWR decoded_imm\[26\] sky130_fd_sc_hd__dfxtp_2
X_10845_ _04981_ net1373 _04985_ VGND VGND VPWR VPWR _04986_ sky130_fd_sc_hd__mux2_1
X_16352_ clknet_leaf_89_clk _00934_ VGND VGND VPWR VPWR cpuregs\[1\]\[17\] sky130_fd_sc_hd__dfxtp_1
XFILLER_0_39_487 VGND VGND VPWR VPWR sky130_fd_sc_hd__fill_1
X_15303_ net472 VGND VGND VPWR VPWR _02037_ sky130_fd_sc_hd__clkbuf_1
X_13564_ _06969_ _07035_ _07037_ _06739_ _07039_ VGND VGND VPWR VPWR _07040_ sky130_fd_sc_hd__o311a_1
XFILLER_0_125_824 VGND VGND VPWR VPWR sky130_fd_sc_hd__fill_2
X_10776_ net635 _03451_ _04946_ VGND VGND VPWR VPWR _04948_ sky130_fd_sc_hd__mux2_1
XFILLER_0_27_638 VGND VGND VPWR VPWR sky130_fd_sc_hd__fill_2
X_13495_ cpuregs\[6\]\[21\] cpuregs\[7\]\[21\] _06842_ VGND VGND VPWR VPWR _06973_
+ sky130_fd_sc_hd__mux2_1
X_12515_ count_cycle\[4\] _06104_ count_cycle\[5\] VGND VGND VPWR VPWR _06108_ sky130_fd_sc_hd__a21o_1
X_16283_ clknet_leaf_4_clk _00868_ VGND VGND VPWR VPWR instr_slli sky130_fd_sc_hd__dfxtp_1
X_12446_ _05751_ _06034_ instr_jal VGND VGND VPWR VPWR _06050_ sky130_fd_sc_hd__a21oi_1
X_15234_ _02002_ VGND VGND VPWR VPWR _01471_ sky130_fd_sc_hd__clkbuf_1
XFILLER_0_81_298 VGND VGND VPWR VPWR sky130_fd_sc_hd__decap_4
XFILLER_0_35_671 VGND VGND VPWR VPWR sky130_fd_sc_hd__fill_1
XFILLER_0_41_129 VGND VGND VPWR VPWR sky130_fd_sc_hd__fill_1
X_15165_ net665 _03615_ _01959_ VGND VGND VPWR VPWR _01966_ sky130_fd_sc_hd__mux2_1
XFILLER_0_112_529 VGND VGND VPWR VPWR sky130_fd_sc_hd__decap_3
X_12377_ _05736_ _05986_ _05520_ VGND VGND VPWR VPWR _05987_ sky130_fd_sc_hd__mux2_1
X_11328_ _04995_ net1360 _05266_ VGND VGND VPWR VPWR _05272_ sky130_fd_sc_hd__mux2_1
X_14116_ _07477_ VGND VGND VPWR VPWR _00922_ sky130_fd_sc_hd__clkbuf_1
X_15096_ _01929_ VGND VGND VPWR VPWR _01406_ sky130_fd_sc_hd__clkbuf_1
X_14047_ _06005_ _01124_ _07420_ VGND VGND VPWR VPWR _07440_ sky130_fd_sc_hd__mux2_1
X_11259_ net591 _05171_ _05229_ VGND VGND VPWR VPWR _05235_ sky130_fd_sc_hd__mux2_1
XFILLER_0_66_46 VGND VGND VPWR VPWR sky130_fd_sc_hd__fill_1
XFILLER_0_89_321 VPWR VGND VPWR VGND sky130_ef_sc_hd__decap_12
X_15998_ clknet_leaf_10_clk _00648_ VGND VGND VPWR VPWR reg_pc\[4\] sky130_fd_sc_hd__dfxtp_2
Xclkbuf_leaf_74_clk clknet_4_15_0_clk VGND VGND VPWR VPWR clknet_leaf_74_clk sky130_fd_sc_hd__clkbuf_16
X_14949_ _03577_ net1417 _01851_ VGND VGND VPWR VPWR _01852_ sky130_fd_sc_hd__mux2_1
X_08470_ instr_sub VGND VGND VPWR VPWR _02850_ sky130_fd_sc_hd__inv_2
X_16619_ clknet_leaf_70_clk _01186_ VGND VGND VPWR VPWR cpuregs\[9\]\[29\] sky130_fd_sc_hd__dfxtp_1
XFILLER_0_58_763 VGND VGND VPWR VPWR sky130_fd_sc_hd__fill_1
XFILLER_0_9_337 VGND VGND VPWR VPWR sky130_fd_sc_hd__decap_6
XFILLER_0_18_616 VGND VGND VPWR VPWR sky130_fd_sc_hd__fill_2
XFILLER_0_134_109 VPWR VGND VPWR VGND sky130_ef_sc_hd__decap_12
XFILLER_0_72_232 VGND VGND VPWR VPWR sky130_fd_sc_hd__decap_8
XFILLER_0_72_210 VGND VGND VPWR VPWR sky130_fd_sc_hd__decap_6
XFILLER_0_57_273 VGND VGND VPWR VPWR sky130_fd_sc_hd__decap_6
XFILLER_0_127_161 VGND VGND VPWR VPWR sky130_fd_sc_hd__decap_6
XFILLER_0_122_62 VGND VGND VPWR VPWR sky130_fd_sc_hd__decap_3
XFILLER_0_73_777 VGND VGND VPWR VPWR sky130_fd_sc_hd__fill_1
XFILLER_0_31_60 VGND VGND VPWR VPWR sky130_fd_sc_hd__fill_1
X_09022_ decoded_imm_j\[19\] _01112_ _03296_ VGND VGND VPWR VPWR _03305_ sky130_fd_sc_hd__mux2_1
XFILLER_0_130_315 VGND VGND VPWR VPWR sky130_fd_sc_hd__fill_1
Xhold211 reg_pc\[4\] VGND VGND VPWR VPWR net569 sky130_fd_sc_hd__dlygate4sd3_1
Xhold200 reg_sh\[1\] VGND VGND VPWR VPWR net558 sky130_fd_sc_hd__dlygate4sd3_1
Xhold244 cpuregs\[15\]\[16\] VGND VGND VPWR VPWR net602 sky130_fd_sc_hd__dlygate4sd3_1
Xhold222 cpuregs\[14\]\[16\] VGND VGND VPWR VPWR net580 sky130_fd_sc_hd__dlygate4sd3_1
Xhold233 cpuregs\[27\]\[5\] VGND VGND VPWR VPWR net591 sky130_fd_sc_hd__dlygate4sd3_1
Xhold266 cpuregs\[19\]\[20\] VGND VGND VPWR VPWR net624 sky130_fd_sc_hd__dlygate4sd3_1
Xhold255 cpuregs\[19\]\[16\] VGND VGND VPWR VPWR net613 sky130_fd_sc_hd__dlygate4sd3_1
Xhold277 cpuregs\[30\]\[1\] VGND VGND VPWR VPWR net635 sky130_fd_sc_hd__dlygate4sd3_1
Xhold288 cpuregs\[28\]\[21\] VGND VGND VPWR VPWR net646 sky130_fd_sc_hd__dlygate4sd3_1
Xhold299 cpuregs\[30\]\[21\] VGND VGND VPWR VPWR net657 sky130_fd_sc_hd__dlygate4sd3_1
X_09924_ _04149_ _02352_ _04150_ VGND VGND VPWR VPWR _04151_ sky130_fd_sc_hd__mux2_1
XFILLER_0_0_281 VGND VGND VPWR VPWR sky130_fd_sc_hd__decap_3
X_09855_ _02082_ _04081_ _04082_ _03780_ VGND VGND VPWR VPWR _04083_ sky130_fd_sc_hd__a22o_1
XTAP_560 VGND VPWR sky130_fd_sc_hd__tapvpwrvgnd_1
X_08806_ _02605_ _03159_ VGND VGND VPWR VPWR _03160_ sky130_fd_sc_hd__and2_1
XTAP_571 VGND VPWR sky130_fd_sc_hd__tapvpwrvgnd_1
XTAP_593 VGND VPWR sky130_fd_sc_hd__tapvpwrvgnd_1
XTAP_582 VGND VPWR sky130_fd_sc_hd__tapvpwrvgnd_1
X_09786_ _03663_ _04011_ _04015_ _03685_ VGND VGND VPWR VPWR _04016_ sky130_fd_sc_hd__o211a_1
Xclkbuf_leaf_65_clk clknet_4_13_0_clk VGND VGND VPWR VPWR clknet_leaf_65_clk sky130_fd_sc_hd__clkbuf_16
X_08737_ _03090_ _03095_ VGND VGND VPWR VPWR _03096_ sky130_fd_sc_hd__or2_1
XANTENNA_106 net199 VGND VGND VPWR VPWR sky130_fd_sc_hd__diode_2
XANTENNA_128 _07519_ VGND VGND VPWR VPWR sky130_fd_sc_hd__diode_2
X_08668_ _02468_ net211 _02942_ _03031_ VGND VGND VPWR VPWR _03032_ sky130_fd_sc_hd__a31o_1
XTAP_1715 VGND VPWR sky130_fd_sc_hd__tapvpwrvgnd_1
XTAP_1704 VGND VPWR sky130_fd_sc_hd__tapvpwrvgnd_1
XFILLER_0_95_324 VGND VGND VPWR VPWR sky130_fd_sc_hd__fill_1
XANTENNA_117 clknet_0_clk VGND VGND VPWR VPWR sky130_fd_sc_hd__diode_2
XANTENNA_139 net94 VGND VGND VPWR VPWR sky130_fd_sc_hd__diode_2
XFILLER_0_138_404 VGND VGND VPWR VPWR sky130_fd_sc_hd__fill_2
XTAP_1737 VGND VPWR sky130_fd_sc_hd__tapvpwrvgnd_1
XTAP_1748 VGND VPWR sky130_fd_sc_hd__tapvpwrvgnd_1
XTAP_1726 VGND VPWR sky130_fd_sc_hd__tapvpwrvgnd_1
XFILLER_0_95_335 VGND VGND VPWR VPWR sky130_fd_sc_hd__fill_1
X_10630_ _02621_ _02646_ _03997_ VGND VGND VPWR VPWR _04837_ sky130_fd_sc_hd__mux2_1
XTAP_1759 VGND VPWR sky130_fd_sc_hd__tapvpwrvgnd_1
X_08599_ _02958_ _02959_ _02956_ VGND VGND VPWR VPWR _02969_ sky130_fd_sc_hd__a21boi_1
XFILLER_0_49_763 VGND VGND VPWR VPWR sky130_fd_sc_hd__fill_2
XFILLER_0_48_240 VGND VGND VPWR VPWR sky130_fd_sc_hd__decap_8
XFILLER_0_76_593 VGND VGND VPWR VPWR sky130_fd_sc_hd__fill_1
XFILLER_0_64_755 VGND VGND VPWR VPWR sky130_fd_sc_hd__fill_1
X_10561_ cpuregs\[16\]\[27\] cpuregs\[17\]\[27\] cpuregs\[18\]\[27\] cpuregs\[19\]\[27\]
+ _03819_ _03799_ VGND VGND VPWR VPWR _04770_ sky130_fd_sc_hd__mux4_1
X_10492_ _03863_ _04696_ _04702_ VGND VGND VPWR VPWR _04703_ sky130_fd_sc_hd__or3_2
X_12300_ decoded_imm_j\[14\] _05720_ VGND VGND VPWR VPWR _05916_ sky130_fd_sc_hd__or2_1
X_13280_ _03342_ VGND VGND VPWR VPWR _06764_ sky130_fd_sc_hd__buf_4
XFILLER_0_51_416 VGND VGND VPWR VPWR sky130_fd_sc_hd__decap_4
X_12231_ _05695_ VGND VGND VPWR VPWR _05852_ sky130_fd_sc_hd__clkbuf_4
XFILLER_0_121_348 VGND VGND VPWR VPWR sky130_fd_sc_hd__fill_1
XFILLER_0_31_140 VGND VGND VPWR VPWR sky130_fd_sc_hd__fill_1
XFILLER_0_32_663 VGND VGND VPWR VPWR sky130_fd_sc_hd__fill_1
X_12162_ _05785_ _05699_ _05786_ _05788_ VGND VGND VPWR VPWR _05789_ sky130_fd_sc_hd__a22o_1
X_16970_ clknet_leaf_71_clk _01534_ VGND VGND VPWR VPWR cpuregs\[10\]\[25\] sky130_fd_sc_hd__dfxtp_1
X_12093_ _05696_ net1539 _05725_ _05734_ VGND VGND VPWR VPWR _00663_ sky130_fd_sc_hd__o211a_1
X_11113_ net623 _03552_ _05135_ VGND VGND VPWR VPWR _05142_ sky130_fd_sc_hd__mux2_1
X_15921_ clknet_leaf_45_clk _00571_ VGND VGND VPWR VPWR cpuregs\[17\]\[23\] sky130_fd_sc_hd__dfxtp_1
X_11044_ _05105_ VGND VGND VPWR VPWR _00243_ sky130_fd_sc_hd__clkbuf_1
XFILLER_0_127_29 VGND VGND VPWR VPWR sky130_fd_sc_hd__fill_2
XFILLER_0_127_18 VGND VGND VPWR VPWR sky130_fd_sc_hd__decap_4
X_15852_ clknet_leaf_58_clk _00502_ VGND VGND VPWR VPWR cpuregs\[25\]\[18\] sky130_fd_sc_hd__dfxtp_1
Xclkbuf_leaf_56_clk clknet_4_12_0_clk VGND VGND VPWR VPWR clknet_leaf_56_clk sky130_fd_sc_hd__clkbuf_16
X_14803_ net776 _05194_ _01767_ VGND VGND VPWR VPWR _01774_ sky130_fd_sc_hd__mux2_1
X_15783_ clknet_leaf_98_clk _00433_ VGND VGND VPWR VPWR cpuregs\[26\]\[13\] sky130_fd_sc_hd__dfxtp_1
X_12995_ _06442_ _06487_ VGND VGND VPWR VPWR _06488_ sky130_fd_sc_hd__or2_1
X_14734_ _01737_ VGND VGND VPWR VPWR _01236_ sky130_fd_sc_hd__clkbuf_1
X_11946_ _05628_ _05620_ _05629_ VGND VGND VPWR VPWR _05630_ sky130_fd_sc_hd__and3b_1
XFILLER_0_52_26 VGND VGND VPWR VPWR sky130_fd_sc_hd__fill_2
X_16404_ clknet_leaf_33_clk _00986_ VGND VGND VPWR VPWR net159 sky130_fd_sc_hd__dfxtp_1
X_14665_ net1554 _05192_ _01695_ VGND VGND VPWR VPWR _01701_ sky130_fd_sc_hd__mux2_1
X_11877_ _05539_ _05579_ VGND VGND VPWR VPWR _05580_ sky130_fd_sc_hd__nor2_1
X_13616_ _06868_ _07087_ _07089_ VGND VGND VPWR VPWR _07090_ sky130_fd_sc_hd__a21o_1
X_10828_ net853 _03616_ _04968_ VGND VGND VPWR VPWR _04975_ sky130_fd_sc_hd__mux2_1
X_14596_ _01664_ VGND VGND VPWR VPWR _01171_ sky130_fd_sc_hd__clkbuf_1
X_10759_ net583 _03622_ _04929_ VGND VGND VPWR VPWR _04937_ sky130_fd_sc_hd__mux2_1
X_13547_ _06780_ _07011_ _07016_ _07023_ _06800_ VGND VGND VPWR VPWR _07024_ sky130_fd_sc_hd__a311o_1
X_16335_ clknet_leaf_119_clk _00917_ VGND VGND VPWR VPWR cpuregs\[1\]\[0\] sky130_fd_sc_hd__dfxtp_1
XFILLER_0_54_265 VPWR VGND VPWR VGND sky130_ef_sc_hd__decap_12
X_16266_ clknet_leaf_149_clk _00851_ VGND VGND VPWR VPWR instr_bltu sky130_fd_sc_hd__dfxtp_1
X_13478_ _06751_ _06952_ _06956_ _06798_ VGND VGND VPWR VPWR _06957_ sky130_fd_sc_hd__o211a_1
X_15217_ _01993_ VGND VGND VPWR VPWR _01463_ sky130_fd_sc_hd__clkbuf_1
XFILLER_0_124_197 VGND VGND VPWR VPWR sky130_fd_sc_hd__decap_6
X_12429_ _05747_ _05749_ _06022_ VGND VGND VPWR VPWR _06034_ sky130_fd_sc_hd__and3_1
XFILLER_0_77_12 VGND VGND VPWR VPWR sky130_fd_sc_hd__fill_1
X_16197_ clknet_leaf_141_clk _00814_ VGND VGND VPWR VPWR net233 sky130_fd_sc_hd__dfxtp_2
X_15148_ net892 _03563_ _01948_ VGND VGND VPWR VPWR _01957_ sky130_fd_sc_hd__mux2_1
X_15079_ _01920_ VGND VGND VPWR VPWR _01398_ sky130_fd_sc_hd__clkbuf_1
X_07970_ net552 _02232_ _02371_ VGND VGND VPWR VPWR _02372_ sky130_fd_sc_hd__a21oi_2
XFILLER_0_93_66 VGND VGND VPWR VPWR sky130_fd_sc_hd__decap_4
X_09640_ _03806_ VGND VGND VPWR VPWR _03873_ sky130_fd_sc_hd__clkbuf_8
X_09571_ _03723_ _03802_ _03804_ VGND VGND VPWR VPWR _03805_ sky130_fd_sc_hd__a21o_1
Xclkbuf_leaf_47_clk clknet_4_7_0_clk VGND VGND VPWR VPWR clknet_leaf_47_clk sky130_fd_sc_hd__clkbuf_16
X_08522_ net251 _02884_ _02850_ VGND VGND VPWR VPWR _02898_ sky130_fd_sc_hd__o21a_1
X_08453_ _02760_ _02830_ instr_bgeu VGND VGND VPWR VPWR _02834_ sky130_fd_sc_hd__o21ai_1
X_08384_ net211 VGND VGND VPWR VPWR _02765_ sky130_fd_sc_hd__inv_2
XFILLER_0_92_338 VGND VGND VPWR VPWR sky130_fd_sc_hd__decap_3
XFILLER_0_58_582 VGND VGND VPWR VPWR sky130_fd_sc_hd__decap_6
XFILLER_0_46_766 VGND VGND VPWR VPWR sky130_fd_sc_hd__fill_2
XFILLER_0_61_747 VGND VGND VPWR VPWR sky130_fd_sc_hd__decap_4
XFILLER_0_61_714 VGND VGND VPWR VPWR sky130_fd_sc_hd__fill_2
XFILLER_0_33_405 VGND VGND VPWR VPWR sky130_fd_sc_hd__decap_3
XFILLER_0_33_427 VGND VGND VPWR VPWR sky130_fd_sc_hd__fill_2
X_09005_ _03295_ VGND VGND VPWR VPWR _03296_ sky130_fd_sc_hd__buf_4
XFILLER_0_103_326 VGND VGND VPWR VPWR sky130_fd_sc_hd__decap_8
XFILLER_0_60_268 VGND VGND VPWR VPWR sky130_fd_sc_hd__fill_2
XFILLER_0_111_381 VGND VGND VPWR VPWR sky130_fd_sc_hd__fill_2
X_09907_ cpuregs\[16\]\[9\] cpuregs\[17\]\[9\] cpuregs\[18\]\[9\] cpuregs\[19\]\[9\]
+ _03819_ _03799_ VGND VGND VPWR VPWR _04134_ sky130_fd_sc_hd__mux4_1
X_09838_ _03793_ _04066_ VGND VGND VPWR VPWR _04067_ sky130_fd_sc_hd__and2_1
XTAP_390 VGND VPWR sky130_fd_sc_hd__tapvpwrvgnd_1
X_09769_ _02243_ _02366_ _03997_ VGND VGND VPWR VPWR _03999_ sky130_fd_sc_hd__mux2_1
XTAP_2224 VGND VPWR sky130_fd_sc_hd__tapvpwrvgnd_1
XTAP_2235 VGND VPWR sky130_fd_sc_hd__tapvpwrvgnd_1
XTAP_2213 VGND VPWR sky130_fd_sc_hd__tapvpwrvgnd_1
XTAP_2202 VGND VPWR sky130_fd_sc_hd__tapvpwrvgnd_1
Xclkbuf_leaf_38_clk clknet_4_5_0_clk VGND VGND VPWR VPWR clknet_leaf_38_clk sky130_fd_sc_hd__clkbuf_16
X_11800_ _05521_ _05522_ _05523_ VGND VGND VPWR VPWR _05524_ sky130_fd_sc_hd__and3b_1
XTAP_2268 VGND VPWR sky130_fd_sc_hd__tapvpwrvgnd_1
XTAP_2257 VGND VPWR sky130_fd_sc_hd__tapvpwrvgnd_1
XTAP_2246 VGND VPWR sky130_fd_sc_hd__tapvpwrvgnd_1
XTAP_1523 VGND VPWR sky130_fd_sc_hd__tapvpwrvgnd_1
XTAP_1512 VGND VPWR sky130_fd_sc_hd__tapvpwrvgnd_1
XTAP_1501 VGND VPWR sky130_fd_sc_hd__tapvpwrvgnd_1
X_12780_ _06304_ VGND VGND VPWR VPWR _00780_ sky130_fd_sc_hd__clkbuf_1
XPHY_30 VGND VGND VPWR VPWR sky130_fd_sc_hd__decap_3
XTAP_2279 VGND VPWR sky130_fd_sc_hd__tapvpwrvgnd_1
XFILLER_0_95_165 VGND VGND VPWR VPWR sky130_fd_sc_hd__decap_3
XFILLER_0_95_154 VGND VGND VPWR VPWR sky130_fd_sc_hd__fill_1
XTAP_1567 VGND VPWR sky130_fd_sc_hd__tapvpwrvgnd_1
XTAP_1556 VGND VPWR sky130_fd_sc_hd__tapvpwrvgnd_1
XTAP_1534 VGND VPWR sky130_fd_sc_hd__tapvpwrvgnd_1
XTAP_1545 VGND VPWR sky130_fd_sc_hd__tapvpwrvgnd_1
XPHY_41 VGND VGND VPWR VPWR sky130_fd_sc_hd__decap_3
XPHY_52 VGND VGND VPWR VPWR sky130_fd_sc_hd__decap_3
XPHY_63 VGND VGND VPWR VPWR sky130_fd_sc_hd__decap_3
XPHY_74 VGND VGND VPWR VPWR sky130_fd_sc_hd__decap_3
XFILLER_0_37_711 VGND VGND VPWR VPWR sky130_fd_sc_hd__fill_1
X_11731_ _04989_ net1609 _05483_ VGND VGND VPWR VPWR _05486_ sky130_fd_sc_hd__mux2_1
XTAP_1589 VGND VPWR sky130_fd_sc_hd__tapvpwrvgnd_1
XTAP_1578 VGND VPWR sky130_fd_sc_hd__tapvpwrvgnd_1
X_14450_ _01575_ VGND VGND VPWR VPWR _01587_ sky130_fd_sc_hd__buf_4
XPHY_96 VGND VGND VPWR VPWR sky130_fd_sc_hd__decap_3
X_11662_ _05449_ VGND VGND VPWR VPWR _00517_ sky130_fd_sc_hd__clkbuf_1
XFILLER_0_22_29 VPWR VGND VPWR VGND sky130_ef_sc_hd__decap_12
XPHY_85 VGND VGND VPWR VPWR sky130_fd_sc_hd__decap_3
XFILLER_0_138_289 VGND VGND VPWR VPWR sky130_fd_sc_hd__fill_2
X_10613_ cpuregs\[28\]\[28\] cpuregs\[29\]\[28\] _03797_ VGND VGND VPWR VPWR _04821_
+ sky130_fd_sc_hd__mux2_1
X_13401_ _06631_ _06874_ _06881_ VGND VGND VPWR VPWR _06882_ sky130_fd_sc_hd__or3_2
XFILLER_0_64_563 VGND VGND VPWR VPWR sky130_fd_sc_hd__fill_1
X_11593_ _04987_ net786 _05411_ VGND VGND VPWR VPWR _05413_ sky130_fd_sc_hd__mux2_1
X_14381_ _01550_ VGND VGND VPWR VPWR _01038_ sky130_fd_sc_hd__clkbuf_1
X_10544_ _04721_ _04725_ _04722_ VGND VGND VPWR VPWR _04753_ sky130_fd_sc_hd__a21bo_1
X_13332_ cpuregs\[0\]\[16\] cpuregs\[1\]\[16\] cpuregs\[2\]\[16\] cpuregs\[3\]\[16\]
+ _06740_ _06708_ VGND VGND VPWR VPWR _06815_ sky130_fd_sc_hd__mux4_1
X_16120_ clknet_leaf_0_clk _00770_ VGND VGND VPWR VPWR count_cycle\[63\] sky130_fd_sc_hd__dfxtp_1
X_16051_ clknet_leaf_34_clk _00701_ VGND VGND VPWR VPWR reg_next_pc\[26\] sky130_fd_sc_hd__dfxtp_1
X_10475_ decoded_imm\[25\] net188 VGND VGND VPWR VPWR _04686_ sky130_fd_sc_hd__or2_1
XFILLER_0_106_197 VPWR VGND VPWR VGND sky130_ef_sc_hd__decap_12
X_13263_ cpuregs\[22\]\[14\] cpuregs\[23\]\[14\] _06450_ VGND VGND VPWR VPWR _06748_
+ sky130_fd_sc_hd__mux2_1
XFILLER_0_121_145 VPWR VGND VPWR VGND sky130_ef_sc_hd__decap_12
X_12214_ _05706_ _05818_ VGND VGND VPWR VPWR _05837_ sky130_fd_sc_hd__nand2_1
X_13194_ cpuregs\[20\]\[12\] cpuregs\[21\]\[12\] _06448_ VGND VGND VPWR VPWR _06681_
+ sky130_fd_sc_hd__mux2_1
X_15002_ _03532_ net1441 _01876_ VGND VGND VPWR VPWR _01880_ sky130_fd_sc_hd__mux2_1
XFILLER_0_138_17 VGND VGND VPWR VPWR sky130_fd_sc_hd__fill_2
XFILLER_0_130_690 VGND VGND VPWR VPWR sky130_fd_sc_hd__decap_3
X_12145_ _02165_ VGND VGND VPWR VPWR _05773_ sky130_fd_sc_hd__clkbuf_4
X_12076_ latched_branch latched_store _03540_ VGND VGND VPWR VPWR _05722_ sky130_fd_sc_hd__and3_1
X_16953_ clknet_leaf_114_clk _01517_ VGND VGND VPWR VPWR cpuregs\[10\]\[8\] sky130_fd_sc_hd__dfxtp_1
X_15904_ clknet_leaf_145_clk _00554_ VGND VGND VPWR VPWR cpuregs\[17\]\[6\] sky130_fd_sc_hd__dfxtp_1
X_16884_ clknet_leaf_120_clk _01448_ VGND VGND VPWR VPWR cpuregs\[8\]\[3\] sky130_fd_sc_hd__dfxtp_1
X_11027_ _05096_ VGND VGND VPWR VPWR _00235_ sky130_fd_sc_hd__clkbuf_1
X_15835_ clknet_leaf_144_clk _00485_ VGND VGND VPWR VPWR cpuregs\[25\]\[1\] sky130_fd_sc_hd__dfxtp_1
Xclkbuf_leaf_29_clk clknet_4_4_0_clk VGND VGND VPWR VPWR clknet_leaf_29_clk sky130_fd_sc_hd__clkbuf_16
X_15766_ clknet_leaf_68_clk _00416_ VGND VGND VPWR VPWR cpuregs\[15\]\[28\] sky130_fd_sc_hd__dfxtp_1
XFILLER_0_87_633 VGND VGND VPWR VPWR sky130_fd_sc_hd__fill_1
X_12978_ _06471_ net250 _06375_ VGND VGND VPWR VPWR _06472_ sky130_fd_sc_hd__mux2_1
X_15697_ clknet_leaf_45_clk _00347_ VGND VGND VPWR VPWR cpuregs\[27\]\[23\] sky130_fd_sc_hd__dfxtp_1
X_11929_ net429 _05614_ _05533_ VGND VGND VPWR VPWR _05617_ sky130_fd_sc_hd__o21ai_1
X_14717_ _01728_ VGND VGND VPWR VPWR _01228_ sky130_fd_sc_hd__clkbuf_1
X_14648_ net956 _05175_ _01684_ VGND VGND VPWR VPWR _01692_ sky130_fd_sc_hd__mux2_1
XFILLER_0_138_790 VPWR VGND VPWR VGND sky130_ef_sc_hd__decap_12
XANTENNA_28 _04392_ VGND VGND VPWR VPWR sky130_fd_sc_hd__diode_2
XANTENNA_17 _03795_ VGND VGND VPWR VPWR sky130_fd_sc_hd__diode_2
XANTENNA_39 net4 VGND VGND VPWR VPWR sky130_fd_sc_hd__diode_2
XFILLER_0_55_541 VGND VGND VPWR VPWR sky130_fd_sc_hd__decap_4
X_16318_ clknet_leaf_27_clk _00903_ VGND VGND VPWR VPWR decoded_imm_j\[16\] sky130_fd_sc_hd__dfxtp_1
X_14579_ _01655_ VGND VGND VPWR VPWR _01163_ sky130_fd_sc_hd__clkbuf_1
XFILLER_0_113_602 VGND VGND VPWR VPWR sky130_fd_sc_hd__fill_1
XFILLER_0_140_421 VGND VGND VPWR VPWR sky130_fd_sc_hd__fill_1
X_16249_ clknet_leaf_40_clk alu_out\[22\] VGND VGND VPWR VPWR alu_out_q\[22\] sky130_fd_sc_hd__dfxtp_1
XFILLER_0_88_22 VGND VGND VPWR VPWR sky130_fd_sc_hd__fill_2
XFILLER_0_70_7 VGND VGND VPWR VPWR sky130_fd_sc_hd__fill_1
Xoutput102 net102 VGND VGND VPWR VPWR mem_la_wdata[14] sky130_fd_sc_hd__clkbuf_4
Xoutput113 net113 VGND VGND VPWR VPWR mem_la_wdata[24] sky130_fd_sc_hd__clkbuf_4
XFILLER_0_2_354 VGND VGND VPWR VPWR sky130_fd_sc_hd__fill_1
Xoutput124 net124 VGND VGND VPWR VPWR mem_la_wdata[5] sky130_fd_sc_hd__clkbuf_4
Xoutput157 net157 VGND VGND VPWR VPWR mem_wdata[2] sky130_fd_sc_hd__clkbuf_4
Xoutput146 net146 VGND VGND VPWR VPWR mem_wdata[1] sky130_fd_sc_hd__clkbuf_4
XFILLER_0_63_6 VGND VGND VPWR VPWR sky130_fd_sc_hd__decap_3
Xoutput168 net168 VGND VGND VPWR VPWR mem_wstrb[1] sky130_fd_sc_hd__clkbuf_4
Xoutput135 net135 VGND VGND VPWR VPWR mem_wdata[0] sky130_fd_sc_hd__clkbuf_4
Xoutput179 net179 VGND VGND VPWR VPWR pcpi_rs1[17] sky130_fd_sc_hd__clkbuf_4
X_07953_ _02346_ _02356_ VGND VGND VPWR VPWR _07649_ sky130_fd_sc_hd__nor2_1
XFILLER_0_128_72 VGND VGND VPWR VPWR sky130_fd_sc_hd__decap_4
X_07884_ _02289_ _02290_ _02291_ VGND VGND VPWR VPWR _02292_ sky130_fd_sc_hd__o21ai_1
X_09623_ _03788_ _03789_ _03790_ VGND VGND VPWR VPWR _03856_ sky130_fd_sc_hd__o21a_1
X_09554_ _03705_ _03782_ _03787_ VGND VGND VPWR VPWR _03788_ sky130_fd_sc_hd__o21a_1
XFILLER_0_77_165 VGND VGND VPWR VPWR sky130_fd_sc_hd__decap_3
X_08505_ _02867_ _02877_ _02878_ _02882_ VGND VGND VPWR VPWR alu_out\[3\] sky130_fd_sc_hd__a31o_1
X_09485_ _03719_ VGND VGND VPWR VPWR _03720_ sky130_fd_sc_hd__buf_4
X_08436_ net189 net221 VGND VGND VPWR VPWR _02817_ sky130_fd_sc_hd__and2b_1
XFILLER_0_19_722 VGND VGND VPWR VPWR sky130_fd_sc_hd__decap_6
X_08367_ net108 VGND VGND VPWR VPWR _02748_ sky130_fd_sc_hd__clkbuf_8
XFILLER_0_92_168 VGND VGND VPWR VPWR sky130_fd_sc_hd__decap_4
XFILLER_0_61_500 VGND VGND VPWR VPWR sky130_fd_sc_hd__decap_4
XFILLER_0_18_276 VGND VGND VPWR VPWR sky130_fd_sc_hd__decap_4
XFILLER_0_18_287 VGND VGND VPWR VPWR sky130_fd_sc_hd__decap_4
X_08298_ _02677_ _02678_ VGND VGND VPWR VPWR _02679_ sky130_fd_sc_hd__nand2_1
XFILLER_0_131_432 VGND VGND VPWR VPWR sky130_fd_sc_hd__fill_2
XFILLER_0_131_410 VGND VGND VPWR VPWR sky130_fd_sc_hd__fill_1
XFILLER_0_103_101 VGND VGND VPWR VPWR sky130_fd_sc_hd__decap_8
XFILLER_0_103_145 VGND VGND VPWR VPWR sky130_fd_sc_hd__decap_4
X_10260_ _04475_ _04476_ VGND VGND VPWR VPWR _04477_ sky130_fd_sc_hd__nor2_1
XFILLER_0_42_780 VGND VGND VPWR VPWR sky130_fd_sc_hd__fill_1
X_10191_ cpuregs\[14\]\[17\] cpuregs\[15\]\[17\] _03665_ VGND VGND VPWR VPWR _04410_
+ sky130_fd_sc_hd__mux2_1
XFILLER_0_17_18 VGND VGND VPWR VPWR sky130_fd_sc_hd__decap_4
X_13950_ _07379_ VGND VGND VPWR VPWR _00866_ sky130_fd_sc_hd__clkbuf_1
XFILLER_0_88_408 VPWR VGND VPWR VGND sky130_ef_sc_hd__decap_12
X_12901_ cpuregs\[16\]\[1\] cpuregs\[17\]\[1\] _03336_ VGND VGND VPWR VPWR _06399_
+ sky130_fd_sc_hd__mux2_1
XTAP_2010 VGND VPWR sky130_fd_sc_hd__tapvpwrvgnd_1
X_15620_ clknet_leaf_134_clk _00270_ VGND VGND VPWR VPWR cpuregs\[31\]\[10\] sky130_fd_sc_hd__dfxtp_1
X_13881_ _02140_ VGND VGND VPWR VPWR _07332_ sky130_fd_sc_hd__clkbuf_2
XTAP_2043 VGND VPWR sky130_fd_sc_hd__tapvpwrvgnd_1
XTAP_2021 VGND VPWR sky130_fd_sc_hd__tapvpwrvgnd_1
XTAP_2032 VGND VPWR sky130_fd_sc_hd__tapvpwrvgnd_1
X_12832_ _02154_ mem_do_prefetch _06330_ VGND VGND VPWR VPWR _06334_ sky130_fd_sc_hd__mux2_1
XTAP_2076 VGND VPWR sky130_fd_sc_hd__tapvpwrvgnd_1
XTAP_2065 VGND VPWR sky130_fd_sc_hd__tapvpwrvgnd_1
XTAP_2054 VGND VPWR sky130_fd_sc_hd__tapvpwrvgnd_1
XTAP_1331 VGND VPWR sky130_fd_sc_hd__tapvpwrvgnd_1
XTAP_1320 VGND VPWR sky130_fd_sc_hd__tapvpwrvgnd_1
X_12763_ _06295_ VGND VGND VPWR VPWR _00772_ sky130_fd_sc_hd__clkbuf_1
X_15551_ clknet_leaf_131_clk _00201_ VGND VGND VPWR VPWR cpuregs\[2\]\[5\] sky130_fd_sc_hd__dfxtp_1
XTAP_2098 VGND VPWR sky130_fd_sc_hd__tapvpwrvgnd_1
XTAP_2087 VGND VPWR sky130_fd_sc_hd__tapvpwrvgnd_1
X_11714_ _05476_ VGND VGND VPWR VPWR _00542_ sky130_fd_sc_hd__clkbuf_1
XFILLER_0_83_113 VGND VGND VPWR VPWR sky130_fd_sc_hd__decap_4
XTAP_1375 VGND VPWR sky130_fd_sc_hd__tapvpwrvgnd_1
XTAP_1353 VGND VPWR sky130_fd_sc_hd__tapvpwrvgnd_1
XTAP_1364 VGND VPWR sky130_fd_sc_hd__tapvpwrvgnd_1
XTAP_1342 VGND VPWR sky130_fd_sc_hd__tapvpwrvgnd_1
XFILLER_0_68_176 VGND VGND VPWR VPWR sky130_fd_sc_hd__fill_2
XFILLER_0_56_338 VGND VGND VPWR VPWR sky130_fd_sc_hd__decap_8
X_15482_ clknet_leaf_125_clk _00132_ VGND VGND VPWR VPWR cpuregs\[30\]\[0\] sky130_fd_sc_hd__dfxtp_1
X_14502_ net688 _05165_ _01612_ VGND VGND VPWR VPWR _01615_ sky130_fd_sc_hd__mux2_1
XFILLER_0_127_727 VGND VGND VPWR VPWR sky130_fd_sc_hd__fill_1
XTAP_1397 VGND VPWR sky130_fd_sc_hd__tapvpwrvgnd_1
XTAP_1386 VGND VPWR sky130_fd_sc_hd__tapvpwrvgnd_1
X_14433_ _01578_ VGND VGND VPWR VPWR _01062_ sky130_fd_sc_hd__clkbuf_1
X_12694_ _06234_ _05523_ _06235_ VGND VGND VPWR VPWR _06236_ sky130_fd_sc_hd__and3b_1
X_11645_ _05039_ net975 _05433_ VGND VGND VPWR VPWR _05440_ sky130_fd_sc_hd__mux2_1
XFILLER_0_25_703 VGND VGND VPWR VPWR sky130_fd_sc_hd__fill_1
X_11576_ _05403_ VGND VGND VPWR VPWR _00477_ sky130_fd_sc_hd__clkbuf_1
Xinput15 mem_rdata[22] VGND VGND VPWR VPWR net15 sky130_fd_sc_hd__buf_2
X_14364_ _04987_ net1278 _07616_ VGND VGND VPWR VPWR _01542_ sky130_fd_sc_hd__mux2_1
Xinput26 mem_rdata[3] VGND VGND VPWR VPWR net26 sky130_fd_sc_hd__clkbuf_2
X_10527_ cpuregs\[0\]\[26\] cpuregs\[1\]\[26\] _03902_ VGND VGND VPWR VPWR _04737_
+ sky130_fd_sc_hd__mux2_1
X_13315_ _06751_ _06791_ _06797_ _06798_ VGND VGND VPWR VPWR _06799_ sky130_fd_sc_hd__o211a_1
X_14295_ mem_rdata_q\[28\] _07576_ VGND VGND VPWR VPWR _07578_ sky130_fd_sc_hd__and2_1
XFILLER_0_3_129 VGND VGND VPWR VPWR sky130_fd_sc_hd__decap_3
X_16103_ clknet_leaf_146_clk _00753_ VGND VGND VPWR VPWR count_cycle\[46\] sky130_fd_sc_hd__dfxtp_1
X_10458_ decoded_imm\[24\] net187 VGND VGND VPWR VPWR _04670_ sky130_fd_sc_hd__or2_1
X_16034_ clknet_leaf_26_clk _00684_ VGND VGND VPWR VPWR reg_next_pc\[9\] sky130_fd_sc_hd__dfxtp_1
X_13246_ cpuregs\[10\]\[14\] cpuregs\[11\]\[14\] _06424_ VGND VGND VPWR VPWR _06731_
+ sky130_fd_sc_hd__mux2_1
X_10389_ cpuregs\[24\]\[22\] cpuregs\[25\]\[22\] cpuregs\[26\]\[22\] cpuregs\[27\]\[22\]
+ _03935_ _04200_ VGND VGND VPWR VPWR _04603_ sky130_fd_sc_hd__mux4_1
X_13177_ cpuregs\[12\]\[12\] cpuregs\[13\]\[12\] cpuregs\[14\]\[12\] cpuregs\[15\]\[12\]
+ _06418_ _06419_ VGND VGND VPWR VPWR _06664_ sky130_fd_sc_hd__mux4_1
XFILLER_0_58_58 VGND VGND VPWR VPWR sky130_fd_sc_hd__fill_2
X_12128_ _03637_ reg_next_pc\[30\] _03224_ VGND VGND VPWR VPWR _05759_ sky130_fd_sc_hd__mux2_2
X_16936_ clknet_leaf_75_clk _01500_ VGND VGND VPWR VPWR cpuregs\[0\]\[23\] sky130_fd_sc_hd__dfxtp_1
X_12059_ _05690_ reg_pc\[9\] VGND VGND VPWR VPWR _05711_ sky130_fd_sc_hd__or2_1
X_16867_ clknet_leaf_57_clk _01431_ VGND VGND VPWR VPWR cpuregs\[22\]\[18\] sky130_fd_sc_hd__dfxtp_1
X_15818_ clknet_leaf_54_clk _00468_ VGND VGND VPWR VPWR cpuregs\[16\]\[16\] sky130_fd_sc_hd__dfxtp_1
X_16798_ clknet_leaf_102_clk _01362_ VGND VGND VPWR VPWR cpuregs\[6\]\[13\] sky130_fd_sc_hd__dfxtp_1
X_15749_ clknet_leaf_100_clk _00399_ VGND VGND VPWR VPWR cpuregs\[15\]\[11\] sky130_fd_sc_hd__dfxtp_1
XFILLER_0_90_56 VGND VGND VPWR VPWR sky130_fd_sc_hd__decap_3
X_09270_ net1166 _03525_ _03512_ VGND VGND VPWR VPWR _03526_ sky130_fd_sc_hd__mux2_1
X_08221_ _02602_ _02603_ _02606_ _02200_ VGND VGND VPWR VPWR _02607_ sky130_fd_sc_hd__a211o_1
XFILLER_0_47_349 VGND VGND VPWR VPWR sky130_fd_sc_hd__decap_8
XFILLER_0_99_21 VGND VGND VPWR VPWR sky130_fd_sc_hd__fill_2
XFILLER_0_99_10 VGND VGND VPWR VPWR sky130_fd_sc_hd__fill_2
XFILLER_0_132_207 VGND VGND VPWR VPWR sky130_fd_sc_hd__fill_1
X_08152_ reg_pc\[23\] decoded_imm\[23\] VGND VGND VPWR VPWR _02542_ sky130_fd_sc_hd__nand2_1
XFILLER_0_99_54 VGND VGND VPWR VPWR sky130_fd_sc_hd__fill_2
XFILLER_0_83_691 VGND VGND VPWR VPWR sky130_fd_sc_hd__decap_6
XFILLER_0_55_393 VGND VGND VPWR VPWR sky130_fd_sc_hd__decap_8
XFILLER_0_125_281 VGND VGND VPWR VPWR sky130_fd_sc_hd__fill_2
X_08083_ _02476_ _02477_ VGND VGND VPWR VPWR _02478_ sky130_fd_sc_hd__xnor2_1
Xclkbuf_leaf_9_clk clknet_4_1_0_clk VGND VGND VPWR VPWR clknet_leaf_9_clk sky130_fd_sc_hd__clkbuf_16
XFILLER_0_15_246 VGND VGND VPWR VPWR sky130_fd_sc_hd__fill_1
XFILLER_0_113_443 VGND VGND VPWR VPWR sky130_fd_sc_hd__decap_4
XFILLER_0_15_279 VGND VGND VPWR VPWR sky130_fd_sc_hd__fill_1
XFILLER_0_30_238 VPWR VGND VPWR VGND sky130_ef_sc_hd__decap_12
XFILLER_0_3_696 VGND VGND VPWR VPWR sky130_fd_sc_hd__fill_2
XFILLER_0_2_195 VGND VGND VPWR VPWR sky130_fd_sc_hd__fill_1
X_08985_ _02605_ _03281_ _03268_ VGND VGND VPWR VPWR _03282_ sky130_fd_sc_hd__mux2_1
X_07936_ count_instr\[40\] _02203_ count_cycle\[40\] _02237_ VGND VGND VPWR VPWR _02341_
+ sky130_fd_sc_hd__a22o_1
X_07867_ reg_pc\[4\] decoded_imm\[4\] VGND VGND VPWR VPWR _02276_ sky130_fd_sc_hd__or2_1
X_07798_ _02211_ VGND VGND VPWR VPWR net130 sky130_fd_sc_hd__buf_4
X_09606_ _03837_ _03838_ _03839_ VGND VGND VPWR VPWR _03840_ sky130_fd_sc_hd__a21o_1
X_09537_ _03677_ _03764_ _03771_ _03685_ VGND VGND VPWR VPWR _03772_ sky130_fd_sc_hd__a211o_1
XFILLER_0_38_327 VGND VGND VPWR VPWR sky130_fd_sc_hd__decap_3
XFILLER_0_108_215 VPWR VGND VPWR VGND sky130_ef_sc_hd__decap_12
X_09468_ _02132_ decoded_imm\[0\] VGND VGND VPWR VPWR _03704_ sky130_fd_sc_hd__or2_1
X_09399_ reg_out\[30\] alu_out_q\[30\] _03437_ VGND VGND VPWR VPWR _03637_ sky130_fd_sc_hd__mux2_1
XFILLER_0_93_499 VGND VGND VPWR VPWR sky130_fd_sc_hd__fill_1
XFILLER_0_81_617 VGND VGND VPWR VPWR sky130_fd_sc_hd__fill_1
X_08419_ _02682_ _02799_ VGND VGND VPWR VPWR _02800_ sky130_fd_sc_hd__nand2_1
XFILLER_0_53_308 VGND VGND VPWR VPWR sky130_fd_sc_hd__fill_1
XFILLER_0_123_218 VGND VGND VPWR VPWR sky130_fd_sc_hd__decap_6
X_11430_ net927 _05205_ _05324_ VGND VGND VPWR VPWR _05326_ sky130_fd_sc_hd__mux2_1
X_11361_ _05289_ VGND VGND VPWR VPWR _00376_ sky130_fd_sc_hd__clkbuf_1
XFILLER_0_61_352 VPWR VGND VPWR VGND sky130_ef_sc_hd__decap_12
XFILLER_0_132_741 VGND VGND VPWR VPWR sky130_fd_sc_hd__fill_1
X_10312_ _03979_ _04527_ _03731_ VGND VGND VPWR VPWR _04528_ sky130_fd_sc_hd__a21o_1
X_13100_ _06447_ _06587_ _06589_ _06453_ VGND VGND VPWR VPWR _06590_ sky130_fd_sc_hd__a211o_1
XFILLER_0_131_273 VGND VGND VPWR VPWR sky130_fd_sc_hd__decap_6
X_11292_ _05252_ VGND VGND VPWR VPWR _00344_ sky130_fd_sc_hd__clkbuf_1
XFILLER_0_14_290 VGND VGND VPWR VPWR sky130_fd_sc_hd__fill_2
X_14080_ _07456_ VGND VGND VPWR VPWR _00907_ sky130_fd_sc_hd__clkbuf_1
XFILLER_0_131_295 VPWR VGND VPWR VGND sky130_ef_sc_hd__decap_12
X_10243_ _03897_ _04458_ _04460_ VGND VGND VPWR VPWR _04461_ sky130_fd_sc_hd__a21o_1
X_13031_ _03341_ _06522_ VGND VGND VPWR VPWR _06523_ sky130_fd_sc_hd__and2_1
X_10174_ cpuregs\[24\]\[16\] cpuregs\[25\]\[16\] cpuregs\[26\]\[16\] cpuregs\[27\]\[16\]
+ _03935_ _04200_ VGND VGND VPWR VPWR _04394_ sky130_fd_sc_hd__mux4_1
X_16721_ clknet_leaf_117_clk _01285_ VGND VGND VPWR VPWR cpuregs\[4\]\[0\] sky130_fd_sc_hd__dfxtp_1
X_14982_ _01869_ VGND VGND VPWR VPWR _01352_ sky130_fd_sc_hd__clkbuf_1
X_13933_ _07324_ VGND VGND VPWR VPWR _07367_ sky130_fd_sc_hd__clkbuf_4
X_16652_ clknet_leaf_57_clk _01219_ VGND VGND VPWR VPWR cpuregs\[23\]\[30\] sky130_fd_sc_hd__dfxtp_1
XFILLER_0_44_38 VGND VGND VPWR VPWR sky130_fd_sc_hd__fill_1
X_13864_ _07318_ _01097_ _07316_ VGND VGND VPWR VPWR _07319_ sky130_fd_sc_hd__and3_1
XFILLER_0_44_27 VGND VGND VPWR VPWR sky130_fd_sc_hd__fill_1
X_15603_ clknet_leaf_67_clk _00253_ VGND VGND VPWR VPWR cpuregs\[28\]\[25\] sky130_fd_sc_hd__dfxtp_1
X_12815_ _06322_ VGND VGND VPWR VPWR _00797_ sky130_fd_sc_hd__clkbuf_1
XFILLER_0_69_452 VGND VGND VPWR VPWR sky130_fd_sc_hd__decap_4
XFILLER_0_57_603 VGND VGND VPWR VPWR sky130_fd_sc_hd__fill_1
X_16583_ clknet_leaf_6_clk _00017_ VGND VGND VPWR VPWR cpu_state\[0\] sky130_fd_sc_hd__dfxtp_1
X_15534_ clknet_leaf_83_clk _00184_ VGND VGND VPWR VPWR cpuregs\[13\]\[20\] sky130_fd_sc_hd__dfxtp_1
XFILLER_0_84_411 VGND VGND VPWR VPWR sky130_fd_sc_hd__decap_8
X_13795_ _03340_ _07262_ _06998_ VGND VGND VPWR VPWR _07263_ sky130_fd_sc_hd__a21o_1
XTAP_1150 VGND VPWR sky130_fd_sc_hd__tapvpwrvgnd_1
XFILLER_0_56_102 VGND VGND VPWR VPWR sky130_fd_sc_hd__decap_4
XFILLER_0_127_513 VGND VGND VPWR VPWR sky130_fd_sc_hd__fill_1
X_12746_ _03723_ _06277_ _06279_ _03675_ VGND VGND VPWR VPWR _06280_ sky130_fd_sc_hd__a211o_1
XTAP_1183 VGND VPWR sky130_fd_sc_hd__tapvpwrvgnd_1
XTAP_1161 VGND VPWR sky130_fd_sc_hd__tapvpwrvgnd_1
XTAP_1172 VGND VPWR sky130_fd_sc_hd__tapvpwrvgnd_1
X_15465_ clknet_leaf_85_clk _00115_ VGND VGND VPWR VPWR cpuregs\[12\]\[15\] sky130_fd_sc_hd__dfxtp_1
XFILLER_0_84_477 VGND VGND VPWR VPWR sky130_fd_sc_hd__decap_3
XFILLER_0_72_617 VGND VGND VPWR VPWR sky130_fd_sc_hd__fill_2
XTAP_1194 VGND VPWR sky130_fd_sc_hd__tapvpwrvgnd_1
X_12677_ _06222_ _06179_ _06223_ VGND VGND VPWR VPWR _06224_ sky130_fd_sc_hd__and3b_1
X_14416_ _05039_ net949 _01562_ VGND VGND VPWR VPWR _01569_ sky130_fd_sc_hd__mux2_1
X_11628_ _05022_ net1516 _05422_ VGND VGND VPWR VPWR _05431_ sky130_fd_sc_hd__mux2_1
X_15396_ clknet_leaf_106_clk _00051_ VGND VGND VPWR VPWR cpuregs\[11\]\[14\] sky130_fd_sc_hd__dfxtp_1
XFILLER_0_114_229 VGND VGND VPWR VPWR sky130_fd_sc_hd__decap_8
XFILLER_0_107_281 VGND VGND VPWR VPWR sky130_fd_sc_hd__fill_2
XFILLER_0_69_13 VGND VGND VPWR VPWR sky130_fd_sc_hd__fill_2
X_14347_ net1654 _07459_ _07606_ VGND VGND VPWR VPWR _01024_ sky130_fd_sc_hd__o21a_1
XFILLER_0_4_438 VGND VGND VPWR VPWR sky130_fd_sc_hd__fill_2
Xhold618 cpuregs\[7\]\[28\] VGND VGND VPWR VPWR net976 sky130_fd_sc_hd__dlygate4sd3_1
X_11559_ _05394_ VGND VGND VPWR VPWR _00469_ sky130_fd_sc_hd__clkbuf_1
Xhold607 cpuregs\[17\]\[13\] VGND VGND VPWR VPWR net965 sky130_fd_sc_hd__dlygate4sd3_1
XFILLER_0_123_785 VGND VGND VPWR VPWR sky130_fd_sc_hd__fill_2
XFILLER_0_100_54 VGND VGND VPWR VPWR sky130_fd_sc_hd__fill_2
XFILLER_0_100_32 VGND VGND VPWR VPWR sky130_fd_sc_hd__fill_2
Xhold629 cpuregs\[31\]\[13\] VGND VGND VPWR VPWR net987 sky130_fd_sc_hd__dlygate4sd3_1
X_14278_ reg_sh\[0\] _03653_ net558 VGND VGND VPWR VPWR _07565_ sky130_fd_sc_hd__o21a_1
X_16017_ clknet_leaf_32_clk _00667_ VGND VGND VPWR VPWR reg_pc\[23\] sky130_fd_sc_hd__dfxtp_2
X_13229_ cpuregs\[20\]\[13\] cpuregs\[21\]\[13\] _06448_ VGND VGND VPWR VPWR _06715_
+ sky130_fd_sc_hd__mux2_1
XTAP_901 VGND VPWR sky130_fd_sc_hd__tapvpwrvgnd_1
XTAP_934 VGND VPWR sky130_fd_sc_hd__tapvpwrvgnd_1
XFILLER_0_20_293 VGND VGND VPWR VPWR sky130_fd_sc_hd__fill_2
XTAP_912 VGND VPWR sky130_fd_sc_hd__tapvpwrvgnd_1
XTAP_923 VGND VPWR sky130_fd_sc_hd__tapvpwrvgnd_1
XTAP_967 VGND VPWR sky130_fd_sc_hd__tapvpwrvgnd_1
XTAP_978 VGND VPWR sky130_fd_sc_hd__tapvpwrvgnd_1
XTAP_956 VGND VPWR sky130_fd_sc_hd__tapvpwrvgnd_1
XTAP_945 VGND VPWR sky130_fd_sc_hd__tapvpwrvgnd_1
Xhold1307 count_cycle\[47\] VGND VGND VPWR VPWR net1665 sky130_fd_sc_hd__dlygate4sd3_1
X_08770_ _02762_ _02771_ _03064_ _03085_ VGND VGND VPWR VPWR _03127_ sky130_fd_sc_hd__and4_1
XTAP_989 VGND VPWR sky130_fd_sc_hd__tapvpwrvgnd_1
X_16919_ clknet_leaf_115_clk _01483_ VGND VGND VPWR VPWR cpuregs\[0\]\[6\] sky130_fd_sc_hd__dfxtp_1
XFILLER_0_26_6 VPWR VGND VPWR VGND sky130_ef_sc_hd__decap_12
X_07721_ instr_slt instr_slti net564 VGND VGND VPWR VPWR _02145_ sky130_fd_sc_hd__or3_1
X_07652_ _02081_ VGND VGND VPWR VPWR _02082_ sky130_fd_sc_hd__buf_4
XFILLER_0_95_709 VGND VGND VPWR VPWR sky130_fd_sc_hd__fill_2
XFILLER_0_87_260 VGND VGND VPWR VPWR sky130_fd_sc_hd__decap_4
X_09322_ _03570_ VGND VGND VPWR VPWR _03571_ sky130_fd_sc_hd__buf_2
XFILLER_0_47_146 VPWR VGND VPWR VGND sky130_ef_sc_hd__decap_12
XFILLER_0_63_617 VGND VGND VPWR VPWR sky130_fd_sc_hd__fill_1
X_09253_ _03510_ VGND VGND VPWR VPWR _03511_ sky130_fd_sc_hd__clkbuf_4
XFILLER_0_8_755 VGND VGND VPWR VPWR sky130_fd_sc_hd__fill_1
XFILLER_0_7_232 VGND VGND VPWR VPWR sky130_fd_sc_hd__fill_1
X_08204_ _02587_ _02589_ VGND VGND VPWR VPWR _02591_ sky130_fd_sc_hd__or2_1
X_09184_ _03450_ VGND VGND VPWR VPWR _03451_ sky130_fd_sc_hd__clkbuf_4
XFILLER_0_105_229 VGND VGND VPWR VPWR sky130_fd_sc_hd__decap_3
X_08135_ reg_pc\[20\] decoded_imm\[20\] _02518_ VGND VGND VPWR VPWR _02526_ sky130_fd_sc_hd__a21o_1
XFILLER_0_71_650 VGND VGND VPWR VPWR sky130_fd_sc_hd__fill_2
X_08066_ _02459_ _02461_ VGND VGND VPWR VPWR _02462_ sky130_fd_sc_hd__nand2_1
XFILLER_0_70_193 VGND VGND VPWR VPWR sky130_fd_sc_hd__decap_3
XFILLER_0_101_446 VGND VGND VPWR VPWR sky130_fd_sc_hd__fill_2
X_08968_ _03224_ VGND VGND VPWR VPWR _03270_ sky130_fd_sc_hd__buf_4
X_07919_ net200 VGND VGND VPWR VPWR _02325_ sky130_fd_sc_hd__clkbuf_4
X_08899_ latched_branch latched_store VGND VGND VPWR VPWR _03221_ sky130_fd_sc_hd__nand2_4
X_10930_ _03628_ VGND VGND VPWR VPWR _05043_ sky130_fd_sc_hd__buf_2
XPHY_200 VGND VGND VPWR VPWR sky130_fd_sc_hd__decap_3
X_12600_ net538 _06165_ _06168_ VGND VGND VPWR VPWR _00736_ sky130_fd_sc_hd__a21oi_1
X_10861_ _04996_ VGND VGND VPWR VPWR _00169_ sky130_fd_sc_hd__clkbuf_1
XPHY_233 VGND VGND VPWR VPWR sky130_fd_sc_hd__decap_3
X_13580_ _07055_ net218 _06960_ VGND VGND VPWR VPWR _07056_ sky130_fd_sc_hd__mux2_1
XPHY_222 VGND VGND VPWR VPWR sky130_fd_sc_hd__decap_3
XFILLER_0_109_502 VGND VGND VPWR VPWR sky130_fd_sc_hd__fill_2
XPHY_211 VGND VGND VPWR VPWR sky130_fd_sc_hd__decap_3
X_10792_ net668 _03504_ _04946_ VGND VGND VPWR VPWR _04956_ sky130_fd_sc_hd__mux2_1
XPHY_277 VGND VGND VPWR VPWR sky130_fd_sc_hd__decap_3
XFILLER_0_136_321 VGND VGND VPWR VPWR sky130_fd_sc_hd__fill_1
XPHY_266 VGND VGND VPWR VPWR sky130_fd_sc_hd__decap_3
XPHY_255 VGND VGND VPWR VPWR sky130_fd_sc_hd__decap_3
XPHY_244 VGND VGND VPWR VPWR sky130_fd_sc_hd__decap_3
XFILLER_0_93_274 VGND VGND VPWR VPWR sky130_fd_sc_hd__fill_2
XFILLER_0_54_628 VGND VGND VPWR VPWR sky130_fd_sc_hd__decap_4
XFILLER_0_54_617 VGND VGND VPWR VPWR sky130_fd_sc_hd__fill_2
X_12531_ count_cycle\[7\] count_cycle\[10\] _06110_ _06118_ VGND VGND VPWR VPWR _06119_
+ sky130_fd_sc_hd__and4_1
X_12462_ _05695_ _06064_ VGND VGND VPWR VPWR _06065_ sky130_fd_sc_hd__nand2_1
XFILLER_0_81_447 VGND VGND VPWR VPWR sky130_fd_sc_hd__fill_1
XFILLER_0_19_393 VGND VGND VPWR VPWR sky130_fd_sc_hd__decap_4
XFILLER_0_30_29 VGND VGND VPWR VPWR sky130_fd_sc_hd__fill_1
X_15250_ _02010_ VGND VGND VPWR VPWR _01479_ sky130_fd_sc_hd__clkbuf_1
X_11413_ net1318 _05188_ _05313_ VGND VGND VPWR VPWR _05317_ sky130_fd_sc_hd__mux2_1
X_14201_ net503 net250 _07519_ VGND VGND VPWR VPWR _07525_ sky130_fd_sc_hd__mux2_1
XFILLER_0_117_590 VGND VGND VPWR VPWR sky130_fd_sc_hd__decap_3
X_12393_ _05998_ _06001_ _05687_ VGND VGND VPWR VPWR _06002_ sky130_fd_sc_hd__a21o_1
X_15181_ _03451_ net1519 _01973_ VGND VGND VPWR VPWR _01975_ sky130_fd_sc_hd__mux2_1
XFILLER_0_104_251 VGND VGND VPWR VPWR sky130_fd_sc_hd__fill_1
X_11344_ _05280_ VGND VGND VPWR VPWR _00368_ sky130_fd_sc_hd__clkbuf_1
X_14132_ _05012_ net950 _07482_ VGND VGND VPWR VPWR _07486_ sky130_fd_sc_hd__mux2_1
X_11275_ _05243_ VGND VGND VPWR VPWR _00336_ sky130_fd_sc_hd__clkbuf_1
X_14063_ net388 _01103_ _07420_ VGND VGND VPWR VPWR _07448_ sky130_fd_sc_hd__mux2_1
XFILLER_0_120_766 VGND VGND VPWR VPWR sky130_fd_sc_hd__fill_2
X_10226_ _04370_ _04373_ _04442_ _04443_ _04403_ VGND VGND VPWR VPWR _04444_ sky130_fd_sc_hd__a32o_1
X_13014_ _06421_ _06503_ _06505_ VGND VGND VPWR VPWR _06506_ sky130_fd_sc_hd__a21o_1
X_10157_ _02391_ _02509_ _03997_ VGND VGND VPWR VPWR _04377_ sky130_fd_sc_hd__mux2_1
X_14965_ _03629_ net894 _01851_ VGND VGND VPWR VPWR _01860_ sky130_fd_sc_hd__mux2_1
X_10088_ cpuregs\[2\]\[14\] cpuregs\[3\]\[14\] _03977_ VGND VGND VPWR VPWR _04310_
+ sky130_fd_sc_hd__mux2_1
XFILLER_0_55_37 VGND VGND VPWR VPWR sky130_fd_sc_hd__decap_3
X_16704_ clknet_leaf_84_clk _01271_ VGND VGND VPWR VPWR cpuregs\[3\]\[18\] sky130_fd_sc_hd__dfxtp_1
X_13916_ _07357_ VGND VGND VPWR VPWR _07358_ sky130_fd_sc_hd__buf_2
X_14896_ _01823_ VGND VGND VPWR VPWR _01312_ sky130_fd_sc_hd__clkbuf_1
XFILLER_0_77_709 VGND VGND VPWR VPWR sky130_fd_sc_hd__decap_6
X_16635_ clknet_leaf_136_clk _01202_ VGND VGND VPWR VPWR cpuregs\[23\]\[13\] sky130_fd_sc_hd__dfxtp_1
X_13847_ net1143 net1 _02089_ VGND VGND VPWR VPWR _07308_ sky130_fd_sc_hd__mux2_1
XFILLER_0_128_811 VGND VGND VPWR VPWR sky130_fd_sc_hd__fill_1
X_13778_ cpuregs\[20\]\[30\] cpuregs\[21\]\[30\] _06456_ VGND VGND VPWR VPWR _07247_
+ sky130_fd_sc_hd__mux2_1
X_16566_ clknet_leaf_58_clk _01143_ VGND VGND VPWR VPWR cpuregs\[24\]\[18\] sky130_fd_sc_hd__dfxtp_1
X_16497_ clknet_leaf_56_clk _01079_ VGND VGND VPWR VPWR cpuregs\[19\]\[18\] sky130_fd_sc_hd__dfxtp_1
XFILLER_0_84_241 VGND VGND VPWR VPWR sky130_fd_sc_hd__fill_1
XFILLER_0_72_414 VGND VGND VPWR VPWR sky130_fd_sc_hd__decap_6
X_12729_ cpuregs\[4\]\[31\] cpuregs\[5\]\[31\] cpuregs\[6\]\[31\] cpuregs\[7\]\[31\]
+ _03798_ _03799_ VGND VGND VPWR VPWR _06263_ sky130_fd_sc_hd__mux4_1
X_15517_ clknet_leaf_122_clk _00167_ VGND VGND VPWR VPWR cpuregs\[13\]\[3\] sky130_fd_sc_hd__dfxtp_1
XFILLER_0_115_505 VGND VGND VPWR VPWR sky130_fd_sc_hd__decap_3
X_15448_ clknet_leaf_41_clk _00098_ VGND VGND VPWR VPWR net192 sky130_fd_sc_hd__dfxtp_4
XFILLER_0_84_296 VGND VGND VPWR VPWR sky130_fd_sc_hd__fill_2
XFILLER_0_44_138 VGND VGND VPWR VPWR sky130_fd_sc_hd__fill_2
XFILLER_0_53_650 VGND VGND VPWR VPWR sky130_fd_sc_hd__fill_1
XFILLER_0_4_213 VGND VGND VPWR VPWR sky130_fd_sc_hd__fill_1
XFILLER_0_130_508 VGND VGND VPWR VPWR sky130_fd_sc_hd__fill_1
XFILLER_0_111_64 VGND VGND VPWR VPWR sky130_fd_sc_hd__decap_4
XFILLER_0_53_694 VGND VGND VPWR VPWR sky130_fd_sc_hd__fill_1
X_15379_ _02077_ _07512_ _06290_ VGND VGND VPWR VPWR _02078_ sky130_fd_sc_hd__a21oi_1
XFILLER_0_13_525 VGND VGND VPWR VPWR sky130_fd_sc_hd__fill_1
Xhold426 cpuregs\[1\]\[24\] VGND VGND VPWR VPWR net784 sky130_fd_sc_hd__dlygate4sd3_1
Xhold404 cpuregs\[14\]\[14\] VGND VGND VPWR VPWR net762 sky130_fd_sc_hd__dlygate4sd3_1
XFILLER_0_20_73 VGND VGND VPWR VPWR sky130_fd_sc_hd__fill_2
Xhold415 cpuregs\[24\]\[10\] VGND VGND VPWR VPWR net773 sky130_fd_sc_hd__dlygate4sd3_1
XFILLER_0_111_733 VGND VGND VPWR VPWR sky130_fd_sc_hd__fill_1
XFILLER_0_110_232 VGND VGND VPWR VPWR sky130_fd_sc_hd__fill_1
Xhold448 cpuregs\[28\]\[19\] VGND VGND VPWR VPWR net806 sky130_fd_sc_hd__dlygate4sd3_1
Xhold437 cpuregs\[7\]\[17\] VGND VGND VPWR VPWR net795 sky130_fd_sc_hd__dlygate4sd3_1
X_09940_ cpuregs\[12\]\[10\] cpuregs\[13\]\[10\] _03976_ VGND VGND VPWR VPWR _04166_
+ sky130_fd_sc_hd__mux2_1
Xhold459 cpuregs\[14\]\[4\] VGND VGND VPWR VPWR net817 sky130_fd_sc_hd__dlygate4sd3_1
XFILLER_0_0_452 VGND VGND VPWR VPWR sky130_fd_sc_hd__fill_2
X_09871_ cpuregs\[24\]\[8\] cpuregs\[25\]\[8\] cpuregs\[26\]\[8\] cpuregs\[27\]\[8\]
+ _03935_ _03936_ VGND VGND VPWR VPWR _04099_ sky130_fd_sc_hd__mux4_1
XTAP_720 VGND VPWR sky130_fd_sc_hd__tapvpwrvgnd_1
XTAP_731 VGND VPWR sky130_fd_sc_hd__tapvpwrvgnd_1
XTAP_742 VGND VPWR sky130_fd_sc_hd__tapvpwrvgnd_1
X_08822_ _03168_ _03174_ VGND VGND VPWR VPWR _03175_ sky130_fd_sc_hd__xnor2_1
Xhold1115 cpuregs\[21\]\[23\] VGND VGND VPWR VPWR net1473 sky130_fd_sc_hd__dlygate4sd3_1
Xhold1104 net168 VGND VGND VPWR VPWR net1462 sky130_fd_sc_hd__dlygate4sd3_1
XFILLER_0_29_82 VGND VGND VPWR VPWR sky130_fd_sc_hd__fill_2
XTAP_753 VGND VPWR sky130_fd_sc_hd__tapvpwrvgnd_1
XTAP_764 VGND VPWR sky130_fd_sc_hd__tapvpwrvgnd_1
XTAP_775 VGND VPWR sky130_fd_sc_hd__tapvpwrvgnd_1
XTAP_786 VGND VPWR sky130_fd_sc_hd__tapvpwrvgnd_1
Xhold1137 cpuregs\[21\]\[25\] VGND VGND VPWR VPWR net1495 sky130_fd_sc_hd__dlygate4sd3_1
X_08753_ _02993_ VGND VGND VPWR VPWR _03110_ sky130_fd_sc_hd__inv_2
Xhold1148 cpuregs\[31\]\[17\] VGND VGND VPWR VPWR net1506 sky130_fd_sc_hd__dlygate4sd3_1
Xhold1126 cpuregs\[9\]\[2\] VGND VGND VPWR VPWR net1484 sky130_fd_sc_hd__dlygate4sd3_1
XTAP_797 VGND VPWR sky130_fd_sc_hd__tapvpwrvgnd_1
Xhold1159 cpuregs\[23\]\[0\] VGND VGND VPWR VPWR net1517 sky130_fd_sc_hd__dlygate4sd3_1
X_07704_ _02121_ _02123_ _02125_ _02129_ VGND VGND VPWR VPWR _02130_ sky130_fd_sc_hd__or4_1
X_08684_ _03039_ _03036_ _03037_ VGND VGND VPWR VPWR _03047_ sky130_fd_sc_hd__o21ba_1
XTAP_1919 VGND VPWR sky130_fd_sc_hd__tapvpwrvgnd_1
XTAP_1908 VGND VPWR sky130_fd_sc_hd__tapvpwrvgnd_1
X_09305_ reg_out\[17\] alu_out_q\[17\] _03436_ VGND VGND VPWR VPWR _03556_ sky130_fd_sc_hd__mux2_1
XFILLER_0_75_263 VGND VGND VPWR VPWR sky130_fd_sc_hd__decap_8
X_09236_ reg_pc\[8\] _03487_ VGND VGND VPWR VPWR _03496_ sky130_fd_sc_hd__or2_1
XFILLER_0_134_825 VGND VGND VPWR VPWR sky130_fd_sc_hd__decap_6
XFILLER_0_133_313 VGND VGND VPWR VPWR sky130_fd_sc_hd__decap_4
XFILLER_0_106_527 VGND VGND VPWR VPWR sky130_fd_sc_hd__fill_2
XFILLER_0_63_458 VGND VGND VPWR VPWR sky130_fd_sc_hd__fill_1
XFILLER_0_28_190 VGND VGND VPWR VPWR sky130_fd_sc_hd__decap_6
XFILLER_0_90_277 VGND VGND VPWR VPWR sky130_fd_sc_hd__decap_3
X_09167_ latched_stalu VGND VGND VPWR VPWR _03435_ sky130_fd_sc_hd__buf_4
X_08118_ count_instr\[20\] _02236_ count_cycle\[52\] _02237_ VGND VGND VPWR VPWR _02511_
+ sky130_fd_sc_hd__a22o_1
X_09098_ cpuregs\[24\]\[3\] cpuregs\[25\]\[3\] cpuregs\[26\]\[3\] cpuregs\[27\]\[3\]
+ _03336_ _03337_ VGND VGND VPWR VPWR _03378_ sky130_fd_sc_hd__mux4_1
XFILLER_0_31_322 VGND VGND VPWR VPWR sky130_fd_sc_hd__fill_2
X_08049_ _02221_ _02432_ VGND VGND VPWR VPWR _02446_ sky130_fd_sc_hd__nand2_2
X_11060_ net839 _03597_ _05110_ VGND VGND VPWR VPWR _05114_ sky130_fd_sc_hd__mux2_1
Xhold982 cpuregs\[14\]\[27\] VGND VGND VPWR VPWR net1340 sky130_fd_sc_hd__dlygate4sd3_1
Xhold971 decoded_imm\[23\] VGND VGND VPWR VPWR net1329 sky130_fd_sc_hd__dlygate4sd3_1
Xhold960 cpuregs\[15\]\[13\] VGND VGND VPWR VPWR net1318 sky130_fd_sc_hd__dlygate4sd3_1
Xhold993 cpuregs\[13\]\[14\] VGND VGND VPWR VPWR net1351 sky130_fd_sc_hd__dlygate4sd3_1
X_10011_ cpuregs\[8\]\[12\] cpuregs\[9\]\[12\] cpuregs\[10\]\[12\] cpuregs\[11\]\[12\]
+ _03876_ _03895_ VGND VGND VPWR VPWR _04235_ sky130_fd_sc_hd__mux4_1
X_14750_ _05033_ net1534 _01742_ VGND VGND VPWR VPWR _01746_ sky130_fd_sc_hd__mux2_1
X_13701_ _07172_ VGND VGND VPWR VPWR _00833_ sky130_fd_sc_hd__clkbuf_1
X_11962_ net597 _05637_ _05641_ VGND VGND VPWR VPWR _00625_ sky130_fd_sc_hd__o21a_1
X_14681_ _01709_ VGND VGND VPWR VPWR _01211_ sky130_fd_sc_hd__clkbuf_1
X_10913_ _05031_ net1395 _05027_ VGND VGND VPWR VPWR _05032_ sky130_fd_sc_hd__mux2_1
X_11893_ count_instr\[26\] _05585_ _05589_ VGND VGND VPWR VPWR _05591_ sky130_fd_sc_hd__and3_1
X_13632_ cpuregs\[24\]\[25\] cpuregs\[25\]\[25\] cpuregs\[26\]\[25\] cpuregs\[27\]\[25\]
+ _06856_ _06889_ VGND VGND VPWR VPWR _07106_ sky130_fd_sc_hd__mux4_1
X_16420_ clknet_leaf_25_clk _01002_ VGND VGND VPWR VPWR decoded_imm\[27\] sky130_fd_sc_hd__dfxtp_2
XFILLER_0_67_742 VGND VGND VPWR VPWR sky130_fd_sc_hd__fill_1
X_10844_ _04984_ VGND VGND VPWR VPWR _04985_ sky130_fd_sc_hd__clkbuf_8
X_13563_ _06911_ _07038_ VGND VGND VPWR VPWR _07039_ sky130_fd_sc_hd__or2_1
XFILLER_0_128_129 VGND VGND VPWR VPWR sky130_fd_sc_hd__decap_8
X_16351_ clknet_leaf_86_clk _00933_ VGND VGND VPWR VPWR cpuregs\[1\]\[16\] sky130_fd_sc_hd__dfxtp_1
XFILLER_0_67_775 VGND VGND VPWR VPWR sky130_fd_sc_hd__decap_3
X_15302_ _02036_ VGND VGND VPWR VPWR _01505_ sky130_fd_sc_hd__clkbuf_1
XFILLER_0_81_222 VGND VGND VPWR VPWR sky130_fd_sc_hd__fill_2
X_10775_ _04947_ VGND VGND VPWR VPWR _00132_ sky130_fd_sc_hd__clkbuf_1
X_12514_ count_cycle\[4\] count_cycle\[5\] _06104_ VGND VGND VPWR VPWR _06107_ sky130_fd_sc_hd__and3_1
X_13494_ _06970_ _06971_ VGND VGND VPWR VPWR _06972_ sky130_fd_sc_hd__and2_1
X_16282_ clknet_leaf_4_clk _00867_ VGND VGND VPWR VPWR instr_sw sky130_fd_sc_hd__dfxtp_1
X_12445_ _06047_ _06048_ VGND VGND VPWR VPWR _06049_ sky130_fd_sc_hd__xor2_1
X_15233_ _03616_ net1081 _01995_ VGND VGND VPWR VPWR _02002_ sky130_fd_sc_hd__mux2_1
XFILLER_0_41_108 VGND VGND VPWR VPWR sky130_fd_sc_hd__decap_4
XFILLER_0_41_119 VGND VGND VPWR VPWR sky130_fd_sc_hd__decap_3
X_15164_ _01965_ VGND VGND VPWR VPWR _01438_ sky130_fd_sc_hd__clkbuf_1
X_12376_ _05978_ _05980_ _05985_ VGND VGND VPWR VPWR _05986_ sky130_fd_sc_hd__a21o_1
XFILLER_0_105_593 VGND VGND VPWR VPWR sky130_fd_sc_hd__fill_2
X_11327_ _05271_ VGND VGND VPWR VPWR _00360_ sky130_fd_sc_hd__clkbuf_1
X_14115_ _04995_ net1487 _07471_ VGND VGND VPWR VPWR _07477_ sky130_fd_sc_hd__mux2_1
X_15095_ net789 _05213_ _01923_ VGND VGND VPWR VPWR _01929_ sky130_fd_sc_hd__mux2_1
XFILLER_0_10_539 VGND VGND VPWR VPWR sky130_fd_sc_hd__fill_1
X_14046_ _07439_ VGND VGND VPWR VPWR _01124_ sky130_fd_sc_hd__clkbuf_1
X_11258_ _05234_ VGND VGND VPWR VPWR _00328_ sky130_fd_sc_hd__clkbuf_1
X_10209_ cpuregs\[24\]\[17\] cpuregs\[25\]\[17\] cpuregs\[26\]\[17\] cpuregs\[27\]\[17\]
+ _03980_ _03718_ VGND VGND VPWR VPWR _04428_ sky130_fd_sc_hd__mux4_1
X_11189_ net723 _05188_ _05182_ VGND VGND VPWR VPWR _05189_ sky130_fd_sc_hd__mux2_1
X_15997_ clknet_leaf_11_clk _00647_ VGND VGND VPWR VPWR reg_pc\[3\] sky130_fd_sc_hd__dfxtp_2
X_14948_ _01828_ VGND VGND VPWR VPWR _01851_ sky130_fd_sc_hd__buf_4
XFILLER_0_89_333 VGND VGND VPWR VPWR sky130_fd_sc_hd__decap_3
X_14879_ _01814_ VGND VGND VPWR VPWR _01304_ sky130_fd_sc_hd__clkbuf_1
XFILLER_0_49_208 VPWR VGND VPWR VGND sky130_ef_sc_hd__decap_12
X_16618_ clknet_leaf_72_clk _01185_ VGND VGND VPWR VPWR cpuregs\[9\]\[28\] sky130_fd_sc_hd__dfxtp_1
XFILLER_0_85_561 VGND VGND VPWR VPWR sky130_fd_sc_hd__fill_1
X_16549_ clknet_leaf_144_clk _01126_ VGND VGND VPWR VPWR cpuregs\[24\]\[1\] sky130_fd_sc_hd__dfxtp_1
XFILLER_0_128_663 VGND VGND VPWR VPWR sky130_fd_sc_hd__decap_3
XFILLER_0_45_447 VGND VGND VPWR VPWR sky130_fd_sc_hd__fill_1
X_09021_ _03304_ VGND VGND VPWR VPWR _01112_ sky130_fd_sc_hd__buf_1
XFILLER_0_31_83 VGND VGND VPWR VPWR sky130_fd_sc_hd__fill_2
Xhold201 count_cycle\[24\] VGND VGND VPWR VPWR net559 sky130_fd_sc_hd__dlygate4sd3_1
XFILLER_0_123_390 VGND VGND VPWR VPWR sky130_fd_sc_hd__fill_2
Xhold234 cpuregs\[19\]\[22\] VGND VGND VPWR VPWR net592 sky130_fd_sc_hd__dlygate4sd3_1
Xhold223 cpuregs\[26\]\[30\] VGND VGND VPWR VPWR net581 sky130_fd_sc_hd__dlygate4sd3_1
Xhold212 net48 VGND VGND VPWR VPWR net570 sky130_fd_sc_hd__dlygate4sd3_1
XFILLER_0_40_141 VGND VGND VPWR VPWR sky130_fd_sc_hd__fill_1
Xhold256 cpuregs\[28\]\[28\] VGND VGND VPWR VPWR net614 sky130_fd_sc_hd__dlygate4sd3_1
Xhold245 cpuregs\[20\]\[23\] VGND VGND VPWR VPWR net603 sky130_fd_sc_hd__dlygate4sd3_1
Xhold278 cpuregs\[20\]\[13\] VGND VGND VPWR VPWR net636 sky130_fd_sc_hd__dlygate4sd3_1
Xhold267 cpuregs\[19\]\[9\] VGND VGND VPWR VPWR net625 sky130_fd_sc_hd__dlygate4sd3_1
X_09923_ _03714_ VGND VGND VPWR VPWR _04150_ sky130_fd_sc_hd__clkbuf_4
Xhold289 cpuregs\[26\]\[17\] VGND VGND VPWR VPWR net647 sky130_fd_sc_hd__dlygate4sd3_1
X_09854_ _02280_ _02325_ _02391_ _02352_ _03847_ _03652_ VGND VGND VPWR VPWR _04082_
+ sky130_fd_sc_hd__mux4_1
XTAP_550 VGND VPWR sky130_fd_sc_hd__tapvpwrvgnd_1
XTAP_561 VGND VPWR sky130_fd_sc_hd__tapvpwrvgnd_1
X_08805_ net222 _03158_ VGND VGND VPWR VPWR _03159_ sky130_fd_sc_hd__xnor2_1
XFILLER_0_99_108 VGND VGND VPWR VPWR sky130_fd_sc_hd__decap_4
XTAP_572 VGND VPWR sky130_fd_sc_hd__tapvpwrvgnd_1
XTAP_594 VGND VPWR sky130_fd_sc_hd__tapvpwrvgnd_1
XTAP_583 VGND VPWR sky130_fd_sc_hd__tapvpwrvgnd_1
X_09785_ _03897_ _04012_ _04014_ VGND VGND VPWR VPWR _04015_ sky130_fd_sc_hd__a21o_1
X_08736_ _03074_ _03091_ _03094_ VGND VGND VPWR VPWR _03095_ sky130_fd_sc_hd__o21ai_1
XFILLER_0_96_804 VGND VGND VPWR VPWR sky130_fd_sc_hd__fill_2
XANTENNA_107 net204 VGND VGND VPWR VPWR sky130_fd_sc_hd__diode_2
XANTENNA_129 _07519_ VGND VGND VPWR VPWR sky130_fd_sc_hd__diode_2
X_08667_ _02840_ VGND VGND VPWR VPWR _03031_ sky130_fd_sc_hd__clkbuf_4
XANTENNA_118 _02552_ VGND VGND VPWR VPWR sky130_fd_sc_hd__diode_2
XTAP_1705 VGND VPWR sky130_fd_sc_hd__tapvpwrvgnd_1
XFILLER_0_68_528 VGND VGND VPWR VPWR sky130_fd_sc_hd__decap_4
XTAP_1738 VGND VPWR sky130_fd_sc_hd__tapvpwrvgnd_1
XTAP_1749 VGND VPWR sky130_fd_sc_hd__tapvpwrvgnd_1
XTAP_1727 VGND VPWR sky130_fd_sc_hd__tapvpwrvgnd_1
XTAP_1716 VGND VPWR sky130_fd_sc_hd__tapvpwrvgnd_1
X_08598_ _02966_ _02967_ VGND VGND VPWR VPWR _02968_ sky130_fd_sc_hd__and2b_1
X_10560_ _03795_ _04762_ _04768_ VGND VGND VPWR VPWR _04769_ sky130_fd_sc_hd__or3_2
XFILLER_0_36_447 VGND VGND VPWR VPWR sky130_fd_sc_hd__fill_2
XFILLER_0_133_132 VGND VGND VPWR VPWR sky130_fd_sc_hd__fill_1
X_10491_ _04125_ _04697_ _04701_ _03971_ VGND VGND VPWR VPWR _04702_ sky130_fd_sc_hd__o211a_1
XFILLER_0_118_195 VGND VGND VPWR VPWR sky130_fd_sc_hd__fill_1
XFILLER_0_63_266 VGND VGND VPWR VPWR sky130_fd_sc_hd__decap_4
X_09219_ reg_pc\[6\] _03474_ _03467_ VGND VGND VPWR VPWR _03481_ sky130_fd_sc_hd__a21oi_1
XFILLER_0_51_439 VGND VGND VPWR VPWR sky130_fd_sc_hd__decap_8
X_12230_ _05741_ net508 _05816_ _05851_ VGND VGND VPWR VPWR _00683_ sky130_fd_sc_hd__o211a_1
X_12161_ _02154_ _05787_ VGND VGND VPWR VPWR _05788_ sky130_fd_sc_hd__nor2_1
X_12092_ _02108_ _05733_ VGND VGND VPWR VPWR _05734_ sky130_fd_sc_hd__or2_1
X_11112_ _05141_ VGND VGND VPWR VPWR _00275_ sky130_fd_sc_hd__clkbuf_1
Xhold790 cpuregs\[18\]\[11\] VGND VGND VPWR VPWR net1148 sky130_fd_sc_hd__dlygate4sd3_1
X_15920_ clknet_leaf_44_clk _00570_ VGND VGND VPWR VPWR cpuregs\[17\]\[22\] sky130_fd_sc_hd__dfxtp_1
X_11043_ net783 _03544_ _05099_ VGND VGND VPWR VPWR _05105_ sky130_fd_sc_hd__mux2_1
X_15851_ clknet_leaf_96_clk _00501_ VGND VGND VPWR VPWR cpuregs\[25\]\[17\] sky130_fd_sc_hd__dfxtp_1
X_14802_ _01773_ VGND VGND VPWR VPWR _01268_ sky130_fd_sc_hd__clkbuf_1
Xclkbuf_4_3_0_clk clknet_0_clk VGND VGND VPWR VPWR clknet_4_3_0_clk sky130_fd_sc_hd__clkbuf_8
XFILLER_0_98_141 VGND VGND VPWR VPWR sky130_fd_sc_hd__decap_6
X_15782_ clknet_leaf_137_clk _00432_ VGND VGND VPWR VPWR cpuregs\[26\]\[12\] sky130_fd_sc_hd__dfxtp_1
X_12994_ cpuregs\[16\]\[6\] cpuregs\[17\]\[6\] cpuregs\[18\]\[6\] cpuregs\[19\]\[6\]
+ _06443_ _06444_ VGND VGND VPWR VPWR _06487_ sky130_fd_sc_hd__mux4_1
XFILLER_0_98_174 VGND VGND VPWR VPWR sky130_fd_sc_hd__fill_2
XFILLER_0_98_163 VGND VGND VPWR VPWR sky130_fd_sc_hd__decap_4
X_14733_ _05016_ net1565 _01731_ VGND VGND VPWR VPWR _01737_ sky130_fd_sc_hd__mux2_1
X_11945_ count_instr\[40\] _05625_ VGND VGND VPWR VPWR _05629_ sky130_fd_sc_hd__or2_1
X_14664_ _01700_ VGND VGND VPWR VPWR _01203_ sky130_fd_sc_hd__clkbuf_1
XFILLER_0_52_38 VGND VGND VPWR VPWR sky130_fd_sc_hd__decap_8
X_13615_ _03340_ _07088_ _06998_ VGND VGND VPWR VPWR _07089_ sky130_fd_sc_hd__a21o_1
X_16403_ clknet_leaf_29_clk _00985_ VGND VGND VPWR VPWR net158 sky130_fd_sc_hd__dfxtp_1
XFILLER_0_86_369 VGND VGND VPWR VPWR sky130_fd_sc_hd__fill_1
XFILLER_0_67_550 VGND VGND VPWR VPWR sky130_fd_sc_hd__fill_1
X_11876_ count_instr\[21\] _05575_ VGND VGND VPWR VPWR _05579_ sky130_fd_sc_hd__and2_1
X_10827_ _04974_ VGND VGND VPWR VPWR _00157_ sky130_fd_sc_hd__clkbuf_1
X_14595_ _05014_ net1611 _01659_ VGND VGND VPWR VPWR _01664_ sky130_fd_sc_hd__mux2_1
XFILLER_0_7_809 VGND VGND VPWR VPWR sky130_fd_sc_hd__decap_6
X_13546_ _06751_ _07017_ _07022_ _06798_ VGND VGND VPWR VPWR _07023_ sky130_fd_sc_hd__o211a_1
X_10758_ _04936_ VGND VGND VPWR VPWR _00126_ sky130_fd_sc_hd__clkbuf_1
XFILLER_0_70_704 VGND VGND VPWR VPWR sky130_fd_sc_hd__fill_1
X_16334_ clknet_leaf_6_clk _00916_ VGND VGND VPWR VPWR is_beq_bne_blt_bge_bltu_bgeu
+ sky130_fd_sc_hd__dfxtp_1
XFILLER_0_125_633 VGND VGND VPWR VPWR sky130_fd_sc_hd__decap_8
X_13477_ _06792_ _06953_ _06955_ _06894_ VGND VGND VPWR VPWR _06956_ sky130_fd_sc_hd__a211o_1
X_16265_ clknet_leaf_140_clk _00850_ VGND VGND VPWR VPWR instr_bge sky130_fd_sc_hd__dfxtp_1
X_12428_ _05763_ net897 _06032_ _06033_ _05697_ VGND VGND VPWR VPWR _00699_ sky130_fd_sc_hd__o221a_1
X_10689_ _04891_ _04892_ _04893_ _04894_ _03676_ _04103_ VGND VGND VPWR VPWR _04895_
+ sky130_fd_sc_hd__mux4_1
X_15216_ _03564_ net1433 _01984_ VGND VGND VPWR VPWR _01993_ sky130_fd_sc_hd__mux2_1
XFILLER_0_35_480 VGND VGND VPWR VPWR sky130_fd_sc_hd__decap_3
XFILLER_0_112_349 VGND VGND VPWR VPWR sky130_fd_sc_hd__decap_6
XFILLER_0_11_815 VGND VGND VPWR VPWR sky130_fd_sc_hd__fill_1
XFILLER_0_22_141 VGND VGND VPWR VPWR sky130_fd_sc_hd__fill_1
X_16196_ clknet_leaf_141_clk _00813_ VGND VGND VPWR VPWR net126 sky130_fd_sc_hd__dfxtp_2
X_12359_ decoded_imm_j\[19\] _05733_ VGND VGND VPWR VPWR _05970_ sky130_fd_sc_hd__nor2_1
X_15147_ _01956_ VGND VGND VPWR VPWR _01430_ sky130_fd_sc_hd__clkbuf_1
XFILLER_0_22_185 VGND VGND VPWR VPWR sky130_fd_sc_hd__decap_8
X_15078_ net795 _05196_ _01912_ VGND VGND VPWR VPWR _01920_ sky130_fd_sc_hd__mux2_1
XFILLER_0_10_347 VGND VGND VPWR VPWR sky130_fd_sc_hd__fill_1
X_14029_ mem_rdata_q\[29\] net22 _07422_ VGND VGND VPWR VPWR _07431_ sky130_fd_sc_hd__mux2_1
XFILLER_0_117_63 VGND VGND VPWR VPWR sky130_fd_sc_hd__fill_1
X_09570_ _03668_ _03803_ _00014_ VGND VGND VPWR VPWR _03804_ sky130_fd_sc_hd__a21o_1
XFILLER_0_89_163 VGND VGND VPWR VPWR sky130_fd_sc_hd__decap_4
X_08521_ _02660_ _02895_ _02896_ VGND VGND VPWR VPWR _02897_ sky130_fd_sc_hd__a21o_1
XFILLER_0_26_72 VGND VGND VPWR VPWR sky130_fd_sc_hd__decap_4
X_08452_ instr_bne is_slti_blt_slt is_sltiu_bltu_sltu _02760_ VGND VGND VPWR VPWR
+ _02833_ sky130_fd_sc_hd__or4b_1
X_08383_ net180 net246 VGND VGND VPWR VPWR _02764_ sky130_fd_sc_hd__or2b_1
XFILLER_0_128_471 VGND VGND VPWR VPWR sky130_fd_sc_hd__decap_4
XFILLER_0_6_831 VGND VGND VPWR VPWR sky130_fd_sc_hd__fill_1
XFILLER_0_116_699 VGND VGND VPWR VPWR sky130_fd_sc_hd__fill_1
XFILLER_0_115_165 VGND VGND VPWR VPWR sky130_fd_sc_hd__decap_3
XFILLER_0_60_247 VGND VGND VPWR VPWR sky130_fd_sc_hd__fill_1
X_09004_ _03294_ _02101_ VGND VGND VPWR VPWR _03295_ sky130_fd_sc_hd__nor2_8
XFILLER_0_131_658 VGND VGND VPWR VPWR sky130_fd_sc_hd__decap_4
XFILLER_0_130_157 VGND VGND VPWR VPWR sky130_fd_sc_hd__fill_2
XFILLER_0_130_135 VGND VGND VPWR VPWR sky130_fd_sc_hd__decap_4
X_09906_ _03795_ _04124_ _04132_ VGND VGND VPWR VPWR _04133_ sky130_fd_sc_hd__or3_2
X_09837_ _03656_ _04050_ _04065_ _03774_ reg_pc\[7\] VGND VGND VPWR VPWR _04066_ sky130_fd_sc_hd__a32o_1
XTAP_391 VGND VPWR sky130_fd_sc_hd__tapvpwrvgnd_1
XTAP_380 VGND VPWR sky130_fd_sc_hd__tapvpwrvgnd_1
X_09768_ _02294_ _02325_ _03997_ VGND VGND VPWR VPWR _03998_ sky130_fd_sc_hd__mux2_1
XTAP_2214 VGND VPWR sky130_fd_sc_hd__tapvpwrvgnd_1
XTAP_2225 VGND VPWR sky130_fd_sc_hd__tapvpwrvgnd_1
XTAP_2203 VGND VPWR sky130_fd_sc_hd__tapvpwrvgnd_1
X_08719_ _02773_ _03078_ VGND VGND VPWR VPWR _03079_ sky130_fd_sc_hd__xnor2_2
XFILLER_0_96_612 VGND VGND VPWR VPWR sky130_fd_sc_hd__fill_2
XTAP_2269 VGND VPWR sky130_fd_sc_hd__tapvpwrvgnd_1
XTAP_2258 VGND VPWR sky130_fd_sc_hd__tapvpwrvgnd_1
XTAP_2247 VGND VPWR sky130_fd_sc_hd__tapvpwrvgnd_1
XTAP_2236 VGND VPWR sky130_fd_sc_hd__tapvpwrvgnd_1
XFILLER_0_96_634 VGND VGND VPWR VPWR sky130_fd_sc_hd__fill_1
XTAP_1524 VGND VPWR sky130_fd_sc_hd__tapvpwrvgnd_1
XTAP_1513 VGND VPWR sky130_fd_sc_hd__tapvpwrvgnd_1
XTAP_1502 VGND VPWR sky130_fd_sc_hd__tapvpwrvgnd_1
X_11730_ _05485_ VGND VGND VPWR VPWR _00549_ sky130_fd_sc_hd__clkbuf_1
XPHY_20 VGND VGND VPWR VPWR sky130_fd_sc_hd__decap_3
X_09699_ _03732_ _03930_ _03659_ VGND VGND VPWR VPWR _03931_ sky130_fd_sc_hd__o21ai_1
XPHY_31 VGND VGND VPWR VPWR sky130_fd_sc_hd__decap_3
XFILLER_0_95_144 VGND VGND VPWR VPWR sky130_fd_sc_hd__decap_3
XTAP_1557 VGND VPWR sky130_fd_sc_hd__tapvpwrvgnd_1
XTAP_1535 VGND VPWR sky130_fd_sc_hd__tapvpwrvgnd_1
XTAP_1546 VGND VPWR sky130_fd_sc_hd__tapvpwrvgnd_1
XPHY_42 VGND VGND VPWR VPWR sky130_fd_sc_hd__decap_3
XPHY_53 VGND VGND VPWR VPWR sky130_fd_sc_hd__decap_3
XPHY_64 VGND VGND VPWR VPWR sky130_fd_sc_hd__decap_3
XFILLER_0_138_268 VGND VGND VPWR VPWR sky130_fd_sc_hd__decap_4
XTAP_1579 VGND VPWR sky130_fd_sc_hd__tapvpwrvgnd_1
XTAP_1568 VGND VPWR sky130_fd_sc_hd__tapvpwrvgnd_1
XFILLER_0_83_317 VGND VGND VPWR VPWR sky130_fd_sc_hd__fill_1
XPHY_97 VGND VGND VPWR VPWR sky130_fd_sc_hd__decap_3
X_11661_ net1250 _05163_ _05447_ VGND VGND VPWR VPWR _05449_ sky130_fd_sc_hd__mux2_1
XPHY_75 VGND VGND VPWR VPWR sky130_fd_sc_hd__decap_3
XPHY_86 VGND VGND VPWR VPWR sky130_fd_sc_hd__decap_3
X_10612_ cpuregs\[30\]\[28\] cpuregs\[31\]\[28\] _03881_ VGND VGND VPWR VPWR _04820_
+ sky130_fd_sc_hd__mux2_1
XFILLER_0_119_482 VGND VGND VPWR VPWR sky130_fd_sc_hd__fill_2
X_13400_ _06638_ _06876_ _06878_ _06739_ _06880_ VGND VGND VPWR VPWR _06881_ sky130_fd_sc_hd__o311a_1
X_11592_ _05412_ VGND VGND VPWR VPWR _00484_ sky130_fd_sc_hd__clkbuf_1
XFILLER_0_36_233 VGND VGND VPWR VPWR sky130_fd_sc_hd__decap_3
X_14380_ _05003_ net1046 _07616_ VGND VGND VPWR VPWR _01550_ sky130_fd_sc_hd__mux2_1
X_10543_ decoded_imm\[27\] net190 VGND VGND VPWR VPWR _04752_ sky130_fd_sc_hd__nand2_1
XFILLER_0_107_633 VGND VGND VPWR VPWR sky130_fd_sc_hd__decap_3
XFILLER_0_106_110 VGND VGND VPWR VPWR sky130_fd_sc_hd__fill_2
X_13331_ _06773_ _06813_ VGND VGND VPWR VPWR _06814_ sky130_fd_sc_hd__and2_1
X_16050_ clknet_leaf_35_clk _00700_ VGND VGND VPWR VPWR reg_next_pc\[25\] sky130_fd_sc_hd__dfxtp_1
XFILLER_0_121_113 VPWR VGND VPWR VGND sky130_ef_sc_hd__decap_12
X_10474_ decoded_imm\[25\] _02578_ VGND VGND VPWR VPWR _04685_ sky130_fd_sc_hd__nand2_1
X_13262_ cpuregs\[20\]\[14\] cpuregs\[21\]\[14\] _06448_ VGND VGND VPWR VPWR _06747_
+ sky130_fd_sc_hd__mux2_1
X_15001_ _01879_ VGND VGND VPWR VPWR _01361_ sky130_fd_sc_hd__clkbuf_1
XFILLER_0_121_157 VGND VGND VPWR VPWR sky130_fd_sc_hd__fill_2
X_12213_ _05706_ _05818_ VGND VGND VPWR VPWR _05836_ sky130_fd_sc_hd__or2_1
X_13193_ _06518_ _06679_ VGND VGND VPWR VPWR _06680_ sky130_fd_sc_hd__or2_1
X_12144_ decoded_imm_j\[1\] _05689_ _05770_ VGND VGND VPWR VPWR _05772_ sky130_fd_sc_hd__nand3_2
X_12075_ _05688_ _05720_ _05721_ _02142_ VGND VGND VPWR VPWR _00658_ sky130_fd_sc_hd__o211a_1
X_16952_ clknet_leaf_112_clk _01516_ VGND VGND VPWR VPWR cpuregs\[10\]\[7\] sky130_fd_sc_hd__dfxtp_1
X_16883_ clknet_leaf_102_clk _01447_ VGND VGND VPWR VPWR cpuregs\[8\]\[2\] sky130_fd_sc_hd__dfxtp_1
X_15903_ clknet_leaf_142_clk _00553_ VGND VGND VPWR VPWR cpuregs\[17\]\[5\] sky130_fd_sc_hd__dfxtp_1
X_11026_ net1187 _03491_ _05088_ VGND VGND VPWR VPWR _05096_ sky130_fd_sc_hd__mux2_1
XFILLER_0_63_15 VGND VGND VPWR VPWR sky130_fd_sc_hd__decap_8
X_15834_ clknet_leaf_125_clk _00484_ VGND VGND VPWR VPWR cpuregs\[25\]\[0\] sky130_fd_sc_hd__dfxtp_1
XFILLER_0_2_29 VGND VGND VPWR VPWR sky130_fd_sc_hd__fill_2
X_15765_ clknet_leaf_71_clk _00415_ VGND VGND VPWR VPWR cpuregs\[15\]\[27\] sky130_fd_sc_hd__dfxtp_1
XFILLER_0_87_645 VGND VGND VPWR VPWR sky130_fd_sc_hd__fill_2
X_12977_ _06416_ _06440_ _06469_ _06470_ decoded_imm\[5\] VGND VGND VPWR VPWR _06471_
+ sky130_fd_sc_hd__a32o_1
X_15696_ clknet_leaf_47_clk _00346_ VGND VGND VPWR VPWR cpuregs\[27\]\[22\] sky130_fd_sc_hd__dfxtp_1
XFILLER_0_86_166 VGND VGND VPWR VPWR sky130_fd_sc_hd__decap_8
XFILLER_0_74_306 VGND VGND VPWR VPWR sky130_fd_sc_hd__fill_2
X_11928_ _05616_ VGND VGND VPWR VPWR _00616_ sky130_fd_sc_hd__clkbuf_1
X_14716_ _04999_ net1551 _01720_ VGND VGND VPWR VPWR _01728_ sky130_fd_sc_hd__mux2_1
X_11859_ count_instr\[17\] count_instr\[16\] VGND VGND VPWR VPWR _05566_ sky130_fd_sc_hd__and2_1
X_14647_ _01691_ VGND VGND VPWR VPWR _01195_ sky130_fd_sc_hd__clkbuf_1
XFILLER_0_103_43 VGND VGND VPWR VPWR sky130_fd_sc_hd__fill_1
XFILLER_0_103_21 VGND VGND VPWR VPWR sky130_fd_sc_hd__fill_2
XANTENNA_18 _03811_ VGND VGND VPWR VPWR sky130_fd_sc_hd__diode_2
XANTENNA_29 _04421_ VGND VGND VPWR VPWR sky130_fd_sc_hd__diode_2
X_14578_ _04997_ net1144 _01648_ VGND VGND VPWR VPWR _01655_ sky130_fd_sc_hd__mux2_1
XFILLER_0_137_290 VPWR VGND VPWR VGND sky130_ef_sc_hd__decap_12
X_13529_ cpuregs\[0\]\[22\] cpuregs\[1\]\[22\] cpuregs\[2\]\[22\] cpuregs\[3\]\[22\]
+ _06740_ _06708_ VGND VGND VPWR VPWR _07006_ sky130_fd_sc_hd__mux4_1
X_16317_ clknet_leaf_27_clk _00902_ VGND VGND VPWR VPWR decoded_imm_j\[15\] sky130_fd_sc_hd__dfxtp_2
XFILLER_0_103_87 VGND VGND VPWR VPWR sky130_fd_sc_hd__decap_6
XFILLER_0_42_214 VGND VGND VPWR VPWR sky130_fd_sc_hd__fill_1
X_16248_ clknet_leaf_39_clk alu_out\[21\] VGND VGND VPWR VPWR alu_out_q\[21\] sky130_fd_sc_hd__dfxtp_1
XFILLER_0_112_102 VGND VGND VPWR VPWR sky130_fd_sc_hd__decap_3
Xoutput103 net103 VGND VGND VPWR VPWR mem_la_wdata[15] sky130_fd_sc_hd__clkbuf_4
Xoutput125 net125 VGND VGND VPWR VPWR mem_la_wdata[6] sky130_fd_sc_hd__clkbuf_4
XFILLER_0_113_669 VGND VGND VPWR VPWR sky130_fd_sc_hd__decap_3
X_16179_ clknet_leaf_29_clk _00797_ VGND VGND VPWR VPWR net52 sky130_fd_sc_hd__dfxtp_1
Xoutput114 net114 VGND VGND VPWR VPWR mem_la_wdata[25] sky130_fd_sc_hd__clkbuf_4
Xoutput136 net136 VGND VGND VPWR VPWR mem_wdata[10] sky130_fd_sc_hd__clkbuf_4
XFILLER_0_100_319 VGND VGND VPWR VPWR sky130_fd_sc_hd__fill_2
Xoutput158 net158 VGND VGND VPWR VPWR mem_wdata[30] sky130_fd_sc_hd__clkbuf_4
Xoutput147 net147 VGND VGND VPWR VPWR mem_wdata[20] sky130_fd_sc_hd__clkbuf_4
Xoutput169 net169 VGND VGND VPWR VPWR mem_wstrb[2] sky130_fd_sc_hd__clkbuf_4
X_07952_ _02197_ _02351_ _02355_ VGND VGND VPWR VPWR _02356_ sky130_fd_sc_hd__a21oi_1
X_07883_ _02274_ _02275_ _02276_ VGND VGND VPWR VPWR _02291_ sky130_fd_sc_hd__a21bo_1
X_09622_ _03653_ _03853_ _03854_ _02309_ VGND VGND VPWR VPWR _03855_ sky130_fd_sc_hd__o211a_1
X_09553_ net182 decoded_imm\[1\] VGND VGND VPWR VPWR _03787_ sky130_fd_sc_hd__nand2_1
XFILLER_0_78_645 VGND VGND VPWR VPWR sky130_fd_sc_hd__fill_2
X_08504_ _02263_ _02753_ _02880_ _02881_ VGND VGND VPWR VPWR _02882_ sky130_fd_sc_hd__o22a_1
XFILLER_0_93_615 VGND VGND VPWR VPWR sky130_fd_sc_hd__fill_1
X_09484_ _03718_ VGND VGND VPWR VPWR _03719_ sky130_fd_sc_hd__clkbuf_8
XFILLER_0_38_509 VGND VGND VPWR VPWR sky130_fd_sc_hd__fill_2
X_08435_ net188 _02813_ _02815_ VGND VGND VPWR VPWR _02816_ sky130_fd_sc_hd__o21ai_1
XFILLER_0_53_92 VGND VGND VPWR VPWR sky130_fd_sc_hd__decap_3
X_08366_ _02728_ _02731_ _02734_ _02746_ VGND VGND VPWR VPWR _02747_ sky130_fd_sc_hd__and4_2
XFILLER_0_108_408 VGND VGND VPWR VPWR sky130_fd_sc_hd__decap_3
XFILLER_0_80_309 VGND VGND VPWR VPWR sky130_fd_sc_hd__decap_6
X_08297_ net202 net248 VGND VGND VPWR VPWR _02678_ sky130_fd_sc_hd__or2_1
XFILLER_0_6_661 VGND VGND VPWR VPWR sky130_fd_sc_hd__fill_1
XFILLER_0_33_225 VGND VGND VPWR VPWR sky130_fd_sc_hd__fill_1
XFILLER_0_116_485 VGND VGND VPWR VPWR sky130_fd_sc_hd__fill_2
XFILLER_0_103_113 VGND VGND VPWR VPWR sky130_fd_sc_hd__fill_1
X_10190_ cpuregs\[8\]\[17\] cpuregs\[9\]\[17\] cpuregs\[10\]\[17\] cpuregs\[11\]\[17\]
+ _03881_ _03718_ VGND VGND VPWR VPWR _04409_ sky130_fd_sc_hd__mux4_1
X_12900_ cpuregs\[20\]\[1\] cpuregs\[21\]\[1\] cpuregs\[22\]\[1\] cpuregs\[23\]\[1\]
+ _03329_ _03330_ VGND VGND VPWR VPWR _06398_ sky130_fd_sc_hd__mux4_1
X_13880_ _07331_ VGND VGND VPWR VPWR _00847_ sky130_fd_sc_hd__clkbuf_1
XTAP_2000 VGND VPWR sky130_fd_sc_hd__tapvpwrvgnd_1
X_12831_ _02189_ _02171_ _02193_ VGND VGND VPWR VPWR _06333_ sky130_fd_sc_hd__a21o_1
XTAP_2033 VGND VPWR sky130_fd_sc_hd__tapvpwrvgnd_1
XTAP_2011 VGND VPWR sky130_fd_sc_hd__tapvpwrvgnd_1
XTAP_2022 VGND VPWR sky130_fd_sc_hd__tapvpwrvgnd_1
XFILLER_0_68_111 VPWR VGND VPWR VGND sky130_ef_sc_hd__decap_12
XTAP_2077 VGND VPWR sky130_fd_sc_hd__tapvpwrvgnd_1
XTAP_2066 VGND VPWR sky130_fd_sc_hd__tapvpwrvgnd_1
XTAP_2055 VGND VPWR sky130_fd_sc_hd__tapvpwrvgnd_1
XTAP_2044 VGND VPWR sky130_fd_sc_hd__tapvpwrvgnd_1
XTAP_1332 VGND VPWR sky130_fd_sc_hd__tapvpwrvgnd_1
XTAP_1321 VGND VPWR sky130_fd_sc_hd__tapvpwrvgnd_1
XTAP_1310 VGND VPWR sky130_fd_sc_hd__tapvpwrvgnd_1
XFILLER_0_68_155 VGND VGND VPWR VPWR sky130_fd_sc_hd__decap_8
X_15550_ clknet_leaf_124_clk _00200_ VGND VGND VPWR VPWR cpuregs\[2\]\[4\] sky130_fd_sc_hd__dfxtp_1
X_12762_ net540 net86 _06294_ VGND VGND VPWR VPWR _06295_ sky130_fd_sc_hd__mux2_1
XTAP_2099 VGND VPWR sky130_fd_sc_hd__tapvpwrvgnd_1
XTAP_2088 VGND VPWR sky130_fd_sc_hd__tapvpwrvgnd_1
X_11713_ net685 _05215_ _05469_ VGND VGND VPWR VPWR _05476_ sky130_fd_sc_hd__mux2_1
X_15481_ clknet_leaf_94_clk _00131_ VGND VGND VPWR VPWR cpuregs\[12\]\[31\] sky130_fd_sc_hd__dfxtp_1
XTAP_1354 VGND VPWR sky130_fd_sc_hd__tapvpwrvgnd_1
XTAP_1365 VGND VPWR sky130_fd_sc_hd__tapvpwrvgnd_1
XTAP_1343 VGND VPWR sky130_fd_sc_hd__tapvpwrvgnd_1
X_12693_ count_cycle\[55\] _06230_ count_cycle\[56\] VGND VGND VPWR VPWR _06235_ sky130_fd_sc_hd__a21o_1
X_14501_ _01614_ VGND VGND VPWR VPWR _01126_ sky130_fd_sc_hd__clkbuf_1
X_11644_ _05439_ VGND VGND VPWR VPWR _00509_ sky130_fd_sc_hd__clkbuf_1
XTAP_1398 VGND VPWR sky130_fd_sc_hd__tapvpwrvgnd_1
XTAP_1387 VGND VPWR sky130_fd_sc_hd__tapvpwrvgnd_1
XTAP_1376 VGND VPWR sky130_fd_sc_hd__tapvpwrvgnd_1
XFILLER_0_49_391 VGND VGND VPWR VPWR sky130_fd_sc_hd__fill_1
X_14432_ net1605 _05163_ _01576_ VGND VGND VPWR VPWR _01578_ sky130_fd_sc_hd__mux2_1
XFILLER_0_126_249 VGND VGND VPWR VPWR sky130_fd_sc_hd__decap_3
X_11575_ _05037_ net1284 _05397_ VGND VGND VPWR VPWR _05403_ sky130_fd_sc_hd__mux2_1
Xinput16 mem_rdata[23] VGND VGND VPWR VPWR net16 sky130_fd_sc_hd__clkbuf_4
Xinput27 mem_rdata[4] VGND VGND VPWR VPWR net27 sky130_fd_sc_hd__clkbuf_2
X_14363_ _07617_ VGND VGND VPWR VPWR _01029_ sky130_fd_sc_hd__clkbuf_1
X_16102_ clknet_leaf_146_clk _00752_ VGND VGND VPWR VPWR count_cycle\[45\] sky130_fd_sc_hd__dfxtp_1
XFILLER_0_135_783 VGND VGND VPWR VPWR sky130_fd_sc_hd__fill_1
X_13314_ _03335_ VGND VGND VPWR VPWR _06798_ sky130_fd_sc_hd__buf_4
X_10526_ cpuregs\[2\]\[26\] cpuregs\[3\]\[26\] _03898_ VGND VGND VPWR VPWR _04736_
+ sky130_fd_sc_hd__mux2_1
X_14294_ _07569_ _07573_ _07577_ _07575_ net1656 VGND VGND VPWR VPWR _01000_ sky130_fd_sc_hd__o32a_1
XFILLER_0_24_269 VGND VGND VPWR VPWR sky130_fd_sc_hd__fill_2
XFILLER_0_40_707 VGND VGND VPWR VPWR sky130_fd_sc_hd__fill_1
XFILLER_0_122_466 VGND VGND VPWR VPWR sky130_fd_sc_hd__decap_8
X_10457_ decoded_imm\[24\] net187 VGND VGND VPWR VPWR _04669_ sky130_fd_sc_hd__nand2_1
X_16033_ clknet_leaf_10_clk _00683_ VGND VGND VPWR VPWR reg_next_pc\[8\] sky130_fd_sc_hd__dfxtp_1
X_13245_ cpuregs\[8\]\[14\] cpuregs\[9\]\[14\] _06422_ VGND VGND VPWR VPWR _06730_
+ sky130_fd_sc_hd__mux2_1
XFILLER_0_58_26 VGND VGND VPWR VPWR sky130_fd_sc_hd__fill_2
X_10388_ cpuregs\[28\]\[22\] cpuregs\[29\]\[22\] cpuregs\[30\]\[22\] cpuregs\[31\]\[22\]
+ _03941_ _03942_ VGND VGND VPWR VPWR _04602_ sky130_fd_sc_hd__mux4_1
XFILLER_0_103_691 VGND VGND VPWR VPWR sky130_fd_sc_hd__fill_1
X_13176_ _06663_ VGND VGND VPWR VPWR _00817_ sky130_fd_sc_hd__clkbuf_1
X_12127_ _05735_ _05757_ _05758_ _05730_ VGND VGND VPWR VPWR _00673_ sky130_fd_sc_hd__o211a_1
X_16935_ clknet_leaf_78_clk _01499_ VGND VGND VPWR VPWR cpuregs\[0\]\[22\] sky130_fd_sc_hd__dfxtp_1
X_12058_ _03502_ reg_next_pc\[9\] _03222_ VGND VGND VPWR VPWR _05710_ sky130_fd_sc_hd__mux2_2
X_11009_ _05086_ VGND VGND VPWR VPWR _00227_ sky130_fd_sc_hd__clkbuf_1
X_16866_ clknet_leaf_55_clk _01430_ VGND VGND VPWR VPWR cpuregs\[22\]\[17\] sky130_fd_sc_hd__dfxtp_1
X_15817_ clknet_leaf_53_clk _00467_ VGND VGND VPWR VPWR cpuregs\[16\]\[15\] sky130_fd_sc_hd__dfxtp_1
XFILLER_0_87_431 VGND VGND VPWR VPWR sky130_fd_sc_hd__fill_2
XFILLER_0_59_111 VGND VGND VPWR VPWR sky130_fd_sc_hd__fill_1
X_16797_ clknet_leaf_107_clk _01361_ VGND VGND VPWR VPWR cpuregs\[6\]\[12\] sky130_fd_sc_hd__dfxtp_1
XFILLER_0_59_155 VGND VGND VPWR VPWR sky130_fd_sc_hd__decap_6
X_15748_ clknet_leaf_105_clk _00398_ VGND VGND VPWR VPWR cpuregs\[15\]\[10\] sky130_fd_sc_hd__dfxtp_1
XFILLER_0_118_717 VGND VGND VPWR VPWR sky130_fd_sc_hd__fill_1
X_08220_ _02221_ _02465_ _02604_ _02160_ _02605_ VGND VGND VPWR VPWR _02606_ sky130_fd_sc_hd__a32o_1
XFILLER_0_74_147 VGND VGND VPWR VPWR sky130_fd_sc_hd__fill_1
X_15679_ clknet_leaf_129_clk _00329_ VGND VGND VPWR VPWR cpuregs\[27\]\[5\] sky130_fd_sc_hd__dfxtp_1
XFILLER_0_28_520 VGND VGND VPWR VPWR sky130_fd_sc_hd__fill_1
XFILLER_0_43_501 VGND VGND VPWR VPWR sky130_fd_sc_hd__decap_3
X_08151_ reg_pc\[23\] decoded_imm\[23\] VGND VGND VPWR VPWR _02541_ sky130_fd_sc_hd__nor2_1
XFILLER_0_15_225 VGND VGND VPWR VPWR sky130_fd_sc_hd__decap_3
XFILLER_0_130_41 VGND VGND VPWR VPWR sky130_fd_sc_hd__decap_4
X_08082_ _02459_ _02463_ _02460_ VGND VGND VPWR VPWR _02477_ sky130_fd_sc_hd__a21oi_1
XFILLER_0_130_85 VGND VGND VPWR VPWR sky130_fd_sc_hd__fill_1
XFILLER_0_113_455 VGND VGND VPWR VPWR sky130_fd_sc_hd__fill_2
XFILLER_0_70_397 VGND VGND VPWR VPWR sky130_fd_sc_hd__fill_1
X_08984_ reg_out\[27\] reg_next_pc\[27\] _03270_ VGND VGND VPWR VPWR _03281_ sky130_fd_sc_hd__mux2_1
X_07935_ net201 VGND VGND VPWR VPWR _02340_ sky130_fd_sc_hd__clkbuf_4
X_07866_ reg_pc\[4\] decoded_imm\[4\] VGND VGND VPWR VPWR _02275_ sky130_fd_sc_hd__nand2_1
X_09605_ _03674_ VGND VGND VPWR VPWR _03839_ sky130_fd_sc_hd__buf_6
X_07797_ _02210_ _02135_ VGND VGND VPWR VPWR _02211_ sky130_fd_sc_hd__or2b_1
X_09536_ _03724_ _03765_ _03770_ _03732_ VGND VGND VPWR VPWR _03771_ sky130_fd_sc_hd__o211a_1
XFILLER_0_66_637 VGND VGND VPWR VPWR sky130_fd_sc_hd__fill_1
X_09467_ _03690_ _03701_ _03702_ VGND VGND VPWR VPWR _03703_ sky130_fd_sc_hd__a21oi_1
XFILLER_0_38_306 VGND VGND VPWR VPWR sky130_fd_sc_hd__fill_2
XFILLER_0_93_445 VGND VGND VPWR VPWR sky130_fd_sc_hd__decap_3
X_08418_ _02676_ _02797_ _02798_ VGND VGND VPWR VPWR _02799_ sky130_fd_sc_hd__a21o_1
X_09398_ _03636_ VGND VGND VPWR VPWR _00066_ sky130_fd_sc_hd__clkbuf_1
XFILLER_0_65_169 VGND VGND VPWR VPWR sky130_fd_sc_hd__fill_1
X_08349_ net189 net221 VGND VGND VPWR VPWR _02730_ sky130_fd_sc_hd__nand2_1
X_11360_ _05026_ net1556 _05288_ VGND VGND VPWR VPWR _05289_ sky130_fd_sc_hd__mux2_1
XFILLER_0_22_707 VGND VGND VPWR VPWR sky130_fd_sc_hd__fill_1
X_10311_ cpuregs\[0\]\[20\] cpuregs\[1\]\[20\] _03902_ VGND VGND VPWR VPWR _04527_
+ sky130_fd_sc_hd__mux2_1
XFILLER_0_61_364 VGND VGND VPWR VPWR sky130_fd_sc_hd__fill_1
X_11291_ net1275 _05202_ _05251_ VGND VGND VPWR VPWR _05252_ sky130_fd_sc_hd__mux2_1
X_13030_ cpuregs\[22\]\[7\] cpuregs\[23\]\[7\] _06450_ VGND VGND VPWR VPWR _06522_
+ sky130_fd_sc_hd__mux2_1
XFILLER_0_131_285 VGND VGND VPWR VPWR sky130_fd_sc_hd__fill_1
X_10242_ _03901_ _04459_ _03731_ VGND VGND VPWR VPWR _04460_ sky130_fd_sc_hd__a21o_1
X_10173_ cpuregs\[28\]\[16\] cpuregs\[29\]\[16\] cpuregs\[30\]\[16\] cpuregs\[31\]\[16\]
+ _03941_ _03942_ VGND VGND VPWR VPWR _04393_ sky130_fd_sc_hd__mux4_1
XFILLER_0_28_29 VGND VGND VPWR VPWR sky130_fd_sc_hd__fill_1
X_16720_ clknet_leaf_13_clk _00026_ VGND VGND VPWR VPWR mem_wordsize\[2\] sky130_fd_sc_hd__dfxtp_2
X_14981_ _03464_ net1139 _01865_ VGND VGND VPWR VPWR _01869_ sky130_fd_sc_hd__mux2_1
X_13932_ _07366_ VGND VGND VPWR VPWR _00861_ sky130_fd_sc_hd__clkbuf_1
X_16651_ clknet_leaf_61_clk _01218_ VGND VGND VPWR VPWR cpuregs\[23\]\[29\] sky130_fd_sc_hd__dfxtp_1
X_13863_ _01098_ VGND VGND VPWR VPWR _07318_ sky130_fd_sc_hd__inv_2
X_15602_ clknet_leaf_59_clk _00252_ VGND VGND VPWR VPWR cpuregs\[28\]\[24\] sky130_fd_sc_hd__dfxtp_1
X_12814_ net512 net83 _06313_ VGND VGND VPWR VPWR _06322_ sky130_fd_sc_hd__mux2_1
X_13794_ cpuregs\[10\]\[31\] cpuregs\[11\]\[31\] _03347_ VGND VGND VPWR VPWR _07262_
+ sky130_fd_sc_hd__mux2_1
X_16582_ clknet_leaf_140_clk _00006_ VGND VGND VPWR VPWR reg_sh\[4\] sky130_fd_sc_hd__dfxtp_1
X_15533_ clknet_leaf_90_clk _00183_ VGND VGND VPWR VPWR cpuregs\[13\]\[19\] sky130_fd_sc_hd__dfxtp_1
X_12745_ _03668_ _06278_ VGND VGND VPWR VPWR _06279_ sky130_fd_sc_hd__and2_1
XFILLER_0_69_497 VGND VGND VPWR VPWR sky130_fd_sc_hd__decap_6
XTAP_1140 VGND VPWR sky130_fd_sc_hd__tapvpwrvgnd_1
XTAP_1162 VGND VPWR sky130_fd_sc_hd__tapvpwrvgnd_1
XTAP_1173 VGND VPWR sky130_fd_sc_hd__tapvpwrvgnd_1
XTAP_1151 VGND VPWR sky130_fd_sc_hd__tapvpwrvgnd_1
X_15464_ clknet_leaf_105_clk _00114_ VGND VGND VPWR VPWR cpuregs\[12\]\[14\] sky130_fd_sc_hd__dfxtp_1
XTAP_1195 VGND VPWR sky130_fd_sc_hd__tapvpwrvgnd_1
XTAP_1184 VGND VPWR sky130_fd_sc_hd__tapvpwrvgnd_1
X_12676_ count_cycle\[51\] _06219_ VGND VGND VPWR VPWR _06223_ sky130_fd_sc_hd__or2_1
X_14415_ _01568_ VGND VGND VPWR VPWR _01054_ sky130_fd_sc_hd__clkbuf_1
X_11627_ _05430_ VGND VGND VPWR VPWR _00501_ sky130_fd_sc_hd__clkbuf_1
X_15395_ clknet_leaf_102_clk _00050_ VGND VGND VPWR VPWR cpuregs\[11\]\[13\] sky130_fd_sc_hd__dfxtp_1
X_11558_ _05020_ net901 _05386_ VGND VGND VPWR VPWR _05394_ sky130_fd_sc_hd__mux2_1
X_14346_ _07320_ decoded_imm_j\[5\] _07588_ mem_rdata_q\[25\] _07357_ VGND VGND VPWR
+ VPWR _07606_ sky130_fd_sc_hd__a221o_1
XFILLER_0_52_342 VGND VGND VPWR VPWR sky130_fd_sc_hd__fill_2
X_10509_ _04719_ _02578_ _04509_ VGND VGND VPWR VPWR _04720_ sky130_fd_sc_hd__mux2_1
Xhold608 cpuregs\[30\]\[10\] VGND VGND VPWR VPWR net966 sky130_fd_sc_hd__dlygate4sd3_1
XFILLER_0_25_578 VGND VGND VPWR VPWR sky130_fd_sc_hd__fill_2
XFILLER_0_122_274 VGND VGND VPWR VPWR sky130_fd_sc_hd__decap_3
X_16016_ clknet_leaf_32_clk _00666_ VGND VGND VPWR VPWR reg_pc\[22\] sky130_fd_sc_hd__dfxtp_2
X_11489_ net647 _05196_ _05349_ VGND VGND VPWR VPWR _05357_ sky130_fd_sc_hd__mux2_1
Xhold619 cpuregs\[30\]\[6\] VGND VGND VPWR VPWR net977 sky130_fd_sc_hd__dlygate4sd3_1
X_14277_ _02508_ net464 _03653_ _07564_ VGND VGND VPWR VPWR _00996_ sky130_fd_sc_hd__a31o_1
X_13228_ _06518_ _06713_ VGND VGND VPWR VPWR _06714_ sky130_fd_sc_hd__or2_1
XFILLER_0_21_762 VGND VGND VPWR VPWR sky130_fd_sc_hd__fill_2
XFILLER_0_85_24 VGND VGND VPWR VPWR sky130_fd_sc_hd__decap_6
X_13159_ _06631_ _06637_ _06646_ VGND VGND VPWR VPWR _06647_ sky130_fd_sc_hd__or3_2
XTAP_935 VGND VPWR sky130_fd_sc_hd__tapvpwrvgnd_1
XTAP_902 VGND VPWR sky130_fd_sc_hd__tapvpwrvgnd_1
XTAP_913 VGND VPWR sky130_fd_sc_hd__tapvpwrvgnd_1
XTAP_924 VGND VPWR sky130_fd_sc_hd__tapvpwrvgnd_1
XFILLER_0_85_57 VGND VGND VPWR VPWR sky130_fd_sc_hd__decap_3
XTAP_968 VGND VPWR sky130_fd_sc_hd__tapvpwrvgnd_1
XTAP_957 VGND VPWR sky130_fd_sc_hd__tapvpwrvgnd_1
XTAP_946 VGND VPWR sky130_fd_sc_hd__tapvpwrvgnd_1
XFILLER_0_40_9 VGND VGND VPWR VPWR sky130_fd_sc_hd__decap_3
XFILLER_0_109_75 VGND VGND VPWR VPWR sky130_fd_sc_hd__fill_1
X_07720_ _02143_ _02106_ _02144_ _02104_ VGND VGND VPWR VPWR _00025_ sky130_fd_sc_hd__a22o_1
XTAP_979 VGND VPWR sky130_fd_sc_hd__tapvpwrvgnd_1
XFILLER_0_18_51 VGND VGND VPWR VPWR sky130_fd_sc_hd__fill_1
X_16918_ clknet_leaf_112_clk _01482_ VGND VGND VPWR VPWR cpuregs\[0\]\[5\] sky130_fd_sc_hd__dfxtp_1
X_07651_ _02080_ VGND VGND VPWR VPWR _02081_ sky130_fd_sc_hd__buf_4
X_16849_ clknet_leaf_126_clk _01413_ VGND VGND VPWR VPWR cpuregs\[22\]\[0\] sky130_fd_sc_hd__dfxtp_1
X_09321_ _03546_ _03566_ _03567_ _03569_ VGND VGND VPWR VPWR _03570_ sky130_fd_sc_hd__a22o_2
XFILLER_0_118_514 VGND VGND VPWR VPWR sky130_fd_sc_hd__fill_2
XFILLER_0_48_648 VGND VGND VPWR VPWR sky130_fd_sc_hd__fill_1
XFILLER_0_8_712 VGND VGND VPWR VPWR sky130_fd_sc_hd__fill_1
XFILLER_0_8_701 VGND VGND VPWR VPWR sky130_fd_sc_hd__decap_8
XFILLER_0_75_467 VPWR VGND VPWR VGND sky130_ef_sc_hd__decap_12
X_09252_ _03434_ _03506_ _03508_ _03509_ VGND VGND VPWR VPWR _03510_ sky130_fd_sc_hd__a22o_2
XFILLER_0_7_211 VPWR VGND VPWR VGND sky130_ef_sc_hd__decap_12
X_08203_ _02587_ _02589_ VGND VGND VPWR VPWR _02590_ sky130_fd_sc_hd__nand2_1
XFILLER_0_62_117 VGND VGND VPWR VPWR sky130_fd_sc_hd__decap_3
X_09183_ reg_pc\[1\] _03448_ _03449_ VGND VGND VPWR VPWR _03450_ sky130_fd_sc_hd__mux2_4
X_08134_ _02286_ _02516_ _02525_ VGND VGND VPWR VPWR _07631_ sky130_fd_sc_hd__o21a_1
XFILLER_0_43_331 VGND VGND VPWR VPWR sky130_fd_sc_hd__fill_2
XFILLER_0_70_161 VPWR VGND VPWR VGND sky130_ef_sc_hd__decap_12
XFILLER_0_113_252 VGND VGND VPWR VPWR sky130_fd_sc_hd__decap_4
X_08065_ _02460_ VGND VGND VPWR VPWR _02461_ sky130_fd_sc_hd__inv_2
Xpicorv32_350 VGND VGND VPWR VPWR picorv32_350/HI trace_data[28] sky130_fd_sc_hd__conb_1
XFILLER_0_12_773 VPWR VGND VPWR VGND sky130_ef_sc_hd__decap_12
X_08967_ _03269_ VGND VGND VPWR VPWR net77 sky130_fd_sc_hd__buf_4
X_08898_ net227 _02448_ _03212_ VGND VGND VPWR VPWR net121 sky130_fd_sc_hd__a21o_2
X_07918_ _02321_ _02322_ _02147_ VGND VGND VPWR VPWR _02324_ sky130_fd_sc_hd__o21a_1
X_07849_ _02257_ _02254_ _02255_ _02148_ VGND VGND VPWR VPWR _02259_ sky130_fd_sc_hd__o31a_1
X_10860_ _04995_ net1291 _04985_ VGND VGND VPWR VPWR _04996_ sky130_fd_sc_hd__mux2_1
XPHY_201 VGND VGND VPWR VPWR sky130_fd_sc_hd__decap_3
X_09519_ _00012_ VGND VGND VPWR VPWR _03754_ sky130_fd_sc_hd__clkbuf_8
XFILLER_0_78_261 VGND VGND VPWR VPWR sky130_fd_sc_hd__decap_8
XPHY_234 VGND VGND VPWR VPWR sky130_fd_sc_hd__decap_3
XPHY_223 VGND VGND VPWR VPWR sky130_fd_sc_hd__decap_3
XPHY_212 VGND VGND VPWR VPWR sky130_fd_sc_hd__decap_3
X_10791_ _04955_ VGND VGND VPWR VPWR _00140_ sky130_fd_sc_hd__clkbuf_1
XPHY_267 VGND VGND VPWR VPWR sky130_fd_sc_hd__decap_3
XPHY_256 VGND VGND VPWR VPWR sky130_fd_sc_hd__decap_3
XPHY_245 VGND VGND VPWR VPWR sky130_fd_sc_hd__decap_3
X_12530_ count_cycle\[8\] count_cycle\[9\] VGND VGND VPWR VPWR _06118_ sky130_fd_sc_hd__and2_1
XFILLER_0_38_169 VGND VGND VPWR VPWR sky130_fd_sc_hd__decap_6
XPHY_278 VGND VGND VPWR VPWR sky130_fd_sc_hd__decap_3
X_12461_ _05769_ _06061_ _06062_ _02166_ _06063_ VGND VGND VPWR VPWR _06064_ sky130_fd_sc_hd__a221o_1
XFILLER_0_53_117 VGND VGND VPWR VPWR sky130_fd_sc_hd__fill_2
XFILLER_0_30_19 VGND VGND VPWR VPWR sky130_fd_sc_hd__fill_2
X_11412_ _05316_ VGND VGND VPWR VPWR _00400_ sky130_fd_sc_hd__clkbuf_1
X_14200_ _07524_ VGND VGND VPWR VPWR _00959_ sky130_fd_sc_hd__clkbuf_1
X_15180_ _01974_ VGND VGND VPWR VPWR _01445_ sky130_fd_sc_hd__clkbuf_1
X_12392_ _05739_ _05999_ _06000_ _02154_ VGND VGND VPWR VPWR _06001_ sky130_fd_sc_hd__o22a_1
X_14131_ _07485_ VGND VGND VPWR VPWR _00929_ sky130_fd_sc_hd__clkbuf_1
XFILLER_0_61_183 VGND VGND VPWR VPWR sky130_fd_sc_hd__fill_2
X_11343_ _05010_ net1583 _05277_ VGND VGND VPWR VPWR _05280_ sky130_fd_sc_hd__mux2_1
XFILLER_0_1_409 VGND VGND VPWR VPWR sky130_fd_sc_hd__decap_4
XFILLER_0_132_583 VGND VGND VPWR VPWR sky130_fd_sc_hd__fill_2
X_11274_ net735 _05186_ _05240_ VGND VGND VPWR VPWR _05243_ sky130_fd_sc_hd__mux2_1
X_14062_ _07447_ VGND VGND VPWR VPWR _01103_ sky130_fd_sc_hd__buf_1
X_10225_ _04372_ _04402_ VGND VGND VPWR VPWR _04443_ sky130_fd_sc_hd__nand2_1
X_13013_ _06351_ _06504_ _03377_ VGND VGND VPWR VPWR _06505_ sky130_fd_sc_hd__a21o_1
X_10156_ _02426_ _02468_ _03997_ VGND VGND VPWR VPWR _04376_ sky130_fd_sc_hd__mux2_1
X_14964_ _01859_ VGND VGND VPWR VPWR _01344_ sky130_fd_sc_hd__clkbuf_1
X_10087_ cpuregs\[4\]\[14\] cpuregs\[5\]\[14\] cpuregs\[6\]\[14\] cpuregs\[7\]\[14\]
+ _03894_ _04090_ VGND VGND VPWR VPWR _04309_ sky130_fd_sc_hd__mux4_1
X_16703_ clknet_leaf_89_clk _01270_ VGND VGND VPWR VPWR cpuregs\[3\]\[17\] sky130_fd_sc_hd__dfxtp_1
X_13915_ _07324_ VGND VGND VPWR VPWR _07357_ sky130_fd_sc_hd__clkbuf_4
X_14895_ _03622_ net920 _01815_ VGND VGND VPWR VPWR _01823_ sky130_fd_sc_hd__mux2_1
X_16634_ clknet_leaf_137_clk _01201_ VGND VGND VPWR VPWR cpuregs\[23\]\[12\] sky130_fd_sc_hd__dfxtp_1
XFILLER_0_97_581 VGND VGND VPWR VPWR sky130_fd_sc_hd__fill_1
XFILLER_0_69_272 VGND VGND VPWR VPWR sky130_fd_sc_hd__fill_2
X_13846_ _07307_ VGND VGND VPWR VPWR _01094_ sky130_fd_sc_hd__clkbuf_1
X_10989_ _05076_ VGND VGND VPWR VPWR _00217_ sky130_fd_sc_hd__clkbuf_1
X_13777_ _06382_ _07245_ VGND VGND VPWR VPWR _07246_ sky130_fd_sc_hd__or2_1
X_16565_ clknet_leaf_95_clk _01142_ VGND VGND VPWR VPWR cpuregs\[24\]\[17\] sky130_fd_sc_hd__dfxtp_1
X_12728_ _04116_ _06257_ _06261_ _04063_ VGND VGND VPWR VPWR _06262_ sky130_fd_sc_hd__o211a_1
X_16496_ clknet_leaf_97_clk _01078_ VGND VGND VPWR VPWR cpuregs\[19\]\[17\] sky130_fd_sc_hd__dfxtp_1
X_15516_ clknet_leaf_131_clk _00166_ VGND VGND VPWR VPWR cpuregs\[13\]\[2\] sky130_fd_sc_hd__dfxtp_1
XFILLER_0_127_355 VGND VGND VPWR VPWR sky130_fd_sc_hd__fill_1
X_15447_ clknet_leaf_40_clk _00097_ VGND VGND VPWR VPWR net191 sky130_fd_sc_hd__dfxtp_4
X_12659_ count_cycle\[47\] _06207_ VGND VGND VPWR VPWR _06210_ sky130_fd_sc_hd__and2_1
XFILLER_0_112_3 VPWR VGND VPWR VGND sky130_ef_sc_hd__decap_12
X_15378_ mem_state\[0\] mem_state\[1\] VGND VGND VPWR VPWR _02077_ sky130_fd_sc_hd__nand2_1
XFILLER_0_111_98 VGND VGND VPWR VPWR sky130_fd_sc_hd__decap_4
X_14329_ _06025_ decoded_imm_j\[13\] _07570_ mem_rdata_q\[13\] _07388_ VGND VGND VPWR
+ VPWR _07597_ sky130_fd_sc_hd__a221o_1
Xhold416 cpuregs\[14\]\[17\] VGND VGND VPWR VPWR net774 sky130_fd_sc_hd__dlygate4sd3_1
Xhold427 cpuregs\[22\]\[14\] VGND VGND VPWR VPWR net785 sky130_fd_sc_hd__dlygate4sd3_1
Xhold405 cpuregs\[7\]\[9\] VGND VGND VPWR VPWR net763 sky130_fd_sc_hd__dlygate4sd3_1
XFILLER_0_111_745 VGND VGND VPWR VPWR sky130_fd_sc_hd__fill_2
XFILLER_0_110_222 VGND VGND VPWR VPWR sky130_fd_sc_hd__decap_4
XFILLER_0_110_211 VGND VGND VPWR VPWR sky130_fd_sc_hd__decap_3
Xhold438 cpuregs\[22\]\[4\] VGND VGND VPWR VPWR net796 sky130_fd_sc_hd__dlygate4sd3_1
Xhold449 cpuregs\[3\]\[9\] VGND VGND VPWR VPWR net807 sky130_fd_sc_hd__dlygate4sd3_1
XFILLER_0_111_767 VGND VGND VPWR VPWR sky130_fd_sc_hd__fill_2
X_09870_ cpuregs\[28\]\[8\] cpuregs\[29\]\[8\] cpuregs\[30\]\[8\] cpuregs\[31\]\[8\]
+ _03865_ _03942_ VGND VGND VPWR VPWR _04098_ sky130_fd_sc_hd__mux4_1
XTAP_710 VGND VPWR sky130_fd_sc_hd__tapvpwrvgnd_1
X_08821_ _03172_ _03173_ VGND VGND VPWR VPWR _03174_ sky130_fd_sc_hd__and2_1
XTAP_721 VGND VPWR sky130_fd_sc_hd__tapvpwrvgnd_1
XTAP_732 VGND VPWR sky130_fd_sc_hd__tapvpwrvgnd_1
XTAP_743 VGND VPWR sky130_fd_sc_hd__tapvpwrvgnd_1
Xhold1105 cpuregs\[21\]\[8\] VGND VGND VPWR VPWR net1463 sky130_fd_sc_hd__dlygate4sd3_1
XTAP_754 VGND VPWR sky130_fd_sc_hd__tapvpwrvgnd_1
XTAP_765 VGND VPWR sky130_fd_sc_hd__tapvpwrvgnd_1
XTAP_776 VGND VPWR sky130_fd_sc_hd__tapvpwrvgnd_1
X_08752_ _02724_ _02986_ _03108_ VGND VGND VPWR VPWR _03109_ sky130_fd_sc_hd__a21o_1
Xhold1127 cpuregs\[29\]\[20\] VGND VGND VPWR VPWR net1485 sky130_fd_sc_hd__dlygate4sd3_1
Xhold1116 cpuregs\[21\]\[24\] VGND VGND VPWR VPWR net1474 sky130_fd_sc_hd__dlygate4sd3_1
Xhold1149 cpuregs\[7\]\[24\] VGND VGND VPWR VPWR net1507 sky130_fd_sc_hd__dlygate4sd3_1
XTAP_798 VGND VPWR sky130_fd_sc_hd__tapvpwrvgnd_1
XTAP_787 VGND VPWR sky130_fd_sc_hd__tapvpwrvgnd_1
Xhold1138 cpu_state\[2\] VGND VGND VPWR VPWR net1496 sky130_fd_sc_hd__dlygate4sd3_1
X_08683_ _03044_ _03045_ VGND VGND VPWR VPWR _03046_ sky130_fd_sc_hd__nor2_1
X_07703_ instr_rdcycle _02126_ _02127_ _02128_ VGND VGND VPWR VPWR _02129_ sky130_fd_sc_hd__or4_1
XFILLER_0_17_3 VGND VGND VPWR VPWR sky130_fd_sc_hd__decap_8
XTAP_1909 VGND VPWR sky130_fd_sc_hd__tapvpwrvgnd_1
XFILLER_0_118_322 VGND VGND VPWR VPWR sky130_fd_sc_hd__decap_3
X_09304_ reg_pc\[17\] _03549_ _03460_ VGND VGND VPWR VPWR _03555_ sky130_fd_sc_hd__o21ai_1
XFILLER_0_76_787 VGND VGND VPWR VPWR sky130_fd_sc_hd__fill_1
XFILLER_0_8_531 VGND VGND VPWR VPWR sky130_fd_sc_hd__fill_1
XFILLER_0_91_724 VGND VGND VPWR VPWR sky130_fd_sc_hd__decap_4
XFILLER_0_75_275 VGND VGND VPWR VPWR sky130_fd_sc_hd__decap_4
X_09235_ _03467_ _03494_ VGND VGND VPWR VPWR _03495_ sky130_fd_sc_hd__nor2_1
XFILLER_0_106_539 VGND VGND VPWR VPWR sky130_fd_sc_hd__fill_1
XFILLER_0_90_245 VGND VGND VPWR VPWR sky130_fd_sc_hd__fill_1
X_09166_ _03433_ VGND VGND VPWR VPWR _03434_ sky130_fd_sc_hd__clkbuf_4
X_08117_ _02222_ _02465_ _02507_ _02508_ _02509_ VGND VGND VPWR VPWR _02510_ sky130_fd_sc_hd__a32o_1
X_09097_ _03317_ VGND VGND VPWR VPWR _03377_ sky130_fd_sc_hd__buf_4
X_08048_ net178 VGND VGND VPWR VPWR _02445_ sky130_fd_sc_hd__clkbuf_4
XFILLER_0_4_781 VPWR VGND VPWR VGND sky130_ef_sc_hd__decap_12
Xhold972 cpuregs\[23\]\[20\] VGND VGND VPWR VPWR net1330 sky130_fd_sc_hd__dlygate4sd3_1
Xhold961 cpuregs\[3\]\[15\] VGND VGND VPWR VPWR net1319 sky130_fd_sc_hd__dlygate4sd3_1
Xhold950 cpuregs\[2\]\[30\] VGND VGND VPWR VPWR net1308 sky130_fd_sc_hd__dlygate4sd3_1
X_10010_ _02081_ _04229_ _04230_ _04233_ _02241_ VGND VGND VPWR VPWR _04234_ sky130_fd_sc_hd__a32o_1
Xhold994 cpuregs\[15\]\[0\] VGND VGND VPWR VPWR net1352 sky130_fd_sc_hd__dlygate4sd3_1
Xhold983 cpuregs\[10\]\[4\] VGND VGND VPWR VPWR net1341 sky130_fd_sc_hd__dlygate4sd3_1
X_09999_ _04223_ _02378_ _04150_ VGND VGND VPWR VPWR _04224_ sky130_fd_sc_hd__mux2_1
X_11961_ count_instr\[44\] _05637_ _05640_ VGND VGND VPWR VPWR _05641_ sky130_fd_sc_hd__a21oi_1
X_13700_ _07171_ net222 _06960_ VGND VGND VPWR VPWR _07172_ sky130_fd_sc_hd__mux2_1
X_10912_ _03590_ VGND VGND VPWR VPWR _05031_ sky130_fd_sc_hd__clkbuf_4
X_14680_ net670 _05207_ _01706_ VGND VGND VPWR VPWR _01709_ sky130_fd_sc_hd__mux2_1
X_11892_ _05585_ _05589_ _05590_ _02164_ VGND VGND VPWR VPWR _00606_ sky130_fd_sc_hd__a211oi_1
X_13631_ _06348_ _07102_ _07104_ _06417_ VGND VGND VPWR VPWR _07105_ sky130_fd_sc_hd__a211o_1
X_10843_ _04903_ _04983_ VGND VGND VPWR VPWR _04984_ sky130_fd_sc_hd__or2_4
X_13562_ cpuregs\[0\]\[23\] cpuregs\[1\]\[23\] cpuregs\[2\]\[23\] cpuregs\[3\]\[23\]
+ _06740_ _06345_ VGND VGND VPWR VPWR _07038_ sky130_fd_sc_hd__mux4_1
X_16350_ clknet_leaf_82_clk _00932_ VGND VGND VPWR VPWR cpuregs\[1\]\[15\] sky130_fd_sc_hd__dfxtp_1
X_10774_ net1368 _03440_ _04946_ VGND VGND VPWR VPWR _04947_ sky130_fd_sc_hd__mux2_1
X_15301_ net466 VGND VGND VPWR VPWR _02036_ sky130_fd_sc_hd__clkbuf_1
XFILLER_0_136_141 VPWR VGND VPWR VGND sky130_ef_sc_hd__decap_12
XFILLER_0_94_584 VGND VGND VPWR VPWR sky130_fd_sc_hd__fill_1
X_12513_ net1371 _06104_ _06106_ VGND VGND VPWR VPWR _00711_ sky130_fd_sc_hd__o21a_1
X_16281_ clknet_leaf_149_clk _00866_ VGND VGND VPWR VPWR instr_andi sky130_fd_sc_hd__dfxtp_1
X_13493_ cpuregs\[4\]\[21\] cpuregs\[5\]\[21\] _06906_ VGND VGND VPWR VPWR _06971_
+ sky130_fd_sc_hd__mux2_1
XFILLER_0_82_757 VGND VGND VPWR VPWR sky130_fd_sc_hd__decap_4
X_15232_ _02001_ VGND VGND VPWR VPWR _01470_ sky130_fd_sc_hd__clkbuf_1
X_12444_ _06038_ _06041_ _06039_ VGND VGND VPWR VPWR _06048_ sky130_fd_sc_hd__a21o_1
X_15163_ net1045 _03609_ _01959_ VGND VGND VPWR VPWR _01965_ sky130_fd_sc_hd__mux2_1
X_12375_ instr_jal _05983_ _05984_ VGND VGND VPWR VPWR _05985_ sky130_fd_sc_hd__and3_1
XFILLER_0_22_312 VGND VGND VPWR VPWR sky130_fd_sc_hd__decap_8
X_15094_ _01928_ VGND VGND VPWR VPWR _01405_ sky130_fd_sc_hd__clkbuf_1
X_14114_ _07476_ VGND VGND VPWR VPWR _00921_ sky130_fd_sc_hd__clkbuf_1
X_11326_ _04993_ net1509 _05266_ VGND VGND VPWR VPWR _05271_ sky130_fd_sc_hd__mux2_1
X_14045_ mem_rdata_q\[31\] net25 _07422_ VGND VGND VPWR VPWR _07439_ sky130_fd_sc_hd__mux2_1
XFILLER_0_120_597 VGND VGND VPWR VPWR sky130_fd_sc_hd__fill_1
X_11257_ net988 _05169_ _05229_ VGND VGND VPWR VPWR _05234_ sky130_fd_sc_hd__mux2_1
X_10208_ _04020_ _04422_ _04426_ _03658_ VGND VGND VPWR VPWR _04427_ sky130_fd_sc_hd__o211a_1
X_11188_ _03531_ VGND VGND VPWR VPWR _05188_ sky130_fd_sc_hd__clkbuf_4
X_10139_ _04359_ _02426_ _04150_ VGND VGND VPWR VPWR _04360_ sky130_fd_sc_hd__mux2_1
X_15996_ clknet_leaf_11_clk _00646_ VGND VGND VPWR VPWR reg_pc\[2\] sky130_fd_sc_hd__dfxtp_4
XFILLER_0_106_21 VGND VGND VPWR VPWR sky130_fd_sc_hd__fill_2
XFILLER_0_89_345 VGND VGND VPWR VPWR sky130_fd_sc_hd__fill_2
X_14947_ _01850_ VGND VGND VPWR VPWR _01336_ sky130_fd_sc_hd__clkbuf_1
X_14878_ _03571_ net826 _01804_ VGND VGND VPWR VPWR _01814_ sky130_fd_sc_hd__mux2_1
X_16617_ clknet_leaf_73_clk _01184_ VGND VGND VPWR VPWR cpuregs\[9\]\[27\] sky130_fd_sc_hd__dfxtp_1
XFILLER_0_106_65 VGND VGND VPWR VPWR sky130_fd_sc_hd__decap_8
X_13829_ _02148_ _05687_ _03437_ VGND VGND VPWR VPWR _07295_ sky130_fd_sc_hd__o21a_1
X_16548_ clknet_leaf_124_clk _01125_ VGND VGND VPWR VPWR cpuregs\[24\]\[0\] sky130_fd_sc_hd__dfxtp_1
XFILLER_0_85_595 VGND VGND VPWR VPWR sky130_fd_sc_hd__fill_2
XFILLER_0_127_152 VGND VGND VPWR VPWR sky130_fd_sc_hd__decap_3
X_09020_ mem_rdata_q\[19\] net11 _03292_ VGND VGND VPWR VPWR _03304_ sky130_fd_sc_hd__mux2_1
X_16479_ clknet_leaf_125_clk _01061_ VGND VGND VPWR VPWR cpuregs\[19\]\[0\] sky130_fd_sc_hd__dfxtp_1
Xclkbuf_leaf_151_clk clknet_4_2_0_clk VGND VGND VPWR VPWR clknet_leaf_151_clk sky130_fd_sc_hd__clkbuf_16
XFILLER_0_14_813 VPWR VGND VPWR VGND sky130_ef_sc_hd__decap_12
Xhold202 net151 VGND VGND VPWR VPWR net560 sky130_fd_sc_hd__dlygate4sd3_1
XFILLER_0_53_492 VGND VGND VPWR VPWR sky130_fd_sc_hd__decap_6
XFILLER_0_5_578 VGND VGND VPWR VPWR sky130_fd_sc_hd__fill_1
XFILLER_0_13_323 VPWR VGND VPWR VGND sky130_ef_sc_hd__decap_12
XFILLER_0_25_183 VGND VGND VPWR VPWR sky130_fd_sc_hd__fill_2
XFILLER_0_40_120 VGND VGND VPWR VPWR sky130_fd_sc_hd__decap_6
Xhold213 net136 VGND VGND VPWR VPWR net571 sky130_fd_sc_hd__dlygate4sd3_1
Xhold235 cpuregs\[14\]\[30\] VGND VGND VPWR VPWR net593 sky130_fd_sc_hd__dlygate4sd3_1
Xhold224 net35 VGND VGND VPWR VPWR net582 sky130_fd_sc_hd__dlygate4sd3_1
Xhold257 net152 VGND VGND VPWR VPWR net615 sky130_fd_sc_hd__dlygate4sd3_1
Xhold268 cpuregs\[11\]\[20\] VGND VGND VPWR VPWR net626 sky130_fd_sc_hd__dlygate4sd3_1
Xhold246 cpuregs\[28\]\[12\] VGND VGND VPWR VPWR net604 sky130_fd_sc_hd__dlygate4sd3_1
X_09922_ _02083_ _04113_ _04114_ _04148_ VGND VGND VPWR VPWR _04149_ sky130_fd_sc_hd__a31o_1
Xhold279 count_instr\[57\] VGND VGND VPWR VPWR net637 sky130_fd_sc_hd__dlygate4sd3_1
X_09853_ _04077_ _04080_ VGND VGND VPWR VPWR _04081_ sky130_fd_sc_hd__xor2_1
XFILLER_0_0_294 VGND VGND VPWR VPWR sky130_fd_sc_hd__fill_2
XTAP_540 VGND VPWR sky130_fd_sc_hd__tapvpwrvgnd_1
XTAP_551 VGND VPWR sky130_fd_sc_hd__tapvpwrvgnd_1
X_08804_ _02934_ _03157_ VGND VGND VPWR VPWR _03158_ sky130_fd_sc_hd__and2_1
XTAP_562 VGND VPWR sky130_fd_sc_hd__tapvpwrvgnd_1
XTAP_573 VGND VPWR sky130_fd_sc_hd__tapvpwrvgnd_1
XTAP_584 VGND VPWR sky130_fd_sc_hd__tapvpwrvgnd_1
X_09784_ _03901_ _04013_ _03796_ VGND VGND VPWR VPWR _04014_ sky130_fd_sc_hd__a21o_1
X_08735_ _03092_ _03079_ _03093_ VGND VGND VPWR VPWR _03094_ sky130_fd_sc_hd__a21o_1
XTAP_595 VGND VPWR sky130_fd_sc_hd__tapvpwrvgnd_1
X_08666_ _03027_ _03028_ _02717_ _03030_ VGND VGND VPWR VPWR alu_out\[16\] sky130_fd_sc_hd__a2bb2o_1
XANTENNA_119 _02584_ VGND VGND VPWR VPWR sky130_fd_sc_hd__diode_2
XTAP_1706 VGND VPWR sky130_fd_sc_hd__tapvpwrvgnd_1
XANTENNA_108 net213 VGND VGND VPWR VPWR sky130_fd_sc_hd__diode_2
XTAP_1739 VGND VPWR sky130_fd_sc_hd__tapvpwrvgnd_1
XTAP_1728 VGND VPWR sky130_fd_sc_hd__tapvpwrvgnd_1
XTAP_1717 VGND VPWR sky130_fd_sc_hd__tapvpwrvgnd_1
XFILLER_0_95_348 VGND VGND VPWR VPWR sky130_fd_sc_hd__decap_8
XFILLER_0_95_337 VGND VGND VPWR VPWR sky130_fd_sc_hd__decap_4
X_08597_ _02963_ _02965_ VGND VGND VPWR VPWR _02967_ sky130_fd_sc_hd__nand2_1
XFILLER_0_49_732 VGND VGND VPWR VPWR sky130_fd_sc_hd__fill_1
XFILLER_0_76_584 VGND VGND VPWR VPWR sky130_fd_sc_hd__decap_4
XFILLER_0_48_275 VGND VGND VPWR VPWR sky130_fd_sc_hd__fill_1
XFILLER_0_64_757 VGND VGND VPWR VPWR sky130_fd_sc_hd__decap_4
XFILLER_0_63_234 VGND VGND VPWR VPWR sky130_fd_sc_hd__decap_4
Xclkbuf_leaf_142_clk clknet_4_3_0_clk VGND VGND VPWR VPWR clknet_leaf_142_clk sky130_fd_sc_hd__clkbuf_16
X_10490_ _03929_ _04698_ _04700_ VGND VGND VPWR VPWR _04701_ sky130_fd_sc_hd__a21o_1
XFILLER_0_133_122 VGND VGND VPWR VPWR sky130_fd_sc_hd__fill_1
XFILLER_0_133_111 VGND VGND VPWR VPWR sky130_fd_sc_hd__fill_1
X_09218_ reg_out\[6\] alu_out_q\[6\] _03435_ VGND VGND VPWR VPWR _03480_ sky130_fd_sc_hd__mux2_1
XFILLER_0_133_155 VGND VGND VPWR VPWR sky130_fd_sc_hd__decap_6
X_09149_ decoded_imm_j\[1\] _01114_ _03296_ VGND VGND VPWR VPWR _03424_ sky130_fd_sc_hd__mux2_2
XFILLER_0_16_172 VGND VGND VPWR VPWR sky130_fd_sc_hd__decap_8
XFILLER_0_16_183 VGND VGND VPWR VPWR sky130_fd_sc_hd__fill_2
XFILLER_0_32_643 VGND VGND VPWR VPWR sky130_fd_sc_hd__fill_1
X_12160_ _05693_ _05698_ VGND VGND VPWR VPWR _05787_ sky130_fd_sc_hd__and2_1
XFILLER_0_114_391 VGND VGND VPWR VPWR sky130_fd_sc_hd__fill_2
X_11111_ net1377 _03544_ _05135_ VGND VGND VPWR VPWR _05141_ sky130_fd_sc_hd__mux2_1
XFILLER_0_31_164 VGND VGND VPWR VPWR sky130_fd_sc_hd__decap_4
Xhold791 cpuregs\[6\]\[27\] VGND VGND VPWR VPWR net1149 sky130_fd_sc_hd__dlygate4sd3_1
X_12091_ _03566_ reg_next_pc\[19\] _03222_ VGND VGND VPWR VPWR _05733_ sky130_fd_sc_hd__mux2_2
Xhold780 cpuregs\[7\]\[19\] VGND VGND VPWR VPWR net1138 sky130_fd_sc_hd__dlygate4sd3_1
X_11042_ _05104_ VGND VGND VPWR VPWR _00242_ sky130_fd_sc_hd__clkbuf_1
X_15850_ clknet_leaf_18_clk _00500_ VGND VGND VPWR VPWR cpuregs\[25\]\[16\] sky130_fd_sc_hd__dfxtp_1
X_14801_ net1319 _05192_ _01767_ VGND VGND VPWR VPWR _01773_ sky130_fd_sc_hd__mux2_1
X_15781_ clknet_leaf_135_clk _00431_ VGND VGND VPWR VPWR cpuregs\[26\]\[11\] sky130_fd_sc_hd__dfxtp_1
X_12993_ _03307_ _06478_ _06485_ VGND VGND VPWR VPWR _06486_ sky130_fd_sc_hd__or3_2
XFILLER_0_86_315 VPWR VGND VPWR VGND sky130_ef_sc_hd__decap_12
X_14732_ _01736_ VGND VGND VPWR VPWR _01235_ sky130_fd_sc_hd__clkbuf_1
X_11944_ count_instr\[40\] count_instr\[39\] count_instr\[38\] _05619_ VGND VGND VPWR
+ VPWR _05628_ sky130_fd_sc_hd__and4_1
XFILLER_0_98_197 VGND VGND VPWR VPWR sky130_fd_sc_hd__decap_8
XFILLER_0_98_186 VGND VGND VPWR VPWR sky130_fd_sc_hd__fill_2
X_14663_ net1071 _05190_ _01695_ VGND VGND VPWR VPWR _01700_ sky130_fd_sc_hd__mux2_1
X_11875_ _05578_ VGND VGND VPWR VPWR _00601_ sky130_fd_sc_hd__clkbuf_1
X_16402_ clknet_leaf_72_clk _00984_ VGND VGND VPWR VPWR net156 sky130_fd_sc_hd__dfxtp_1
X_10826_ net669 _03610_ _04968_ VGND VGND VPWR VPWR _04974_ sky130_fd_sc_hd__mux2_1
X_13614_ cpuregs\[10\]\[25\] cpuregs\[11\]\[25\] _03347_ VGND VGND VPWR VPWR _07088_
+ sky130_fd_sc_hd__mux2_1
XFILLER_0_39_242 VGND VGND VPWR VPWR sky130_fd_sc_hd__fill_2
X_14594_ _01663_ VGND VGND VPWR VPWR _01170_ sky130_fd_sc_hd__clkbuf_1
XFILLER_0_55_735 VGND VGND VPWR VPWR sky130_fd_sc_hd__fill_1
XFILLER_0_54_212 VGND VGND VPWR VPWR sky130_fd_sc_hd__fill_1
X_10757_ net620 _03616_ _04929_ VGND VGND VPWR VPWR _04936_ sky130_fd_sc_hd__mux2_1
X_13545_ _06792_ _07019_ _07021_ _06894_ VGND VGND VPWR VPWR _07022_ sky130_fd_sc_hd__a211o_1
XFILLER_0_6_309 VGND VGND VPWR VPWR sky130_fd_sc_hd__fill_1
X_16333_ clknet_leaf_141_clk _00003_ VGND VGND VPWR VPWR is_sltiu_bltu_sltu sky130_fd_sc_hd__dfxtp_1
Xclkbuf_leaf_133_clk clknet_4_9_0_clk VGND VGND VPWR VPWR clknet_leaf_133_clk sky130_fd_sc_hd__clkbuf_16
XFILLER_0_109_196 VGND VGND VPWR VPWR sky130_fd_sc_hd__fill_1
XFILLER_0_109_185 VGND VGND VPWR VPWR sky130_fd_sc_hd__fill_1
X_13476_ _06794_ _06954_ VGND VGND VPWR VPWR _06955_ sky130_fd_sc_hd__and2_1
X_10688_ cpuregs\[16\]\[30\] cpuregs\[17\]\[30\] cpuregs\[18\]\[30\] cpuregs\[19\]\[30\]
+ _03938_ _04028_ VGND VGND VPWR VPWR _04894_ sky130_fd_sc_hd__mux4_1
XFILLER_0_82_598 VGND VGND VPWR VPWR sky130_fd_sc_hd__decap_4
X_16264_ clknet_leaf_140_clk _00849_ VGND VGND VPWR VPWR instr_blt sky130_fd_sc_hd__dfxtp_1
X_12427_ _05773_ _05747_ _05687_ VGND VGND VPWR VPWR _06033_ sky130_fd_sc_hd__a21o_1
X_15215_ _01992_ VGND VGND VPWR VPWR _01462_ sky130_fd_sc_hd__clkbuf_1
XFILLER_0_112_328 VGND VGND VPWR VPWR sky130_fd_sc_hd__fill_2
X_16195_ clknet_leaf_19_clk _00812_ VGND VGND VPWR VPWR net125 sky130_fd_sc_hd__dfxtp_4
XFILLER_0_105_391 VGND VGND VPWR VPWR sky130_fd_sc_hd__fill_1
X_12358_ decoded_imm_j\[19\] _05733_ VGND VGND VPWR VPWR _05969_ sky130_fd_sc_hd__and2_1
X_15146_ net1362 _03557_ _01948_ VGND VGND VPWR VPWR _01956_ sky130_fd_sc_hd__mux2_1
XFILLER_0_23_698 VGND VGND VPWR VPWR sky130_fd_sc_hd__fill_1
X_11309_ net810 _05221_ _05251_ VGND VGND VPWR VPWR _05261_ sky130_fd_sc_hd__mux2_1
X_12289_ _05861_ _05871_ _05905_ VGND VGND VPWR VPWR _05906_ sky130_fd_sc_hd__or3_1
X_15077_ _01919_ VGND VGND VPWR VPWR _01397_ sky130_fd_sc_hd__clkbuf_1
XFILLER_0_77_69 VGND VGND VPWR VPWR sky130_fd_sc_hd__decap_6
XFILLER_0_22_197 VGND VGND VPWR VPWR sky130_fd_sc_hd__fill_1
X_14028_ _07430_ VGND VGND VPWR VPWR _00889_ sky130_fd_sc_hd__clkbuf_1
XFILLER_0_93_24 VPWR VGND VPWR VGND sky130_ef_sc_hd__decap_12
X_15979_ clknet_leaf_151_clk _00629_ VGND VGND VPWR VPWR count_instr\[48\] sky130_fd_sc_hd__dfxtp_1
X_08520_ _02294_ net250 _02839_ _02841_ VGND VGND VPWR VPWR _02896_ sky130_fd_sc_hd__a31o_1
XFILLER_0_89_175 VGND VGND VPWR VPWR sky130_fd_sc_hd__fill_1
XFILLER_0_26_95 VGND VGND VPWR VPWR sky130_fd_sc_hd__decap_4
X_08451_ _02760_ _02831_ VGND VGND VPWR VPWR _02832_ sky130_fd_sc_hd__nor2_1
X_08382_ net213 VGND VGND VPWR VPWR _02763_ sky130_fd_sc_hd__inv_2
XFILLER_0_46_713 VGND VGND VPWR VPWR sky130_fd_sc_hd__fill_1
XFILLER_0_45_245 VGND VGND VPWR VPWR sky130_fd_sc_hd__fill_1
XFILLER_0_9_169 VGND VGND VPWR VPWR sky130_fd_sc_hd__decap_4
Xclkbuf_leaf_124_clk clknet_4_8_0_clk VGND VGND VPWR VPWR clknet_leaf_124_clk sky130_fd_sc_hd__clkbuf_16
XFILLER_0_115_155 VGND VGND VPWR VPWR sky130_fd_sc_hd__fill_2
XFILLER_0_115_133 VGND VGND VPWR VPWR sky130_fd_sc_hd__decap_4
X_09003_ mem_do_rinst VGND VGND VPWR VPWR _03294_ sky130_fd_sc_hd__inv_2
XFILLER_0_13_164 VGND VGND VPWR VPWR sky130_fd_sc_hd__decap_4
X_09905_ _04125_ _04126_ _04131_ _03971_ VGND VGND VPWR VPWR _04132_ sky130_fd_sc_hd__o211a_1
XFILLER_0_67_91 VGND VGND VPWR VPWR sky130_fd_sc_hd__decap_4
XTAP_392 VGND VPWR sky130_fd_sc_hd__tapvpwrvgnd_1
XTAP_381 VGND VPWR sky130_fd_sc_hd__tapvpwrvgnd_1
XTAP_370 VGND VPWR sky130_fd_sc_hd__tapvpwrvgnd_1
X_09836_ _03687_ _04056_ _04064_ VGND VGND VPWR VPWR _04065_ sky130_fd_sc_hd__or3_2
X_09767_ _03650_ VGND VGND VPWR VPWR _03997_ sky130_fd_sc_hd__clkbuf_4
XTAP_2215 VGND VPWR sky130_fd_sc_hd__tapvpwrvgnd_1
XTAP_2226 VGND VPWR sky130_fd_sc_hd__tapvpwrvgnd_1
XTAP_2204 VGND VPWR sky130_fd_sc_hd__tapvpwrvgnd_1
X_08718_ _02122_ _03064_ _03065_ VGND VGND VPWR VPWR _03078_ sky130_fd_sc_hd__o21ai_1
X_09698_ cpuregs\[16\]\[4\] cpuregs\[17\]\[4\] cpuregs\[18\]\[4\] cpuregs\[19\]\[4\]
+ _03751_ _03929_ VGND VGND VPWR VPWR _03930_ sky130_fd_sc_hd__mux4_1
XTAP_2259 VGND VPWR sky130_fd_sc_hd__tapvpwrvgnd_1
XTAP_2248 VGND VPWR sky130_fd_sc_hd__tapvpwrvgnd_1
XTAP_2237 VGND VPWR sky130_fd_sc_hd__tapvpwrvgnd_1
X_08649_ _03014_ _02426_ VGND VGND VPWR VPWR _03015_ sky130_fd_sc_hd__and2b_1
XFILLER_0_95_123 VGND VGND VPWR VPWR sky130_fd_sc_hd__fill_2
XTAP_1514 VGND VPWR sky130_fd_sc_hd__tapvpwrvgnd_1
XTAP_1503 VGND VPWR sky130_fd_sc_hd__tapvpwrvgnd_1
XFILLER_0_68_326 VGND VGND VPWR VPWR sky130_fd_sc_hd__fill_1
XPHY_10 VGND VGND VPWR VPWR sky130_fd_sc_hd__decap_3
XPHY_21 VGND VGND VPWR VPWR sky130_fd_sc_hd__decap_3
XTAP_1536 VGND VPWR sky130_fd_sc_hd__tapvpwrvgnd_1
XTAP_1547 VGND VPWR sky130_fd_sc_hd__tapvpwrvgnd_1
XTAP_1525 VGND VPWR sky130_fd_sc_hd__tapvpwrvgnd_1
XFILLER_0_83_307 VGND VGND VPWR VPWR sky130_fd_sc_hd__fill_1
XPHY_32 VGND VGND VPWR VPWR sky130_fd_sc_hd__decap_3
XPHY_43 VGND VGND VPWR VPWR sky130_fd_sc_hd__decap_3
XPHY_54 VGND VGND VPWR VPWR sky130_fd_sc_hd__decap_3
XPHY_65 VGND VGND VPWR VPWR sky130_fd_sc_hd__decap_3
XTAP_1569 VGND VPWR sky130_fd_sc_hd__tapvpwrvgnd_1
XTAP_1558 VGND VPWR sky130_fd_sc_hd__tapvpwrvgnd_1
XPHY_98 VGND VGND VPWR VPWR sky130_fd_sc_hd__decap_3
X_11660_ _05448_ VGND VGND VPWR VPWR _00516_ sky130_fd_sc_hd__clkbuf_1
XPHY_76 VGND VGND VPWR VPWR sky130_fd_sc_hd__decap_3
XPHY_87 VGND VGND VPWR VPWR sky130_fd_sc_hd__decap_3
X_10611_ cpuregs\[24\]\[28\] cpuregs\[25\]\[28\] cpuregs\[26\]\[28\] cpuregs\[27\]\[28\]
+ _03666_ _03669_ VGND VGND VPWR VPWR _04819_ sky130_fd_sc_hd__mux4_1
XFILLER_0_92_830 VGND VGND VPWR VPWR sky130_fd_sc_hd__fill_2
XFILLER_0_9_670 VGND VGND VPWR VPWR sky130_fd_sc_hd__fill_2
X_11591_ _04981_ net1333 _05411_ VGND VGND VPWR VPWR _05412_ sky130_fd_sc_hd__mux2_1
Xclkbuf_leaf_115_clk clknet_4_10_0_clk VGND VGND VPWR VPWR clknet_leaf_115_clk sky130_fd_sc_hd__clkbuf_16
X_10542_ decoded_imm\[27\] net190 VGND VGND VPWR VPWR _04751_ sky130_fd_sc_hd__or2_1
XFILLER_0_106_122 VGND VGND VPWR VPWR sky130_fd_sc_hd__fill_1
XFILLER_0_91_373 VGND VGND VPWR VPWR sky130_fd_sc_hd__fill_1
X_13330_ cpuregs\[6\]\[16\] cpuregs\[7\]\[16\] _06511_ VGND VGND VPWR VPWR _06813_
+ sky130_fd_sc_hd__mux2_1
XFILLER_0_51_204 VGND VGND VPWR VPWR sky130_fd_sc_hd__decap_4
X_13261_ _06518_ _06745_ VGND VGND VPWR VPWR _06746_ sky130_fd_sc_hd__or2_1
XFILLER_0_121_125 VGND VGND VPWR VPWR sky130_fd_sc_hd__decap_3
X_10473_ _04684_ VGND VGND VPWR VPWR _00093_ sky130_fd_sc_hd__clkbuf_1
X_12212_ _05829_ _05831_ _05834_ VGND VGND VPWR VPWR _05835_ sky130_fd_sc_hd__o21a_1
X_15000_ _03525_ net969 _01876_ VGND VGND VPWR VPWR _01879_ sky130_fd_sc_hd__mux2_1
X_13192_ cpuregs\[16\]\[12\] cpuregs\[17\]\[12\] cpuregs\[18\]\[12\] cpuregs\[19\]\[12\]
+ _06614_ _06648_ VGND VGND VPWR VPWR _06679_ sky130_fd_sc_hd__mux4_1
X_12143_ decoded_imm_j\[1\] _05689_ _05770_ VGND VGND VPWR VPWR _05771_ sky130_fd_sc_hd__a21o_1
X_12074_ _05690_ reg_pc\[14\] VGND VGND VPWR VPWR _05721_ sky130_fd_sc_hd__or2_1
X_16951_ clknet_leaf_115_clk _01515_ VGND VGND VPWR VPWR cpuregs\[10\]\[6\] sky130_fd_sc_hd__dfxtp_1
X_15902_ clknet_leaf_126_clk _00552_ VGND VGND VPWR VPWR cpuregs\[17\]\[4\] sky130_fd_sc_hd__dfxtp_1
X_11025_ _05095_ VGND VGND VPWR VPWR _00234_ sky130_fd_sc_hd__clkbuf_1
X_16882_ clknet_leaf_120_clk _01446_ VGND VGND VPWR VPWR cpuregs\[8\]\[1\] sky130_fd_sc_hd__dfxtp_1
X_15833_ clknet_leaf_55_clk _00483_ VGND VGND VPWR VPWR cpuregs\[16\]\[31\] sky130_fd_sc_hd__dfxtp_1
X_15764_ clknet_leaf_80_clk _00414_ VGND VGND VPWR VPWR cpuregs\[15\]\[26\] sky130_fd_sc_hd__dfxtp_1
XFILLER_0_63_49 VGND VGND VPWR VPWR sky130_fd_sc_hd__decap_3
X_14715_ _01727_ VGND VGND VPWR VPWR _01227_ sky130_fd_sc_hd__clkbuf_1
X_12976_ _02181_ VGND VGND VPWR VPWR _06470_ sky130_fd_sc_hd__clkbuf_4
X_15695_ clknet_leaf_46_clk _00345_ VGND VGND VPWR VPWR cpuregs\[27\]\[21\] sky130_fd_sc_hd__dfxtp_1
XFILLER_0_87_679 VGND VGND VPWR VPWR sky130_fd_sc_hd__fill_1
XFILLER_0_86_156 VGND VGND VPWR VPWR sky130_fd_sc_hd__decap_4
X_11927_ _05614_ _05576_ _05615_ VGND VGND VPWR VPWR _05616_ sky130_fd_sc_hd__and3b_1
X_11858_ net428 _05562_ _05565_ VGND VGND VPWR VPWR _00597_ sky130_fd_sc_hd__a21oi_1
X_14646_ net1558 _05173_ _01684_ VGND VGND VPWR VPWR _01691_ sky130_fd_sc_hd__mux2_1
X_11789_ _05047_ net1400 _05482_ VGND VGND VPWR VPWR _05516_ sky130_fd_sc_hd__mux2_1
X_10809_ net852 _03558_ _04957_ VGND VGND VPWR VPWR _04965_ sky130_fd_sc_hd__mux2_1
Xclkbuf_leaf_106_clk clknet_4_11_0_clk VGND VGND VPWR VPWR clknet_leaf_106_clk sky130_fd_sc_hd__clkbuf_16
XANTENNA_19 _03887_ VGND VGND VPWR VPWR sky130_fd_sc_hd__diode_2
XFILLER_0_7_629 VGND VGND VPWR VPWR sky130_fd_sc_hd__fill_1
X_14577_ _01654_ VGND VGND VPWR VPWR _01162_ sky130_fd_sc_hd__clkbuf_1
XFILLER_0_125_431 VGND VGND VPWR VPWR sky130_fd_sc_hd__fill_1
X_13528_ _06773_ _07004_ VGND VGND VPWR VPWR _07005_ sky130_fd_sc_hd__and2_1
XFILLER_0_55_587 VGND VGND VPWR VPWR sky130_fd_sc_hd__fill_2
X_16316_ clknet_leaf_14_clk _00901_ VGND VGND VPWR VPWR decoded_rd\[4\] sky130_fd_sc_hd__dfxtp_1
XFILLER_0_15_418 VGND VGND VPWR VPWR sky130_fd_sc_hd__decap_6
XFILLER_0_82_395 VGND VGND VPWR VPWR sky130_fd_sc_hd__decap_3
XFILLER_0_12_64 VGND VGND VPWR VPWR sky130_fd_sc_hd__fill_2
XFILLER_0_140_401 VGND VGND VPWR VPWR sky130_fd_sc_hd__decap_4
X_16247_ clknet_leaf_40_clk alu_out\[20\] VGND VGND VPWR VPWR alu_out_q\[20\] sky130_fd_sc_hd__dfxtp_1
X_13459_ _06639_ _06937_ VGND VGND VPWR VPWR _06938_ sky130_fd_sc_hd__and2_1
XFILLER_0_88_46 VGND VGND VPWR VPWR sky130_fd_sc_hd__decap_6
XFILLER_0_51_760 VGND VGND VPWR VPWR sky130_fd_sc_hd__fill_2
Xoutput104 net104 VGND VGND VPWR VPWR mem_la_wdata[16] sky130_fd_sc_hd__clkbuf_4
XFILLER_0_88_79 VGND VGND VPWR VPWR sky130_fd_sc_hd__decap_4
Xoutput115 net115 VGND VGND VPWR VPWR mem_la_wdata[26] sky130_fd_sc_hd__clkbuf_4
X_16178_ clknet_leaf_114_clk _00796_ VGND VGND VPWR VPWR net51 sky130_fd_sc_hd__dfxtp_1
Xoutput148 net148 VGND VGND VPWR VPWR mem_wdata[21] sky130_fd_sc_hd__clkbuf_4
Xoutput159 net159 VGND VGND VPWR VPWR mem_wdata[31] sky130_fd_sc_hd__clkbuf_4
XFILLER_0_100_309 VGND VGND VPWR VPWR sky130_fd_sc_hd__decap_3
Xoutput126 net249 VGND VGND VPWR VPWR mem_la_wdata[7] sky130_fd_sc_hd__clkbuf_4
Xoutput137 net137 VGND VGND VPWR VPWR mem_wdata[11] sky130_fd_sc_hd__clkbuf_4
X_15129_ net958 _03503_ _01937_ VGND VGND VPWR VPWR _01947_ sky130_fd_sc_hd__mux2_1
X_07951_ _02309_ _02352_ _02354_ _02194_ _02199_ VGND VGND VPWR VPWR _02355_ sky130_fd_sc_hd__a221o_1
XFILLER_0_10_189 VGND VGND VPWR VPWR sky130_fd_sc_hd__decap_6
X_07882_ reg_pc\[5\] decoded_imm\[5\] VGND VGND VPWR VPWR _02290_ sky130_fd_sc_hd__nor2_1
XFILLER_0_128_85 VGND VGND VPWR VPWR sky130_fd_sc_hd__fill_1
X_09621_ _02325_ _03652_ _03365_ VGND VGND VPWR VPWR _03854_ sky130_fd_sc_hd__a21o_1
X_09552_ _03786_ VGND VGND VPWR VPWR _00070_ sky130_fd_sc_hd__clkbuf_1
XFILLER_0_77_101 VGND VGND VPWR VPWR sky130_fd_sc_hd__decap_3
X_08503_ _02263_ _02753_ _02839_ _02841_ VGND VGND VPWR VPWR _02881_ sky130_fd_sc_hd__a31o_1
X_09483_ _00013_ VGND VGND VPWR VPWR _03718_ sky130_fd_sc_hd__clkbuf_8
X_08434_ net187 _02814_ _02727_ VGND VGND VPWR VPWR _02815_ sky130_fd_sc_hd__or3_1
XFILLER_0_65_329 VGND VGND VPWR VPWR sky130_fd_sc_hd__fill_1
XFILLER_0_135_217 VGND VGND VPWR VPWR sky130_fd_sc_hd__decap_6
X_08365_ _02739_ _02745_ VGND VGND VPWR VPWR _02746_ sky130_fd_sc_hd__nor2_1
XFILLER_0_73_351 VGND VGND VPWR VPWR sky130_fd_sc_hd__decap_4
XFILLER_0_46_587 VGND VGND VPWR VPWR sky130_fd_sc_hd__fill_1
X_08296_ net202 net248 VGND VGND VPWR VPWR _02677_ sky130_fd_sc_hd__nand2_1
XFILLER_0_33_215 VGND VGND VPWR VPWR sky130_fd_sc_hd__decap_4
XFILLER_0_116_475 VGND VGND VPWR VPWR sky130_fd_sc_hd__fill_1
Xclkbuf_4_2_0_clk clknet_0_clk VGND VGND VPWR VPWR clknet_4_2_0_clk sky130_fd_sc_hd__clkbuf_8
XFILLER_0_5_194 VGND VGND VPWR VPWR sky130_fd_sc_hd__decap_4
XFILLER_0_41_292 VGND VGND VPWR VPWR sky130_fd_sc_hd__decap_6
X_09819_ _03984_ _04044_ _04047_ VGND VGND VPWR VPWR _04048_ sky130_fd_sc_hd__a21o_1
XTAP_2001 VGND VPWR sky130_fd_sc_hd__tapvpwrvgnd_1
X_12830_ cpu_state\[1\] _06330_ _06331_ _02179_ VGND VGND VPWR VPWR _06332_ sky130_fd_sc_hd__o211a_1
XTAP_2034 VGND VPWR sky130_fd_sc_hd__tapvpwrvgnd_1
XTAP_2012 VGND VPWR sky130_fd_sc_hd__tapvpwrvgnd_1
XTAP_2023 VGND VPWR sky130_fd_sc_hd__tapvpwrvgnd_1
X_12761_ _06293_ VGND VGND VPWR VPWR _06294_ sky130_fd_sc_hd__buf_8
XTAP_2067 VGND VPWR sky130_fd_sc_hd__tapvpwrvgnd_1
XTAP_2056 VGND VPWR sky130_fd_sc_hd__tapvpwrvgnd_1
XTAP_2045 VGND VPWR sky130_fd_sc_hd__tapvpwrvgnd_1
XFILLER_0_96_454 VGND VGND VPWR VPWR sky130_fd_sc_hd__fill_1
XTAP_1322 VGND VPWR sky130_fd_sc_hd__tapvpwrvgnd_1
XTAP_1311 VGND VPWR sky130_fd_sc_hd__tapvpwrvgnd_1
XFILLER_0_69_657 VGND VGND VPWR VPWR sky130_fd_sc_hd__fill_1
XTAP_1300 VGND VPWR sky130_fd_sc_hd__tapvpwrvgnd_1
XFILLER_0_68_145 VGND VGND VPWR VPWR sky130_fd_sc_hd__fill_1
XFILLER_0_68_123 VPWR VGND VPWR VGND sky130_ef_sc_hd__decap_12
XTAP_2089 VGND VPWR sky130_fd_sc_hd__tapvpwrvgnd_1
XTAP_2078 VGND VPWR sky130_fd_sc_hd__tapvpwrvgnd_1
X_11712_ _05475_ VGND VGND VPWR VPWR _00541_ sky130_fd_sc_hd__clkbuf_1
X_15480_ clknet_leaf_81_clk _00130_ VGND VGND VPWR VPWR cpuregs\[12\]\[30\] sky130_fd_sc_hd__dfxtp_1
XTAP_1366 VGND VPWR sky130_fd_sc_hd__tapvpwrvgnd_1
XTAP_1344 VGND VPWR sky130_fd_sc_hd__tapvpwrvgnd_1
XTAP_1355 VGND VPWR sky130_fd_sc_hd__tapvpwrvgnd_1
XTAP_1333 VGND VPWR sky130_fd_sc_hd__tapvpwrvgnd_1
XFILLER_0_56_329 VGND VGND VPWR VPWR sky130_fd_sc_hd__fill_1
X_12692_ count_cycle\[55\] count_cycle\[56\] _06230_ VGND VGND VPWR VPWR _06234_ sky130_fd_sc_hd__and3_1
X_14500_ net1450 _05163_ _01612_ VGND VGND VPWR VPWR _01614_ sky130_fd_sc_hd__mux2_1
X_11643_ _05037_ net1409 _05433_ VGND VGND VPWR VPWR _05439_ sky130_fd_sc_hd__mux2_1
XTAP_1399 VGND VPWR sky130_fd_sc_hd__tapvpwrvgnd_1
XTAP_1388 VGND VPWR sky130_fd_sc_hd__tapvpwrvgnd_1
XTAP_1377 VGND VPWR sky130_fd_sc_hd__tapvpwrvgnd_1
X_14431_ _01577_ VGND VGND VPWR VPWR _01061_ sky130_fd_sc_hd__clkbuf_1
Xinput28 mem_rdata[5] VGND VGND VPWR VPWR net28 sky130_fd_sc_hd__clkbuf_4
Xinput17 mem_rdata[24] VGND VGND VPWR VPWR net17 sky130_fd_sc_hd__buf_4
XFILLER_0_119_291 VPWR VGND VPWR VGND sky130_ef_sc_hd__decap_12
X_11574_ _05402_ VGND VGND VPWR VPWR _00476_ sky130_fd_sc_hd__clkbuf_1
X_16101_ clknet_leaf_146_clk _00751_ VGND VGND VPWR VPWR count_cycle\[44\] sky130_fd_sc_hd__dfxtp_1
X_14362_ _04981_ net1353 _07616_ VGND VGND VPWR VPWR _07617_ sky130_fd_sc_hd__mux2_1
XFILLER_0_134_283 VGND VGND VPWR VPWR sky130_fd_sc_hd__fill_2
X_10525_ cpuregs\[4\]\[26\] cpuregs\[5\]\[26\] cpuregs\[6\]\[26\] cpuregs\[7\]\[26\]
+ _03894_ _04090_ VGND VGND VPWR VPWR _04735_ sky130_fd_sc_hd__mux4_1
XFILLER_0_107_497 VGND VGND VPWR VPWR sky130_fd_sc_hd__decap_4
X_13313_ _06792_ _06793_ _06796_ _06563_ VGND VGND VPWR VPWR _06797_ sky130_fd_sc_hd__a211o_1
X_14293_ mem_rdata_q\[29\] _07576_ VGND VGND VPWR VPWR _07577_ sky130_fd_sc_hd__and2_1
XFILLER_0_52_568 VGND VGND VPWR VPWR sky130_fd_sc_hd__decap_4
X_10456_ _03657_ _04661_ _04667_ _03992_ reg_pc\[24\] VGND VGND VPWR VPWR _04668_
+ sky130_fd_sc_hd__a32o_1
X_13244_ cpuregs\[12\]\[14\] cpuregs\[13\]\[14\] cpuregs\[14\]\[14\] cpuregs\[15\]\[14\]
+ _06696_ _06728_ VGND VGND VPWR VPWR _06729_ sky130_fd_sc_hd__mux4_1
X_16032_ clknet_leaf_10_clk _00682_ VGND VGND VPWR VPWR reg_next_pc\[7\] sky130_fd_sc_hd__dfxtp_1
X_13175_ _06662_ net205 _06629_ VGND VGND VPWR VPWR _06663_ sky130_fd_sc_hd__mux2_1
X_12126_ _05737_ reg_pc\[29\] VGND VGND VPWR VPWR _05758_ sky130_fd_sc_hd__or2_1
X_10387_ _03863_ _04594_ _04600_ VGND VGND VPWR VPWR _04601_ sky130_fd_sc_hd__or3_2
X_16934_ clknet_leaf_75_clk _01498_ VGND VGND VPWR VPWR cpuregs\[0\]\[21\] sky130_fd_sc_hd__dfxtp_1
X_12057_ _05696_ net1623 _05697_ _05709_ VGND VGND VPWR VPWR _00652_ sky130_fd_sc_hd__o211a_1
X_16865_ clknet_leaf_54_clk _01429_ VGND VGND VPWR VPWR cpuregs\[22\]\[16\] sky130_fd_sc_hd__dfxtp_1
XFILLER_0_74_48 VGND VGND VPWR VPWR sky130_fd_sc_hd__decap_3
XFILLER_0_74_37 VGND VGND VPWR VPWR sky130_fd_sc_hd__fill_2
XFILLER_0_74_26 VGND VGND VPWR VPWR sky130_fd_sc_hd__fill_2
X_11008_ _05049_ net1483 _05051_ VGND VGND VPWR VPWR _05086_ sky130_fd_sc_hd__mux2_1
X_15816_ clknet_leaf_55_clk _00466_ VGND VGND VPWR VPWR cpuregs\[16\]\[14\] sky130_fd_sc_hd__dfxtp_1
X_16796_ clknet_leaf_102_clk _01360_ VGND VGND VPWR VPWR cpuregs\[6\]\[11\] sky130_fd_sc_hd__dfxtp_1
X_12959_ _03328_ VGND VGND VPWR VPWR _06453_ sky130_fd_sc_hd__clkbuf_4
X_15747_ clknet_leaf_111_clk _00397_ VGND VGND VPWR VPWR cpuregs\[15\]\[9\] sky130_fd_sc_hd__dfxtp_1
XFILLER_0_114_21 VGND VGND VPWR VPWR sky130_fd_sc_hd__fill_1
XFILLER_0_87_465 VGND VGND VPWR VPWR sky130_fd_sc_hd__fill_2
XFILLER_0_59_167 VGND VGND VPWR VPWR sky130_fd_sc_hd__fill_1
X_15678_ clknet_leaf_125_clk _00328_ VGND VGND VPWR VPWR cpuregs\[27\]\[4\] sky130_fd_sc_hd__dfxtp_1
X_14629_ _01681_ VGND VGND VPWR VPWR _01187_ sky130_fd_sc_hd__clkbuf_1
XFILLER_0_74_137 VGND VGND VPWR VPWR sky130_fd_sc_hd__decap_3
X_08150_ _02200_ _02534_ _02537_ _02540_ VGND VGND VPWR VPWR _07632_ sky130_fd_sc_hd__o31a_1
XFILLER_0_83_671 VGND VGND VPWR VPWR sky130_fd_sc_hd__fill_1
XFILLER_0_125_250 VGND VGND VPWR VPWR sky130_fd_sc_hd__decap_4
X_08081_ _02474_ _02475_ VGND VGND VPWR VPWR _02476_ sky130_fd_sc_hd__nand2_1
XFILLER_0_125_294 VGND VGND VPWR VPWR sky130_fd_sc_hd__fill_2
XFILLER_0_70_365 VGND VGND VPWR VPWR sky130_fd_sc_hd__decap_3
XFILLER_0_140_253 VGND VGND VPWR VPWR sky130_fd_sc_hd__fill_2
XFILLER_0_100_139 VGND VGND VPWR VPWR sky130_fd_sc_hd__fill_1
X_08983_ _03280_ VGND VGND VPWR VPWR net82 sky130_fd_sc_hd__buf_4
X_07934_ _02336_ _02337_ _02338_ VGND VGND VPWR VPWR _02339_ sky130_fd_sc_hd__a21o_1
XFILLER_0_47_3 VGND VGND VPWR VPWR sky130_fd_sc_hd__fill_2
X_07865_ _02257_ _02273_ _02255_ VGND VGND VPWR VPWR _02274_ sky130_fd_sc_hd__a21o_1
X_09604_ cpuregs\[28\]\[2\] cpuregs\[29\]\[2\] _03754_ VGND VGND VPWR VPWR _03838_
+ sky130_fd_sc_hd__mux2_1
XFILLER_0_3_62 VGND VGND VPWR VPWR sky130_fd_sc_hd__fill_1
XFILLER_0_64_81 VGND VGND VPWR VPWR sky130_fd_sc_hd__decap_3
X_07796_ _02208_ mem_wordsize\[2\] _02209_ VGND VGND VPWR VPWR _02210_ sky130_fd_sc_hd__a21o_2
X_09535_ _03766_ _03769_ VGND VGND VPWR VPWR _03770_ sky130_fd_sc_hd__or2_1
X_09466_ cpu_state\[4\] _02080_ VGND VGND VPWR VPWR _03702_ sky130_fd_sc_hd__or2_4
XFILLER_0_109_729 VGND VGND VPWR VPWR sky130_fd_sc_hd__decap_4
X_08417_ net172 net247 VGND VGND VPWR VPWR _02798_ sky130_fd_sc_hd__and2b_1
XFILLER_0_65_137 VGND VGND VPWR VPWR sky130_fd_sc_hd__fill_1
X_09397_ net903 _03635_ _03578_ VGND VGND VPWR VPWR _03636_ sky130_fd_sc_hd__mux2_1
XFILLER_0_62_811 VGND VGND VPWR VPWR sky130_fd_sc_hd__fill_1
XFILLER_0_19_543 VGND VGND VPWR VPWR sky130_fd_sc_hd__fill_1
X_08348_ net189 net221 VGND VGND VPWR VPWR _02729_ sky130_fd_sc_hd__or2_1
X_08279_ net198 net250 VGND VGND VPWR VPWR _02660_ sky130_fd_sc_hd__nand2_1
XFILLER_0_61_343 VGND VGND VPWR VPWR sky130_fd_sc_hd__fill_1
XFILLER_0_132_754 VGND VGND VPWR VPWR sky130_fd_sc_hd__fill_2
X_11290_ _05228_ VGND VGND VPWR VPWR _05251_ sky130_fd_sc_hd__buf_4
X_10310_ cpuregs\[2\]\[20\] cpuregs\[3\]\[20\] _03977_ VGND VGND VPWR VPWR _04526_
+ sky130_fd_sc_hd__mux2_1
XFILLER_0_131_253 VGND VGND VPWR VPWR sky130_fd_sc_hd__fill_1
XFILLER_0_131_242 VGND VGND VPWR VPWR sky130_fd_sc_hd__decap_3
X_10241_ cpuregs\[0\]\[18\] cpuregs\[1\]\[18\] _03902_ VGND VGND VPWR VPWR _04459_
+ sky130_fd_sc_hd__mux2_1
XFILLER_0_100_640 VGND VGND VPWR VPWR sky130_fd_sc_hd__fill_1
X_10172_ _03747_ _04385_ _04391_ VGND VGND VPWR VPWR _04392_ sky130_fd_sc_hd__or3_2
X_14980_ _01868_ VGND VGND VPWR VPWR _01351_ sky130_fd_sc_hd__clkbuf_1
X_13931_ _07332_ _07365_ VGND VGND VPWR VPWR _07366_ sky130_fd_sc_hd__and2_1
X_16650_ clknet_leaf_65_clk _01217_ VGND VGND VPWR VPWR cpuregs\[23\]\[28\] sky130_fd_sc_hd__dfxtp_1
X_13862_ net403 _07306_ _07312_ _07317_ VGND VGND VPWR VPWR _00844_ sky130_fd_sc_hd__a22o_1
X_15601_ clknet_leaf_69_clk _00251_ VGND VGND VPWR VPWR cpuregs\[28\]\[23\] sky130_fd_sc_hd__dfxtp_1
X_13793_ cpuregs\[8\]\[31\] cpuregs\[9\]\[31\] _03343_ VGND VGND VPWR VPWR _07261_
+ sky130_fd_sc_hd__mux2_1
X_12813_ _06321_ VGND VGND VPWR VPWR _00796_ sky130_fd_sc_hd__clkbuf_1
X_16581_ clknet_leaf_139_clk _00005_ VGND VGND VPWR VPWR reg_sh\[3\] sky130_fd_sc_hd__dfxtp_1
XFILLER_0_96_273 VGND VGND VPWR VPWR sky130_fd_sc_hd__fill_1
X_15532_ clknet_leaf_82_clk _00182_ VGND VGND VPWR VPWR cpuregs\[13\]\[18\] sky130_fd_sc_hd__dfxtp_1
X_12744_ cpuregs\[30\]\[31\] cpuregs\[31\]\[31\] _03664_ VGND VGND VPWR VPWR _06278_
+ sky130_fd_sc_hd__mux2_1
XTAP_1141 VGND VPWR sky130_fd_sc_hd__tapvpwrvgnd_1
XTAP_1130 VGND VPWR sky130_fd_sc_hd__tapvpwrvgnd_1
XTAP_1163 VGND VPWR sky130_fd_sc_hd__tapvpwrvgnd_1
XTAP_1174 VGND VPWR sky130_fd_sc_hd__tapvpwrvgnd_1
XTAP_1152 VGND VPWR sky130_fd_sc_hd__tapvpwrvgnd_1
XFILLER_0_56_126 VPWR VGND VPWR VGND sky130_ef_sc_hd__decap_12
XFILLER_0_38_830 VGND VGND VPWR VPWR sky130_fd_sc_hd__fill_2
X_15463_ clknet_leaf_104_clk _00113_ VGND VGND VPWR VPWR cpuregs\[12\]\[13\] sky130_fd_sc_hd__dfxtp_1
XTAP_1196 VGND VPWR sky130_fd_sc_hd__tapvpwrvgnd_1
XTAP_1185 VGND VPWR sky130_fd_sc_hd__tapvpwrvgnd_1
X_12675_ count_cycle\[51\] _06219_ VGND VGND VPWR VPWR _06222_ sky130_fd_sc_hd__and2_1
X_14414_ _05037_ net1314 _01562_ VGND VGND VPWR VPWR _01568_ sky130_fd_sc_hd__mux2_1
X_11626_ _05020_ net963 _05422_ VGND VGND VPWR VPWR _05430_ sky130_fd_sc_hd__mux2_1
X_15394_ clknet_leaf_107_clk _00049_ VGND VGND VPWR VPWR cpuregs\[11\]\[12\] sky130_fd_sc_hd__dfxtp_1
X_11557_ _05393_ VGND VGND VPWR VPWR _00468_ sky130_fd_sc_hd__clkbuf_1
X_14345_ decoded_imm\[6\] _07459_ _07605_ VGND VGND VPWR VPWR _01023_ sky130_fd_sc_hd__o21a_1
XFILLER_0_4_418 VGND VGND VPWR VPWR sky130_fd_sc_hd__fill_2
XFILLER_0_25_557 VGND VGND VPWR VPWR sky130_fd_sc_hd__decap_3
X_10508_ _02083_ _04689_ _04718_ VGND VGND VPWR VPWR _04719_ sky130_fd_sc_hd__a21o_1
Xhold609 cpuregs\[1\]\[30\] VGND VGND VPWR VPWR net967 sky130_fd_sc_hd__dlygate4sd3_1
XFILLER_0_80_696 VGND VGND VPWR VPWR sky130_fd_sc_hd__fill_1
XFILLER_0_80_674 VGND VGND VPWR VPWR sky130_fd_sc_hd__fill_2
X_16015_ clknet_leaf_32_clk _00665_ VGND VGND VPWR VPWR reg_pc\[21\] sky130_fd_sc_hd__dfxtp_2
X_11488_ _05356_ VGND VGND VPWR VPWR _00436_ sky130_fd_sc_hd__clkbuf_1
X_14276_ _02508_ _07562_ _07563_ VGND VGND VPWR VPWR _07564_ sky130_fd_sc_hd__o21a_1
X_10439_ _03724_ _04648_ _04650_ VGND VGND VPWR VPWR _04651_ sky130_fd_sc_hd__a21o_1
X_13227_ cpuregs\[16\]\[13\] cpuregs\[17\]\[13\] cpuregs\[18\]\[13\] cpuregs\[19\]\[13\]
+ _06614_ _06648_ VGND VGND VPWR VPWR _06713_ sky130_fd_sc_hd__mux4_1
X_13158_ _06638_ _06641_ _06643_ _06342_ _06645_ VGND VGND VPWR VPWR _06646_ sky130_fd_sc_hd__o311a_1
XTAP_903 VGND VPWR sky130_fd_sc_hd__tapvpwrvgnd_1
XTAP_914 VGND VPWR sky130_fd_sc_hd__tapvpwrvgnd_1
XTAP_925 VGND VPWR sky130_fd_sc_hd__tapvpwrvgnd_1
X_12109_ _05741_ net1520 _05725_ _05746_ VGND VGND VPWR VPWR _00667_ sky130_fd_sc_hd__o211a_1
XTAP_958 VGND VPWR sky130_fd_sc_hd__tapvpwrvgnd_1
XTAP_947 VGND VPWR sky130_fd_sc_hd__tapvpwrvgnd_1
XTAP_936 VGND VPWR sky130_fd_sc_hd__tapvpwrvgnd_1
X_13089_ _06434_ _06578_ VGND VGND VPWR VPWR _06579_ sky130_fd_sc_hd__and2_1
XTAP_969 VGND VPWR sky130_fd_sc_hd__tapvpwrvgnd_1
X_16917_ clknet_leaf_124_clk _01481_ VGND VGND VPWR VPWR cpuregs\[0\]\[4\] sky130_fd_sc_hd__dfxtp_1
XFILLER_0_18_85 VGND VGND VPWR VPWR sky130_fd_sc_hd__decap_4
X_16848_ clknet_leaf_99_clk _01412_ VGND VGND VPWR VPWR cpuregs\[7\]\[31\] sky130_fd_sc_hd__dfxtp_1
X_07650_ cpu_state\[6\] cpu_state\[5\] VGND VGND VPWR VPWR _02080_ sky130_fd_sc_hd__or2_2
X_16779_ clknet_leaf_74_clk _01343_ VGND VGND VPWR VPWR cpuregs\[5\]\[26\] sky130_fd_sc_hd__dfxtp_1
X_09320_ _03467_ _03568_ VGND VGND VPWR VPWR _03569_ sky130_fd_sc_hd__nor2_1
XFILLER_0_87_240 VGND VGND VPWR VPWR sky130_fd_sc_hd__decap_4
XFILLER_0_75_446 VGND VGND VPWR VPWR sky130_fd_sc_hd__fill_2
X_09251_ reg_pc\[10\] _03500_ VGND VGND VPWR VPWR _03509_ sky130_fd_sc_hd__or2_1
X_08202_ _02565_ _02588_ _02573_ VGND VGND VPWR VPWR _02589_ sky130_fd_sc_hd__a21o_1
XFILLER_0_7_223 VGND VGND VPWR VPWR sky130_fd_sc_hd__fill_1
X_09182_ _03433_ VGND VGND VPWR VPWR _03449_ sky130_fd_sc_hd__clkbuf_4
XFILLER_0_8_757 VPWR VGND VPWR VGND sky130_ef_sc_hd__decap_12
X_08133_ _02520_ _02521_ _02524_ _02268_ VGND VGND VPWR VPWR _02525_ sky130_fd_sc_hd__o211ai_1
XFILLER_0_71_630 VGND VGND VPWR VPWR sky130_fd_sc_hd__fill_2
XFILLER_0_7_267 VPWR VGND VPWR VGND sky130_ef_sc_hd__decap_12
XFILLER_0_113_220 VGND VGND VPWR VPWR sky130_fd_sc_hd__decap_4
X_08064_ reg_pc\[17\] decoded_imm\[17\] VGND VGND VPWR VPWR _02460_ sky130_fd_sc_hd__nor2_1
XFILLER_0_31_527 VGND VGND VPWR VPWR sky130_fd_sc_hd__fill_2
XFILLER_0_70_173 VPWR VGND VPWR VGND sky130_ef_sc_hd__decap_12
Xpicorv32_351 VGND VGND VPWR VPWR picorv32_351/HI trace_data[29] sky130_fd_sc_hd__conb_1
XFILLER_0_113_275 VGND VGND VPWR VPWR sky130_fd_sc_hd__decap_4
Xpicorv32_340 VGND VGND VPWR VPWR picorv32_340/HI trace_data[18] sky130_fd_sc_hd__conb_1
XFILLER_0_12_752 VGND VGND VPWR VPWR sky130_fd_sc_hd__decap_4
XFILLER_0_12_785 VPWR VGND VPWR VGND sky130_ef_sc_hd__decap_12
X_08966_ _02522_ _03267_ _03268_ VGND VGND VPWR VPWR _03269_ sky130_fd_sc_hd__mux2_1
X_08897_ net226 _02448_ _03211_ VGND VGND VPWR VPWR net120 sky130_fd_sc_hd__a21o_4
Xclkbuf_leaf_95_clk clknet_4_12_0_clk VGND VGND VPWR VPWR clknet_leaf_95_clk sky130_fd_sc_hd__clkbuf_16
X_07917_ _02321_ _02322_ VGND VGND VPWR VPWR _02323_ sky130_fd_sc_hd__nand2_1
X_07848_ _02254_ _02255_ _02257_ VGND VGND VPWR VPWR _02258_ sky130_fd_sc_hd__o21ai_1
X_09518_ _03696_ _03752_ VGND VGND VPWR VPWR _03753_ sky130_fd_sc_hd__or2_1
X_07779_ cpu_state\[6\] VGND VGND VPWR VPWR _02194_ sky130_fd_sc_hd__clkbuf_4
XPHY_224 VGND VGND VPWR VPWR sky130_fd_sc_hd__decap_3
XPHY_213 VGND VGND VPWR VPWR sky130_fd_sc_hd__decap_3
XPHY_202 VGND VGND VPWR VPWR sky130_fd_sc_hd__decap_3
XFILLER_0_78_295 VGND VGND VPWR VPWR sky130_fd_sc_hd__fill_1
X_10790_ net994 _03498_ _04946_ VGND VGND VPWR VPWR _04955_ sky130_fd_sc_hd__mux2_1
XPHY_268 VGND VGND VPWR VPWR sky130_fd_sc_hd__decap_3
XPHY_257 VGND VGND VPWR VPWR sky130_fd_sc_hd__decap_3
XPHY_246 VGND VGND VPWR VPWR sky130_fd_sc_hd__decap_3
XPHY_235 VGND VGND VPWR VPWR sky130_fd_sc_hd__decap_3
XFILLER_0_94_788 VGND VGND VPWR VPWR sky130_fd_sc_hd__fill_2
X_09449_ _03684_ VGND VGND VPWR VPWR _03685_ sky130_fd_sc_hd__clkbuf_8
XFILLER_0_38_148 VGND VGND VPWR VPWR sky130_fd_sc_hd__fill_1
XPHY_279 VGND VGND VPWR VPWR sky130_fd_sc_hd__decap_3
X_12460_ _05773_ _06050_ _05753_ VGND VGND VPWR VPWR _06063_ sky130_fd_sc_hd__o21ba_1
XFILLER_0_19_373 VGND VGND VPWR VPWR sky130_fd_sc_hd__fill_1
X_12391_ _05739_ _05979_ VGND VGND VPWR VPWR _06000_ sky130_fd_sc_hd__nand2_1
X_11411_ net864 _05186_ _05313_ VGND VGND VPWR VPWR _05316_ sky130_fd_sc_hd__mux2_1
XFILLER_0_46_192 VGND VGND VPWR VPWR sky130_fd_sc_hd__decap_4
X_11342_ _05279_ VGND VGND VPWR VPWR _00367_ sky130_fd_sc_hd__clkbuf_1
X_14130_ _05010_ net1015 _07482_ VGND VGND VPWR VPWR _07485_ sky130_fd_sc_hd__mux2_1
XFILLER_0_34_365 VGND VGND VPWR VPWR sky130_fd_sc_hd__decap_6
XFILLER_0_132_562 VGND VGND VPWR VPWR sky130_fd_sc_hd__decap_3
XFILLER_0_104_253 VGND VGND VPWR VPWR sky130_fd_sc_hd__decap_8
XFILLER_0_104_275 VGND VGND VPWR VPWR sky130_fd_sc_hd__decap_6
X_11273_ _05242_ VGND VGND VPWR VPWR _00335_ sky130_fd_sc_hd__clkbuf_1
X_14061_ mem_rdata_q\[10\] net2 _03292_ VGND VGND VPWR VPWR _07447_ sky130_fd_sc_hd__mux2_1
XFILLER_0_39_29 VGND VGND VPWR VPWR sky130_fd_sc_hd__fill_1
X_10224_ _04404_ VGND VGND VPWR VPWR _04442_ sky130_fd_sc_hd__inv_2
X_13012_ cpuregs\[10\]\[7\] cpuregs\[11\]\[7\] _06424_ VGND VGND VPWR VPWR _06504_
+ sky130_fd_sc_hd__mux2_1
X_10155_ _04370_ _04373_ VGND VGND VPWR VPWR _04375_ sky130_fd_sc_hd__nand2_1
X_14963_ _03622_ net1336 _01851_ VGND VGND VPWR VPWR _01859_ sky130_fd_sc_hd__mux2_1
Xclkbuf_leaf_86_clk clknet_4_14_0_clk VGND VGND VPWR VPWR clknet_leaf_86_clk sky130_fd_sc_hd__clkbuf_16
X_10086_ _03663_ _04303_ _04307_ _03685_ VGND VGND VPWR VPWR _04308_ sky130_fd_sc_hd__o211a_1
X_14894_ _01822_ VGND VGND VPWR VPWR _01311_ sky130_fd_sc_hd__clkbuf_1
X_16702_ clknet_leaf_87_clk _01269_ VGND VGND VPWR VPWR cpuregs\[3\]\[16\] sky130_fd_sc_hd__dfxtp_1
X_13914_ _07312_ _07321_ net238 _07306_ net579 VGND VGND VPWR VPWR _00853_ sky130_fd_sc_hd__a32o_1
X_16633_ clknet_leaf_134_clk _01200_ VGND VGND VPWR VPWR cpuregs\[23\]\[11\] sky130_fd_sc_hd__dfxtp_1
X_13845_ net1514 net12 _02089_ VGND VGND VPWR VPWR _07307_ sky130_fd_sc_hd__mux2_1
XFILLER_0_71_27 VGND VGND VPWR VPWR sky130_fd_sc_hd__fill_2
XFILLER_0_57_402 VGND VGND VPWR VPWR sky130_fd_sc_hd__fill_2
X_10988_ _05029_ net1096 _05074_ VGND VGND VPWR VPWR _05076_ sky130_fd_sc_hd__mux2_1
X_13776_ cpuregs\[16\]\[30\] cpuregs\[17\]\[30\] cpuregs\[18\]\[30\] cpuregs\[19\]\[30\]
+ _06418_ _06979_ VGND VGND VPWR VPWR _07245_ sky130_fd_sc_hd__mux4_1
X_16564_ clknet_leaf_55_clk _01141_ VGND VGND VPWR VPWR cpuregs\[24\]\[16\] sky130_fd_sc_hd__dfxtp_1
XFILLER_0_139_161 VGND VGND VPWR VPWR sky130_fd_sc_hd__decap_6
XFILLER_0_127_301 VGND VGND VPWR VPWR sky130_fd_sc_hd__decap_4
XFILLER_0_84_265 VPWR VGND VPWR VGND sky130_ef_sc_hd__decap_12
X_16495_ clknet_leaf_54_clk _01077_ VGND VGND VPWR VPWR cpuregs\[19\]\[16\] sky130_fd_sc_hd__dfxtp_1
X_12727_ _03766_ _06258_ _06260_ VGND VGND VPWR VPWR _06261_ sky130_fd_sc_hd__a21o_1
X_15515_ clknet_leaf_124_clk _00165_ VGND VGND VPWR VPWR cpuregs\[13\]\[1\] sky130_fd_sc_hd__dfxtp_1
XFILLER_0_29_159 VGND VGND VPWR VPWR sky130_fd_sc_hd__decap_3
XFILLER_0_127_334 VGND VGND VPWR VPWR sky130_fd_sc_hd__fill_2
X_15446_ clknet_leaf_42_clk _00096_ VGND VGND VPWR VPWR net190 sky130_fd_sc_hd__dfxtp_2
X_12658_ _06209_ VGND VGND VPWR VPWR _00753_ sky130_fd_sc_hd__clkbuf_1
XFILLER_0_26_822 VGND VGND VPWR VPWR sky130_fd_sc_hd__fill_2
X_11609_ _05003_ net973 _05411_ VGND VGND VPWR VPWR _05421_ sky130_fd_sc_hd__mux2_1
Xclkbuf_leaf_10_clk clknet_4_1_0_clk VGND VGND VPWR VPWR clknet_leaf_10_clk sky130_fd_sc_hd__clkbuf_16
X_15377_ net33 VGND VGND VPWR VPWR _02076_ sky130_fd_sc_hd__inv_2
XFILLER_0_4_226 VGND VGND VPWR VPWR sky130_fd_sc_hd__fill_1
XFILLER_0_20_20 VGND VGND VPWR VPWR sky130_fd_sc_hd__decap_8
X_12589_ _02141_ _06159_ _06160_ VGND VGND VPWR VPWR _06161_ sky130_fd_sc_hd__and3_1
Xhold417 cpuregs\[30\]\[24\] VGND VGND VPWR VPWR net775 sky130_fd_sc_hd__dlygate4sd3_1
X_14328_ net1641 _07587_ _07590_ _07596_ VGND VGND VPWR VPWR _01015_ sky130_fd_sc_hd__o22a_1
Xhold406 cpuregs\[13\]\[10\] VGND VGND VPWR VPWR net764 sky130_fd_sc_hd__dlygate4sd3_1
XFILLER_0_40_335 VGND VGND VPWR VPWR sky130_fd_sc_hd__decap_4
X_14259_ _06290_ _02113_ VGND VGND VPWR VPWR _07555_ sky130_fd_sc_hd__and2b_1
Xhold428 cpuregs\[25\]\[1\] VGND VGND VPWR VPWR net786 sky130_fd_sc_hd__dlygate4sd3_1
Xhold439 cpuregs\[24\]\[7\] VGND VGND VPWR VPWR net797 sky130_fd_sc_hd__dlygate4sd3_1
XFILLER_0_0_443 VGND VGND VPWR VPWR sky130_fd_sc_hd__fill_1
XTAP_700 VGND VPWR sky130_fd_sc_hd__tapvpwrvgnd_1
X_08820_ _02621_ _03171_ VGND VGND VPWR VPWR _03173_ sky130_fd_sc_hd__or2_1
XTAP_711 VGND VPWR sky130_fd_sc_hd__tapvpwrvgnd_1
XTAP_722 VGND VPWR sky130_fd_sc_hd__tapvpwrvgnd_1
XTAP_733 VGND VPWR sky130_fd_sc_hd__tapvpwrvgnd_1
Xhold1106 cpuregs\[1\]\[15\] VGND VGND VPWR VPWR net1464 sky130_fd_sc_hd__dlygate4sd3_1
XFILLER_0_29_95 VGND VGND VPWR VPWR sky130_fd_sc_hd__fill_1
XTAP_744 VGND VPWR sky130_fd_sc_hd__tapvpwrvgnd_1
XTAP_755 VGND VPWR sky130_fd_sc_hd__tapvpwrvgnd_1
XTAP_766 VGND VPWR sky130_fd_sc_hd__tapvpwrvgnd_1
XTAP_777 VGND VPWR sky130_fd_sc_hd__tapvpwrvgnd_1
X_08751_ _02567_ net219 _02942_ _03031_ VGND VGND VPWR VPWR _03108_ sky130_fd_sc_hd__a31o_1
Xclkbuf_leaf_77_clk clknet_4_15_0_clk VGND VGND VPWR VPWR clknet_leaf_77_clk sky130_fd_sc_hd__clkbuf_16
Xhold1139 cpuregs\[9\]\[26\] VGND VGND VPWR VPWR net1497 sky130_fd_sc_hd__dlygate4sd3_1
Xhold1128 cpuregs\[21\]\[18\] VGND VGND VPWR VPWR net1486 sky130_fd_sc_hd__dlygate4sd3_1
Xhold1117 cpuregs\[9\]\[19\] VGND VGND VPWR VPWR net1475 sky130_fd_sc_hd__dlygate4sd3_1
XTAP_799 VGND VPWR sky130_fd_sc_hd__tapvpwrvgnd_1
XTAP_788 VGND VPWR sky130_fd_sc_hd__tapvpwrvgnd_1
X_08682_ net180 _03043_ VGND VGND VPWR VPWR _03045_ sky130_fd_sc_hd__nor2_1
X_07702_ instr_sra instr_srl instr_xor instr_sll VGND VGND VPWR VPWR _02128_ sky130_fd_sc_hd__or4_1
XFILLER_0_136_85 VPWR VGND VPWR VGND sky130_ef_sc_hd__decap_12
XFILLER_0_88_560 VGND VGND VPWR VPWR sky130_fd_sc_hd__decap_4
X_09303_ reg_pc\[17\] _03549_ VGND VGND VPWR VPWR _03554_ sky130_fd_sc_hd__and2_1
XFILLER_0_75_254 VGND VGND VPWR VPWR sky130_fd_sc_hd__decap_3
XFILLER_0_0_63 VGND VGND VPWR VPWR sky130_fd_sc_hd__fill_2
XFILLER_0_134_805 VGND VGND VPWR VPWR sky130_fd_sc_hd__decap_6
X_09234_ reg_pc\[8\] _03487_ VGND VGND VPWR VPWR _03494_ sky130_fd_sc_hd__and2_1
X_09165_ _03432_ VGND VGND VPWR VPWR _03433_ sky130_fd_sc_hd__buf_2
XFILLER_0_90_257 VGND VGND VPWR VPWR sky130_fd_sc_hd__fill_1
X_08116_ net183 VGND VGND VPWR VPWR _02509_ sky130_fd_sc_hd__buf_4
XFILLER_0_44_674 VGND VGND VPWR VPWR sky130_fd_sc_hd__fill_2
XFILLER_0_16_365 VGND VGND VPWR VPWR sky130_fd_sc_hd__decap_6
X_09096_ _03309_ _03369_ _03371_ _03373_ _03375_ VGND VGND VPWR VPWR _03376_ sky130_fd_sc_hd__a32o_1
XFILLER_0_43_173 VGND VGND VPWR VPWR sky130_fd_sc_hd__fill_1
Xhold940 cpuregs\[16\]\[27\] VGND VGND VPWR VPWR net1298 sky130_fd_sc_hd__dlygate4sd3_1
X_08047_ _02170_ _02442_ _02443_ VGND VGND VPWR VPWR _02444_ sky130_fd_sc_hd__or3_1
XFILLER_0_4_793 VPWR VGND VPWR VGND sky130_ef_sc_hd__decap_12
XFILLER_0_102_757 VGND VGND VPWR VPWR sky130_fd_sc_hd__decap_3
XFILLER_0_101_234 VGND VGND VPWR VPWR sky130_fd_sc_hd__decap_4
Xhold951 cpuregs\[13\]\[16\] VGND VGND VPWR VPWR net1309 sky130_fd_sc_hd__dlygate4sd3_1
Xhold973 cpuregs\[31\]\[11\] VGND VGND VPWR VPWR net1331 sky130_fd_sc_hd__dlygate4sd3_1
Xhold962 cpuregs\[6\]\[7\] VGND VGND VPWR VPWR net1320 sky130_fd_sc_hd__dlygate4sd3_1
Xhold995 cpuregs\[18\]\[0\] VGND VGND VPWR VPWR net1353 sky130_fd_sc_hd__dlygate4sd3_1
Xhold984 cpuregs\[31\]\[9\] VGND VGND VPWR VPWR net1342 sky130_fd_sc_hd__dlygate4sd3_1
X_09998_ _04189_ _04190_ _04222_ VGND VGND VPWR VPWR _04223_ sky130_fd_sc_hd__o21ai_1
XFILLER_0_99_814 VGND VGND VPWR VPWR sky130_fd_sc_hd__fill_2
X_08949_ reg_out\[16\] reg_next_pc\[16\] _03248_ VGND VGND VPWR VPWR _03257_ sky130_fd_sc_hd__mux2_1
Xclkbuf_leaf_68_clk clknet_4_13_0_clk VGND VGND VPWR VPWR clknet_leaf_68_clk sky130_fd_sc_hd__clkbuf_16
XFILLER_0_98_313 VGND VGND VPWR VPWR sky130_fd_sc_hd__fill_1
X_11960_ _02085_ VGND VGND VPWR VPWR _05640_ sky130_fd_sc_hd__clkbuf_4
X_10911_ _05030_ VGND VGND VPWR VPWR _00185_ sky130_fd_sc_hd__clkbuf_1
X_11891_ net427 _05585_ net458 VGND VGND VPWR VPWR _05590_ sky130_fd_sc_hd__a21oi_1
X_13630_ _07013_ _07103_ VGND VGND VPWR VPWR _07104_ sky130_fd_sc_hd__and2_1
X_10842_ _04982_ VGND VGND VPWR VPWR _04983_ sky130_fd_sc_hd__buf_2
X_13561_ _06773_ _07036_ VGND VGND VPWR VPWR _07037_ sky130_fd_sc_hd__and2_1
XFILLER_0_94_541 VGND VGND VPWR VPWR sky130_fd_sc_hd__decap_3
X_10773_ _04945_ VGND VGND VPWR VPWR _04946_ sky130_fd_sc_hd__buf_4
X_15300_ _02035_ VGND VGND VPWR VPWR _01504_ sky130_fd_sc_hd__clkbuf_1
XFILLER_0_136_120 VGND VGND VPWR VPWR sky130_fd_sc_hd__fill_2
XFILLER_0_54_405 VGND VGND VPWR VPWR sky130_fd_sc_hd__decap_6
X_12512_ count_cycle\[4\] _06104_ _05640_ VGND VGND VPWR VPWR _06106_ sky130_fd_sc_hd__a21oi_1
X_16280_ clknet_leaf_140_clk _00865_ VGND VGND VPWR VPWR instr_ori sky130_fd_sc_hd__dfxtp_1
XFILLER_0_136_153 VPWR VGND VPWR VGND sky130_ef_sc_hd__decap_12
X_15231_ _03610_ net1402 _01995_ VGND VGND VPWR VPWR _02001_ sky130_fd_sc_hd__mux2_1
X_13492_ _03345_ VGND VGND VPWR VPWR _06970_ sky130_fd_sc_hd__clkbuf_4
XFILLER_0_35_630 VGND VGND VPWR VPWR sky130_fd_sc_hd__fill_2
X_12443_ _06004_ _05751_ VGND VGND VPWR VPWR _06047_ sky130_fd_sc_hd__xor2_2
XFILLER_0_22_302 VGND VGND VPWR VPWR sky130_fd_sc_hd__decap_6
XFILLER_0_140_819 VGND VGND VPWR VPWR sky130_fd_sc_hd__fill_2
XFILLER_0_140_808 VGND VGND VPWR VPWR sky130_fd_sc_hd__fill_1
X_15162_ _01964_ VGND VGND VPWR VPWR _01437_ sky130_fd_sc_hd__clkbuf_1
X_12374_ _05969_ _05973_ _05982_ VGND VGND VPWR VPWR _05984_ sky130_fd_sc_hd__o21ai_1
XFILLER_0_50_622 VGND VGND VPWR VPWR sky130_fd_sc_hd__fill_1
X_15093_ net1507 _05211_ _01923_ VGND VGND VPWR VPWR _01928_ sky130_fd_sc_hd__mux2_1
X_14113_ _04993_ net1601 _07471_ VGND VGND VPWR VPWR _07476_ sky130_fd_sc_hd__mux2_1
X_11325_ _05270_ VGND VGND VPWR VPWR _00359_ sky130_fd_sc_hd__clkbuf_1
XFILLER_0_120_543 VGND VGND VPWR VPWR sky130_fd_sc_hd__decap_3
X_14044_ _07438_ VGND VGND VPWR VPWR _00895_ sky130_fd_sc_hd__clkbuf_1
X_11256_ _05233_ VGND VGND VPWR VPWR _00327_ sky130_fd_sc_hd__clkbuf_1
X_10207_ _03984_ _04423_ _04425_ VGND VGND VPWR VPWR _04426_ sky130_fd_sc_hd__a21o_1
X_11187_ _05187_ VGND VGND VPWR VPWR _00304_ sky130_fd_sc_hd__clkbuf_1
X_10138_ _02083_ _04328_ _04329_ _04358_ VGND VGND VPWR VPWR _04359_ sky130_fd_sc_hd__a31o_1
X_15995_ clknet_leaf_8_clk _00645_ VGND VGND VPWR VPWR reg_pc\[1\] sky130_fd_sc_hd__dfxtp_2
Xclkbuf_leaf_59_clk clknet_4_12_0_clk VGND VGND VPWR VPWR clknet_leaf_59_clk sky130_fd_sc_hd__clkbuf_16
XFILLER_0_89_302 VGND VGND VPWR VPWR sky130_fd_sc_hd__fill_1
X_10069_ _02083_ _04261_ _04262_ _04291_ VGND VGND VPWR VPWR _04292_ sky130_fd_sc_hd__a31o_1
X_14946_ _03571_ net798 _01840_ VGND VGND VPWR VPWR _01850_ sky130_fd_sc_hd__mux2_1
X_14877_ _01813_ VGND VGND VPWR VPWR _01303_ sky130_fd_sc_hd__clkbuf_1
X_16616_ clknet_leaf_81_clk _01183_ VGND VGND VPWR VPWR cpuregs\[9\]\[26\] sky130_fd_sc_hd__dfxtp_1
X_13828_ _02169_ is_beq_bne_blt_bge_bltu_bgeu VGND VGND VPWR VPWR _07294_ sky130_fd_sc_hd__nor2_1
X_13759_ _06415_ _07215_ _07228_ _02181_ decoded_imm\[29\] VGND VGND VPWR VPWR _07229_
+ sky130_fd_sc_hd__a32o_1
X_16547_ clknet_leaf_26_clk _01124_ VGND VGND VPWR VPWR mem_rdata_q\[31\] sky130_fd_sc_hd__dfxtp_2
XFILLER_0_128_698 VGND VGND VPWR VPWR sky130_fd_sc_hd__fill_2
XFILLER_0_122_54 VGND VGND VPWR VPWR sky130_fd_sc_hd__decap_8
X_16478_ clknet_leaf_55_clk _01060_ VGND VGND VPWR VPWR cpuregs\[18\]\[31\] sky130_fd_sc_hd__dfxtp_1
X_15429_ clknet_leaf_19_clk _00079_ VGND VGND VPWR VPWR net172 sky130_fd_sc_hd__dfxtp_2
XFILLER_0_14_825 VGND VGND VPWR VPWR sky130_fd_sc_hd__fill_1
XFILLER_0_25_151 VGND VGND VPWR VPWR sky130_fd_sc_hd__decap_6
XFILLER_0_130_307 VGND VGND VPWR VPWR sky130_fd_sc_hd__fill_1
XFILLER_0_13_335 VGND VGND VPWR VPWR sky130_fd_sc_hd__fill_1
Xhold225 cpuregs\[12\]\[27\] VGND VGND VPWR VPWR net583 sky130_fd_sc_hd__dlygate4sd3_1
Xhold203 cpuregs\[22\]\[20\] VGND VGND VPWR VPWR net561 sky130_fd_sc_hd__dlygate4sd3_1
Xhold214 cpuregs\[19\]\[12\] VGND VGND VPWR VPWR net572 sky130_fd_sc_hd__dlygate4sd3_1
Xhold236 net154 VGND VGND VPWR VPWR net594 sky130_fd_sc_hd__dlygate4sd3_1
XFILLER_0_111_543 VGND VGND VPWR VPWR sky130_fd_sc_hd__decap_4
Xhold269 cpuregs\[14\]\[22\] VGND VGND VPWR VPWR net627 sky130_fd_sc_hd__dlygate4sd3_1
X_09921_ _03780_ _04115_ _04147_ _03793_ VGND VGND VPWR VPWR _04148_ sky130_fd_sc_hd__a22o_1
Xhold258 cpuregs\[28\]\[14\] VGND VGND VPWR VPWR net616 sky130_fd_sc_hd__dlygate4sd3_1
Xhold247 cpuregs\[26\]\[4\] VGND VGND VPWR VPWR net605 sky130_fd_sc_hd__dlygate4sd3_1
XFILLER_0_40_165 VGND VGND VPWR VPWR sky130_fd_sc_hd__decap_3
XFILLER_0_41_688 VGND VGND VPWR VPWR sky130_fd_sc_hd__fill_1
XFILLER_0_111_587 VGND VGND VPWR VPWR sky130_fd_sc_hd__fill_1
XFILLER_0_1_785 VPWR VGND VPWR VGND sky130_ef_sc_hd__decap_12
X_09852_ _04078_ _04079_ VGND VGND VPWR VPWR _04080_ sky130_fd_sc_hd__nand2_1
XTAP_530 VGND VPWR sky130_fd_sc_hd__tapvpwrvgnd_1
XTAP_541 VGND VPWR sky130_fd_sc_hd__tapvpwrvgnd_1
XTAP_552 VGND VPWR sky130_fd_sc_hd__tapvpwrvgnd_1
X_08803_ net221 net220 net219 _03127_ VGND VGND VPWR VPWR _03157_ sky130_fd_sc_hd__or4b_1
XTAP_563 VGND VPWR sky130_fd_sc_hd__tapvpwrvgnd_1
XTAP_574 VGND VPWR sky130_fd_sc_hd__tapvpwrvgnd_1
X_09783_ cpuregs\[12\]\[6\] cpuregs\[13\]\[6\] _03976_ VGND VGND VPWR VPWR _04013_
+ sky130_fd_sc_hd__mux2_1
XTAP_585 VGND VPWR sky130_fd_sc_hd__tapvpwrvgnd_1
X_08734_ _03092_ _03079_ _03082_ VGND VGND VPWR VPWR _03093_ sky130_fd_sc_hd__o21a_1
XFILLER_0_56_71 VGND VGND VPWR VPWR sky130_fd_sc_hd__fill_1
XTAP_596 VGND VPWR sky130_fd_sc_hd__tapvpwrvgnd_1
X_08665_ _02718_ _02895_ _03029_ VGND VGND VPWR VPWR _03030_ sky130_fd_sc_hd__a21o_1
XFILLER_0_49_700 VGND VGND VPWR VPWR sky130_fd_sc_hd__fill_1
XANTENNA_109 net215 VGND VGND VPWR VPWR sky130_fd_sc_hd__diode_2
XTAP_1729 VGND VPWR sky130_fd_sc_hd__tapvpwrvgnd_1
XTAP_1718 VGND VPWR sky130_fd_sc_hd__tapvpwrvgnd_1
XTAP_1707 VGND VPWR sky130_fd_sc_hd__tapvpwrvgnd_1
X_08596_ _02963_ _02965_ VGND VGND VPWR VPWR _02966_ sky130_fd_sc_hd__nor2_1
XFILLER_0_36_438 VGND VGND VPWR VPWR sky130_fd_sc_hd__fill_1
XFILLER_0_118_197 VGND VGND VPWR VPWR sky130_fd_sc_hd__decap_4
X_09217_ _03479_ VGND VGND VPWR VPWR _00042_ sky130_fd_sc_hd__clkbuf_1
X_09148_ _03423_ VGND VGND VPWR VPWR _01114_ sky130_fd_sc_hd__buf_1
XFILLER_0_32_622 VGND VGND VPWR VPWR sky130_fd_sc_hd__fill_1
XFILLER_0_121_318 VGND VGND VPWR VPWR sky130_fd_sc_hd__fill_1
XFILLER_0_31_132 VGND VGND VPWR VPWR sky130_fd_sc_hd__fill_1
X_09079_ decoded_imm_j\[11\] decoded_imm_j\[4\] _03359_ VGND VGND VPWR VPWR _03360_
+ sky130_fd_sc_hd__or3_4
X_11110_ _05140_ VGND VGND VPWR VPWR _00274_ sky130_fd_sc_hd__clkbuf_1
XFILLER_0_32_699 VGND VGND VPWR VPWR sky130_fd_sc_hd__fill_1
X_12090_ _05688_ _05731_ _05732_ _05730_ VGND VGND VPWR VPWR _00662_ sky130_fd_sc_hd__o211a_1
Xhold781 cpuregs\[6\]\[3\] VGND VGND VPWR VPWR net1139 sky130_fd_sc_hd__dlygate4sd3_1
Xhold770 cpuregs\[11\]\[5\] VGND VGND VPWR VPWR net1128 sky130_fd_sc_hd__dlygate4sd3_1
X_11041_ net616 _03538_ _05099_ VGND VGND VPWR VPWR _05104_ sky130_fd_sc_hd__mux2_1
Xhold792 cpuregs\[29\]\[12\] VGND VGND VPWR VPWR net1150 sky130_fd_sc_hd__dlygate4sd3_1
X_14800_ _01772_ VGND VGND VPWR VPWR _01267_ sky130_fd_sc_hd__clkbuf_1
X_15780_ clknet_leaf_137_clk _00430_ VGND VGND VPWR VPWR cpuregs\[26\]\[10\] sky130_fd_sc_hd__dfxtp_1
X_12992_ _06430_ _06480_ _06482_ _06342_ _06484_ VGND VGND VPWR VPWR _06485_ sky130_fd_sc_hd__o311a_1
X_14731_ _05014_ net1642 _01731_ VGND VGND VPWR VPWR _01736_ sky130_fd_sc_hd__mux2_1
X_11943_ _05627_ VGND VGND VPWR VPWR _00620_ sky130_fd_sc_hd__clkbuf_1
XFILLER_0_86_327 VGND VGND VPWR VPWR sky130_fd_sc_hd__fill_1
X_14662_ _01699_ VGND VGND VPWR VPWR _01202_ sky130_fd_sc_hd__clkbuf_1
XFILLER_0_52_29 VGND VGND VPWR VPWR sky130_fd_sc_hd__decap_3
X_11874_ _05575_ _05576_ _05577_ VGND VGND VPWR VPWR _05578_ sky130_fd_sc_hd__and3b_1
X_13613_ cpuregs\[8\]\[25\] cpuregs\[9\]\[25\] _03343_ VGND VGND VPWR VPWR _07087_
+ sky130_fd_sc_hd__mux2_1
X_16401_ clknet_leaf_34_clk _00983_ VGND VGND VPWR VPWR net155 sky130_fd_sc_hd__dfxtp_1
X_10825_ _04973_ VGND VGND VPWR VPWR _00156_ sky130_fd_sc_hd__clkbuf_1
XFILLER_0_39_221 VGND VGND VPWR VPWR sky130_fd_sc_hd__decap_3
XFILLER_0_109_120 VGND VGND VPWR VPWR sky130_fd_sc_hd__fill_1
X_14593_ _05012_ net1571 _01659_ VGND VGND VPWR VPWR _01663_ sky130_fd_sc_hd__mux2_1
X_16332_ clknet_leaf_140_clk _00002_ VGND VGND VPWR VPWR is_slti_blt_slt sky130_fd_sc_hd__dfxtp_1
X_10756_ _04935_ VGND VGND VPWR VPWR _00125_ sky130_fd_sc_hd__clkbuf_1
X_13544_ _06794_ _07020_ VGND VGND VPWR VPWR _07021_ sky130_fd_sc_hd__and2_1
XFILLER_0_82_533 VGND VGND VPWR VPWR sky130_fd_sc_hd__fill_1
XFILLER_0_54_246 VGND VGND VPWR VPWR sky130_fd_sc_hd__decap_6
X_13475_ cpuregs\[30\]\[20\] cpuregs\[31\]\[20\] _06754_ VGND VGND VPWR VPWR _06954_
+ sky130_fd_sc_hd__mux2_1
X_10687_ cpuregs\[20\]\[30\] cpuregs\[21\]\[30\] cpuregs\[22\]\[30\] cpuregs\[23\]\[30\]
+ _04100_ _03936_ VGND VGND VPWR VPWR _04893_ sky130_fd_sc_hd__mux4_1
X_16263_ clknet_leaf_140_clk _00848_ VGND VGND VPWR VPWR instr_bne sky130_fd_sc_hd__dfxtp_1
XFILLER_0_35_460 VGND VGND VPWR VPWR sky130_fd_sc_hd__fill_1
XFILLER_0_42_419 VGND VGND VPWR VPWR sky130_fd_sc_hd__fill_1
X_12426_ _05773_ _06031_ VGND VGND VPWR VPWR _06032_ sky130_fd_sc_hd__nor2_1
X_15214_ _03558_ net921 _01984_ VGND VGND VPWR VPWR _01992_ sky130_fd_sc_hd__mux2_1
X_16194_ clknet_leaf_141_clk _00811_ VGND VGND VPWR VPWR net124 sky130_fd_sc_hd__dfxtp_4
X_15145_ _01955_ VGND VGND VPWR VPWR _01429_ sky130_fd_sc_hd__clkbuf_1
X_12357_ _05735_ _05967_ _05968_ _05768_ VGND VGND VPWR VPWR _00693_ sky130_fd_sc_hd__o211a_1
XFILLER_0_23_688 VGND VGND VPWR VPWR sky130_fd_sc_hd__fill_2
X_11308_ _05260_ VGND VGND VPWR VPWR _00352_ sky130_fd_sc_hd__clkbuf_1
XFILLER_0_120_351 VGND VGND VPWR VPWR sky130_fd_sc_hd__fill_1
X_12288_ _05901_ VGND VGND VPWR VPWR _05905_ sky130_fd_sc_hd__inv_2
X_15076_ net1181 _05194_ _01912_ VGND VGND VPWR VPWR _01919_ sky130_fd_sc_hd__mux2_1
X_11239_ _05222_ VGND VGND VPWR VPWR _00321_ sky130_fd_sc_hd__clkbuf_1
X_14027_ net1092 _01121_ _03430_ VGND VGND VPWR VPWR _07430_ sky130_fd_sc_hd__mux2_1
XFILLER_0_117_21 VGND VGND VPWR VPWR sky130_fd_sc_hd__fill_2
XFILLER_0_93_36 VPWR VGND VPWR VGND sky130_ef_sc_hd__decap_12
X_15978_ clknet_leaf_147_clk _00628_ VGND VGND VPWR VPWR count_instr\[47\] sky130_fd_sc_hd__dfxtp_1
XFILLER_0_89_154 VGND VGND VPWR VPWR sky130_fd_sc_hd__fill_2
X_14929_ _01841_ VGND VGND VPWR VPWR _01327_ sky130_fd_sc_hd__clkbuf_1
XFILLER_0_26_85 VGND VGND VPWR VPWR sky130_fd_sc_hd__decap_3
X_08450_ _02829_ _02830_ instr_bne VGND VGND VPWR VPWR _02831_ sky130_fd_sc_hd__o21ba_1
X_08381_ net218 VGND VGND VPWR VPWR _02762_ sky130_fd_sc_hd__inv_2
XFILLER_0_73_500 VGND VGND VPWR VPWR sky130_fd_sc_hd__decap_4
XFILLER_0_18_405 VGND VGND VPWR VPWR sky130_fd_sc_hd__fill_2
XFILLER_0_116_613 VGND VGND VPWR VPWR sky130_fd_sc_hd__fill_1
XFILLER_0_45_213 VGND VGND VPWR VPWR sky130_fd_sc_hd__fill_2
XFILLER_0_5_321 VGND VGND VPWR VPWR sky130_fd_sc_hd__decap_4
X_09002_ _03293_ VGND VGND VPWR VPWR _01108_ sky130_fd_sc_hd__buf_1
XFILLER_0_112_830 VGND VGND VPWR VPWR sky130_fd_sc_hd__fill_2
XFILLER_0_14_699 VGND VGND VPWR VPWR sky130_fd_sc_hd__fill_1
X_09904_ _04127_ _04128_ _04130_ VGND VGND VPWR VPWR _04131_ sky130_fd_sc_hd__a21o_1
XTAP_360 VGND VPWR sky130_fd_sc_hd__tapvpwrvgnd_1
X_09835_ _04020_ _04057_ _04062_ _04063_ VGND VGND VPWR VPWR _04064_ sky130_fd_sc_hd__o211a_1
XTAP_393 VGND VPWR sky130_fd_sc_hd__tapvpwrvgnd_1
XTAP_382 VGND VPWR sky130_fd_sc_hd__tapvpwrvgnd_1
XTAP_371 VGND VPWR sky130_fd_sc_hd__tapvpwrvgnd_1
X_09766_ _03996_ VGND VGND VPWR VPWR _00074_ sky130_fd_sc_hd__clkbuf_1
XTAP_2216 VGND VPWR sky130_fd_sc_hd__tapvpwrvgnd_1
XTAP_2205 VGND VPWR sky130_fd_sc_hd__tapvpwrvgnd_1
X_08717_ _02707_ _02986_ _03076_ VGND VGND VPWR VPWR _03077_ sky130_fd_sc_hd__a21o_1
X_09697_ _03718_ VGND VGND VPWR VPWR _03929_ sky130_fd_sc_hd__clkbuf_8
XTAP_2249 VGND VPWR sky130_fd_sc_hd__tapvpwrvgnd_1
XTAP_2238 VGND VPWR sky130_fd_sc_hd__tapvpwrvgnd_1
XTAP_2227 VGND VPWR sky130_fd_sc_hd__tapvpwrvgnd_1
X_08648_ _02779_ _03013_ VGND VGND VPWR VPWR _03014_ sky130_fd_sc_hd__xnor2_1
XTAP_1515 VGND VPWR sky130_fd_sc_hd__tapvpwrvgnd_1
XTAP_1504 VGND VPWR sky130_fd_sc_hd__tapvpwrvgnd_1
XPHY_11 VGND VGND VPWR VPWR sky130_fd_sc_hd__decap_3
XPHY_22 VGND VGND VPWR VPWR sky130_fd_sc_hd__decap_3
XFILLER_0_139_727 VGND VGND VPWR VPWR sky130_fd_sc_hd__fill_1
XTAP_1537 VGND VPWR sky130_fd_sc_hd__tapvpwrvgnd_1
XTAP_1548 VGND VPWR sky130_fd_sc_hd__tapvpwrvgnd_1
XTAP_1526 VGND VPWR sky130_fd_sc_hd__tapvpwrvgnd_1
XPHY_33 VGND VGND VPWR VPWR sky130_fd_sc_hd__decap_3
XPHY_44 VGND VGND VPWR VPWR sky130_fd_sc_hd__decap_3
XPHY_55 VGND VGND VPWR VPWR sky130_fd_sc_hd__decap_3
X_08579_ _02949_ _02950_ VGND VGND VPWR VPWR _02951_ sky130_fd_sc_hd__xnor2_1
XTAP_1559 VGND VPWR sky130_fd_sc_hd__tapvpwrvgnd_1
XFILLER_0_76_360 VGND VGND VPWR VPWR sky130_fd_sc_hd__fill_1
XPHY_66 VGND VGND VPWR VPWR sky130_fd_sc_hd__decap_3
XPHY_77 VGND VGND VPWR VPWR sky130_fd_sc_hd__decap_3
XPHY_88 VGND VGND VPWR VPWR sky130_fd_sc_hd__decap_3
X_10610_ _03662_ _04813_ _04817_ _03971_ VGND VGND VPWR VPWR _04818_ sky130_fd_sc_hd__o211a_1
XFILLER_0_91_330 VGND VGND VPWR VPWR sky130_fd_sc_hd__decap_6
XPHY_99 VGND VGND VPWR VPWR sky130_fd_sc_hd__decap_3
X_11590_ _05410_ VGND VGND VPWR VPWR _05411_ sky130_fd_sc_hd__buf_4
XFILLER_0_134_421 VGND VGND VPWR VPWR sky130_fd_sc_hd__decap_6
X_10541_ _04750_ VGND VGND VPWR VPWR _00095_ sky130_fd_sc_hd__clkbuf_1
XFILLER_0_106_101 VGND VGND VPWR VPWR sky130_fd_sc_hd__fill_1
XFILLER_0_9_682 VGND VGND VPWR VPWR sky130_fd_sc_hd__fill_2
XFILLER_0_36_246 VGND VGND VPWR VPWR sky130_fd_sc_hd__decap_6
XFILLER_0_122_605 VGND VGND VPWR VPWR sky130_fd_sc_hd__fill_2
X_13260_ cpuregs\[16\]\[14\] cpuregs\[17\]\[14\] cpuregs\[18\]\[14\] cpuregs\[19\]\[14\]
+ _06614_ _06648_ VGND VGND VPWR VPWR _06745_ sky130_fd_sc_hd__mux4_1
X_10472_ _04683_ _02567_ _04509_ VGND VGND VPWR VPWR _04684_ sky130_fd_sc_hd__mux2_1
X_12211_ _05832_ _05833_ VGND VGND VPWR VPWR _05834_ sky130_fd_sc_hd__nor2_1
XFILLER_0_32_430 VGND VGND VPWR VPWR sky130_fd_sc_hd__decap_6
X_13191_ _06631_ _06670_ _06677_ VGND VGND VPWR VPWR _06678_ sky130_fd_sc_hd__or3_2
X_12142_ decoded_imm_j\[2\] _05693_ VGND VGND VPWR VPWR _05770_ sky130_fd_sc_hd__xor2_1
X_12073_ _03536_ reg_next_pc\[14\] _03222_ VGND VGND VPWR VPWR _05720_ sky130_fd_sc_hd__mux2_2
X_16950_ clknet_leaf_122_clk _01514_ VGND VGND VPWR VPWR cpuregs\[10\]\[5\] sky130_fd_sc_hd__dfxtp_1
X_11024_ net712 _03484_ _05088_ VGND VGND VPWR VPWR _05095_ sky130_fd_sc_hd__mux2_1
X_15901_ clknet_leaf_128_clk _00551_ VGND VGND VPWR VPWR cpuregs\[17\]\[3\] sky130_fd_sc_hd__dfxtp_1
X_16881_ clknet_leaf_118_clk _01445_ VGND VGND VPWR VPWR cpuregs\[8\]\[0\] sky130_fd_sc_hd__dfxtp_1
X_15832_ clknet_leaf_53_clk _00482_ VGND VGND VPWR VPWR cpuregs\[16\]\[30\] sky130_fd_sc_hd__dfxtp_1
X_15763_ clknet_leaf_70_clk _00413_ VGND VGND VPWR VPWR cpuregs\[15\]\[25\] sky130_fd_sc_hd__dfxtp_1
X_12975_ _06441_ _06446_ _06454_ _06467_ _06468_ VGND VGND VPWR VPWR _06469_ sky130_fd_sc_hd__a311o_1
XFILLER_0_87_625 VGND VGND VPWR VPWR sky130_fd_sc_hd__decap_8
XFILLER_0_59_327 VGND VGND VPWR VPWR sky130_fd_sc_hd__fill_1
XFILLER_0_59_316 VGND VGND VPWR VPWR sky130_fd_sc_hd__fill_1
X_14714_ _04997_ net1527 _01720_ VGND VGND VPWR VPWR _01727_ sky130_fd_sc_hd__mux2_1
X_11926_ count_instr\[35\] _05612_ VGND VGND VPWR VPWR _05615_ sky130_fd_sc_hd__or2_1
X_15694_ clknet_leaf_49_clk _00344_ VGND VGND VPWR VPWR cpuregs\[27\]\[20\] sky130_fd_sc_hd__dfxtp_1
XFILLER_0_129_237 VGND VGND VPWR VPWR sky130_fd_sc_hd__decap_6
X_11857_ net428 _05562_ _05533_ VGND VGND VPWR VPWR _05565_ sky130_fd_sc_hd__o21ai_1
X_14645_ _01690_ VGND VGND VPWR VPWR _01194_ sky130_fd_sc_hd__clkbuf_1
X_11788_ _05515_ VGND VGND VPWR VPWR _00577_ sky130_fd_sc_hd__clkbuf_1
XFILLER_0_95_691 VGND VGND VPWR VPWR sky130_fd_sc_hd__fill_1
XFILLER_0_83_831 VGND VGND VPWR VPWR sky130_fd_sc_hd__fill_1
X_10808_ _04964_ VGND VGND VPWR VPWR _00148_ sky130_fd_sc_hd__clkbuf_1
XFILLER_0_12_21 VGND VGND VPWR VPWR sky130_fd_sc_hd__decap_6
X_14576_ _04995_ net1594 _01648_ VGND VGND VPWR VPWR _01654_ sky130_fd_sc_hd__mux2_1
X_13527_ cpuregs\[6\]\[22\] cpuregs\[7\]\[22\] _06842_ VGND VGND VPWR VPWR _07004_
+ sky130_fd_sc_hd__mux2_1
X_10739_ _04926_ VGND VGND VPWR VPWR _00117_ sky130_fd_sc_hd__clkbuf_1
X_16315_ clknet_leaf_139_clk _00900_ VGND VGND VPWR VPWR decoded_rd\[3\] sky130_fd_sc_hd__dfxtp_1
XFILLER_0_27_246 VPWR VGND VPWR VGND sky130_ef_sc_hd__decap_12
X_16246_ clknet_leaf_40_clk alu_out\[19\] VGND VGND VPWR VPWR alu_out_q\[19\] sky130_fd_sc_hd__dfxtp_1
XFILLER_0_140_413 VGND VGND VPWR VPWR sky130_fd_sc_hd__fill_1
XFILLER_0_125_487 VGND VGND VPWR VPWR sky130_fd_sc_hd__fill_1
X_13458_ cpuregs\[4\]\[20\] cpuregs\[5\]\[20\] _06906_ VGND VGND VPWR VPWR _06937_
+ sky130_fd_sc_hd__mux2_1
XFILLER_0_88_36 VGND VGND VPWR VPWR sky130_fd_sc_hd__fill_1
XFILLER_0_42_249 VGND VGND VPWR VPWR sky130_fd_sc_hd__decap_3
Xoutput105 net105 VGND VGND VPWR VPWR mem_la_wdata[17] sky130_fd_sc_hd__clkbuf_4
Xoutput116 net116 VGND VGND VPWR VPWR mem_la_wdata[27] sky130_fd_sc_hd__clkbuf_4
X_12409_ reg_next_pc\[22\] _03224_ _05742_ VGND VGND VPWR VPWR _06016_ sky130_fd_sc_hd__a21o_1
XFILLER_0_112_126 VPWR VGND VPWR VGND sky130_ef_sc_hd__decap_12
XFILLER_0_106_690 VGND VGND VPWR VPWR sky130_fd_sc_hd__decap_4
X_13389_ cpuregs\[10\]\[18\] cpuregs\[11\]\[18\] _06766_ VGND VGND VPWR VPWR _06870_
+ sky130_fd_sc_hd__mux2_1
X_16177_ clknet_leaf_109_clk _00795_ VGND VGND VPWR VPWR net50 sky130_fd_sc_hd__dfxtp_1
XFILLER_0_2_346 VGND VGND VPWR VPWR sky130_fd_sc_hd__fill_2
XFILLER_0_11_614 VGND VGND VPWR VPWR sky130_fd_sc_hd__fill_2
Xoutput138 net138 VGND VGND VPWR VPWR mem_wdata[12] sky130_fd_sc_hd__clkbuf_4
Xoutput127 net127 VGND VGND VPWR VPWR mem_la_wdata[8] sky130_fd_sc_hd__clkbuf_4
XFILLER_0_121_671 VGND VGND VPWR VPWR sky130_fd_sc_hd__fill_1
Xoutput149 net149 VGND VGND VPWR VPWR mem_wdata[22] sky130_fd_sc_hd__buf_2
XFILLER_0_11_647 VGND VGND VPWR VPWR sky130_fd_sc_hd__fill_2
X_15128_ _01946_ VGND VGND VPWR VPWR _01421_ sky130_fd_sc_hd__clkbuf_1
X_07950_ _02336_ _02353_ _02338_ VGND VGND VPWR VPWR _02354_ sky130_fd_sc_hd__a21o_1
XFILLER_0_10_168 VGND VGND VPWR VPWR sky130_fd_sc_hd__decap_4
X_15059_ net1453 _05177_ _01901_ VGND VGND VPWR VPWR _01910_ sky130_fd_sc_hd__mux2_1
X_07881_ reg_pc\[5\] decoded_imm\[5\] VGND VGND VPWR VPWR _02289_ sky130_fd_sc_hd__and2_1
X_09620_ _02243_ _02280_ _03652_ VGND VGND VPWR VPWR _03853_ sky130_fd_sc_hd__mux2_1
X_09551_ _03785_ _02224_ _03715_ VGND VGND VPWR VPWR _03786_ sky130_fd_sc_hd__mux2_1
XFILLER_0_77_113 VGND VGND VPWR VPWR sky130_fd_sc_hd__decap_3
X_08502_ _02263_ _02753_ _02879_ VGND VGND VPWR VPWR _02880_ sky130_fd_sc_hd__a21oi_1
X_09482_ _03709_ VGND VGND VPWR VPWR _03717_ sky130_fd_sc_hd__clkbuf_4
X_08433_ net219 VGND VGND VPWR VPWR _02814_ sky130_fd_sc_hd__inv_2
X_08364_ _02740_ _02741_ _02744_ VGND VGND VPWR VPWR _02745_ sky130_fd_sc_hd__a21o_1
XFILLER_0_92_149 VGND VGND VPWR VPWR sky130_fd_sc_hd__decap_3
XFILLER_0_92_127 VGND VGND VPWR VPWR sky130_fd_sc_hd__fill_2
XFILLER_0_46_533 VGND VGND VPWR VPWR sky130_fd_sc_hd__fill_2
XFILLER_0_129_782 VGND VGND VPWR VPWR sky130_fd_sc_hd__fill_2
XFILLER_0_128_270 VPWR VGND VPWR VGND sky130_ef_sc_hd__decap_12
XFILLER_0_116_421 VGND VGND VPWR VPWR sky130_fd_sc_hd__decap_8
X_08295_ _02674_ _02675_ VGND VGND VPWR VPWR _02676_ sky130_fd_sc_hd__nand2_1
XFILLER_0_5_140 VGND VGND VPWR VPWR sky130_fd_sc_hd__fill_1
XFILLER_0_131_402 VGND VGND VPWR VPWR sky130_fd_sc_hd__decap_8
XFILLER_0_131_457 VGND VGND VPWR VPWR sky130_fd_sc_hd__decap_6
XFILLER_0_131_446 VGND VGND VPWR VPWR sky130_fd_sc_hd__fill_2
XFILLER_0_14_452 VGND VGND VPWR VPWR sky130_fd_sc_hd__fill_1
XFILLER_0_14_474 VGND VGND VPWR VPWR sky130_fd_sc_hd__fill_2
XFILLER_0_112_671 VGND VGND VPWR VPWR sky130_fd_sc_hd__decap_6
X_09818_ _04045_ _04046_ _00014_ VGND VGND VPWR VPWR _04047_ sky130_fd_sc_hd__a21o_1
XFILLER_0_69_603 VGND VGND VPWR VPWR sky130_fd_sc_hd__fill_2
X_09749_ _03797_ VGND VGND VPWR VPWR _03980_ sky130_fd_sc_hd__clkbuf_8
XTAP_2013 VGND VPWR sky130_fd_sc_hd__tapvpwrvgnd_1
XTAP_2024 VGND VPWR sky130_fd_sc_hd__tapvpwrvgnd_1
XTAP_2002 VGND VPWR sky130_fd_sc_hd__tapvpwrvgnd_1
XTAP_2068 VGND VPWR sky130_fd_sc_hd__tapvpwrvgnd_1
XTAP_2057 VGND VPWR sky130_fd_sc_hd__tapvpwrvgnd_1
XTAP_2046 VGND VPWR sky130_fd_sc_hd__tapvpwrvgnd_1
XTAP_2035 VGND VPWR sky130_fd_sc_hd__tapvpwrvgnd_1
X_12760_ _06292_ VGND VGND VPWR VPWR _06293_ sky130_fd_sc_hd__clkbuf_8
XTAP_1323 VGND VPWR sky130_fd_sc_hd__tapvpwrvgnd_1
XTAP_1312 VGND VPWR sky130_fd_sc_hd__tapvpwrvgnd_1
XTAP_1301 VGND VPWR sky130_fd_sc_hd__tapvpwrvgnd_1
XFILLER_0_68_135 VGND VGND VPWR VPWR sky130_fd_sc_hd__decap_4
XTAP_2079 VGND VPWR sky130_fd_sc_hd__tapvpwrvgnd_1
X_11711_ net644 _05213_ _05469_ VGND VGND VPWR VPWR _05475_ sky130_fd_sc_hd__mux2_1
XFILLER_0_96_477 VGND VGND VPWR VPWR sky130_fd_sc_hd__decap_4
XTAP_1345 VGND VPWR sky130_fd_sc_hd__tapvpwrvgnd_1
XTAP_1356 VGND VPWR sky130_fd_sc_hd__tapvpwrvgnd_1
XTAP_1334 VGND VPWR sky130_fd_sc_hd__tapvpwrvgnd_1
X_12691_ net1370 _06230_ _06233_ VGND VGND VPWR VPWR _00762_ sky130_fd_sc_hd__o21a_1
X_11642_ _05438_ VGND VGND VPWR VPWR _00508_ sky130_fd_sc_hd__clkbuf_1
XTAP_1389 VGND VPWR sky130_fd_sc_hd__tapvpwrvgnd_1
XTAP_1378 VGND VPWR sky130_fd_sc_hd__tapvpwrvgnd_1
XTAP_1367 VGND VPWR sky130_fd_sc_hd__tapvpwrvgnd_1
X_14430_ net1349 _05159_ _01576_ VGND VGND VPWR VPWR _01577_ sky130_fd_sc_hd__mux2_1
XFILLER_0_126_229 VGND VGND VPWR VPWR sky130_fd_sc_hd__decap_4
XFILLER_0_92_661 VGND VGND VPWR VPWR sky130_fd_sc_hd__fill_1
X_14361_ _07615_ VGND VGND VPWR VPWR _07616_ sky130_fd_sc_hd__buf_4
X_11573_ _05035_ net1296 _05397_ VGND VGND VPWR VPWR _05402_ sky130_fd_sc_hd__mux2_1
X_13312_ _06794_ _06795_ VGND VGND VPWR VPWR _06796_ sky130_fd_sc_hd__and2_1
X_16100_ clknet_leaf_145_clk _00750_ VGND VGND VPWR VPWR count_cycle\[43\] sky130_fd_sc_hd__dfxtp_1
Xinput18 mem_rdata[25] VGND VGND VPWR VPWR net18 sky130_fd_sc_hd__clkbuf_4
XFILLER_0_24_205 VGND VGND VPWR VPWR sky130_fd_sc_hd__decap_4
Xinput29 mem_rdata[6] VGND VGND VPWR VPWR net29 sky130_fd_sc_hd__buf_2
X_10524_ _03739_ _04729_ _04733_ _03873_ VGND VGND VPWR VPWR _04734_ sky130_fd_sc_hd__o211a_1
X_14292_ _02118_ VGND VGND VPWR VPWR _07576_ sky130_fd_sc_hd__clkbuf_2
X_10455_ _03688_ _04666_ VGND VGND VPWR VPWR _04667_ sky130_fd_sc_hd__or2_1
X_16031_ clknet_leaf_10_clk _00681_ VGND VGND VPWR VPWR reg_next_pc\[6\] sky130_fd_sc_hd__dfxtp_1
X_13243_ _03314_ VGND VGND VPWR VPWR _06728_ sky130_fd_sc_hd__buf_4
X_13174_ _06416_ _06647_ _06661_ _06470_ decoded_imm\[11\] VGND VGND VPWR VPWR _06662_
+ sky130_fd_sc_hd__a32o_1
XFILLER_0_32_293 VGND VGND VPWR VPWR sky130_fd_sc_hd__decap_8
X_12125_ _03633_ reg_next_pc\[29\] _03224_ VGND VGND VPWR VPWR _05757_ sky130_fd_sc_hd__mux2_2
X_10386_ _03744_ _04595_ _04599_ _03885_ VGND VGND VPWR VPWR _04600_ sky130_fd_sc_hd__o211a_1
XFILLER_0_58_39 VGND VGND VPWR VPWR sky130_fd_sc_hd__decap_6
XFILLER_0_20_444 VGND VGND VPWR VPWR sky130_fd_sc_hd__decap_4
XFILLER_0_20_477 VGND VGND VPWR VPWR sky130_fd_sc_hd__fill_1
X_16933_ clknet_leaf_84_clk _01497_ VGND VGND VPWR VPWR cpuregs\[0\]\[20\] sky130_fd_sc_hd__dfxtp_1
X_12056_ _05686_ _05708_ VGND VGND VPWR VPWR _05709_ sky130_fd_sc_hd__or2_1
X_11007_ _05085_ VGND VGND VPWR VPWR _00226_ sky130_fd_sc_hd__clkbuf_1
X_16864_ clknet_leaf_53_clk _01428_ VGND VGND VPWR VPWR cpuregs\[22\]\[15\] sky130_fd_sc_hd__dfxtp_1
X_15815_ clknet_leaf_98_clk _00465_ VGND VGND VPWR VPWR cpuregs\[16\]\[13\] sky130_fd_sc_hd__dfxtp_1
XFILLER_0_59_113 VGND VGND VPWR VPWR sky130_fd_sc_hd__decap_4
X_16795_ clknet_leaf_111_clk _01359_ VGND VGND VPWR VPWR cpuregs\[6\]\[10\] sky130_fd_sc_hd__dfxtp_1
XFILLER_0_90_26 VGND VGND VPWR VPWR sky130_fd_sc_hd__fill_2
X_15746_ clknet_leaf_113_clk _00396_ VGND VGND VPWR VPWR cpuregs\[15\]\[8\] sky130_fd_sc_hd__dfxtp_1
X_12958_ _03341_ _06451_ VGND VGND VPWR VPWR _06452_ sky130_fd_sc_hd__and2_1
XFILLER_0_90_48 VGND VGND VPWR VPWR sky130_fd_sc_hd__decap_8
XFILLER_0_47_319 VGND VGND VPWR VPWR sky130_fd_sc_hd__fill_2
XFILLER_0_47_308 VGND VGND VPWR VPWR sky130_fd_sc_hd__fill_1
X_11909_ count_instr\[30\] _05599_ VGND VGND VPWR VPWR _05603_ sky130_fd_sc_hd__or2_1
X_12889_ _03324_ VGND VGND VPWR VPWR _06387_ sky130_fd_sc_hd__buf_4
X_15677_ clknet_leaf_130_clk _00327_ VGND VGND VPWR VPWR cpuregs\[27\]\[3\] sky130_fd_sc_hd__dfxtp_1
X_14628_ _05047_ net1648 _01647_ VGND VGND VPWR VPWR _01681_ sky130_fd_sc_hd__mux2_1
XFILLER_0_56_831 VGND VGND VPWR VPWR sky130_fd_sc_hd__fill_1
XTAP_1890 VGND VPWR sky130_fd_sc_hd__tapvpwrvgnd_1
XFILLER_0_55_352 VGND VGND VPWR VPWR sky130_fd_sc_hd__decap_3
X_14559_ _01644_ VGND VGND VPWR VPWR _01154_ sky130_fd_sc_hd__clkbuf_1
XFILLER_0_55_363 VGND VGND VPWR VPWR sky130_fd_sc_hd__fill_1
X_08080_ reg_pc\[18\] decoded_imm\[18\] VGND VGND VPWR VPWR _02475_ sky130_fd_sc_hd__nand2_1
XFILLER_0_82_182 VGND VGND VPWR VPWR sky130_fd_sc_hd__fill_1
XFILLER_0_70_322 VGND VGND VPWR VPWR sky130_fd_sc_hd__decap_6
X_16229_ clknet_leaf_13_clk alu_out\[2\] VGND VGND VPWR VPWR alu_out_q\[2\] sky130_fd_sc_hd__dfxtp_1
X_08982_ _02593_ _03279_ _03268_ VGND VGND VPWR VPWR _03280_ sky130_fd_sc_hd__mux2_1
X_07933_ latched_is_lb _02328_ VGND VGND VPWR VPWR _02338_ sky130_fd_sc_hd__and2_2
XFILLER_0_48_94 VGND VGND VPWR VPWR sky130_fd_sc_hd__fill_2
X_07864_ reg_pc\[3\] decoded_imm\[3\] VGND VGND VPWR VPWR _02273_ sky130_fd_sc_hd__nand2_1
X_09603_ _03722_ VGND VGND VPWR VPWR _03837_ sky130_fd_sc_hd__buf_4
X_07795_ mem_wordsize\[2\] mem_wordsize\[1\] VGND VGND VPWR VPWR _02209_ sky130_fd_sc_hd__nor2_4
X_09534_ cpuregs\[4\]\[1\] cpuregs\[5\]\[1\] _03768_ VGND VGND VPWR VPWR _03769_ sky130_fd_sc_hd__mux2_1
X_09465_ _03660_ _03692_ _03694_ _03698_ _03700_ VGND VGND VPWR VPWR _03701_ sky130_fd_sc_hd__o32a_2
X_08416_ _02795_ _02671_ _02679_ _02796_ VGND VGND VPWR VPWR _02797_ sky130_fd_sc_hd__a31o_1
X_09396_ _03634_ VGND VGND VPWR VPWR _03635_ sky130_fd_sc_hd__buf_2
XFILLER_0_93_458 VGND VGND VPWR VPWR sky130_fd_sc_hd__fill_1
XFILLER_0_81_609 VGND VGND VPWR VPWR sky130_fd_sc_hd__fill_1
XFILLER_0_80_70 VPWR VGND VPWR VGND sky130_ef_sc_hd__decap_12
X_08347_ _02723_ _02724_ _02727_ VGND VGND VPWR VPWR _02728_ sky130_fd_sc_hd__a21oi_1
XFILLER_0_74_672 VGND VGND VPWR VPWR sky130_fd_sc_hd__decap_4
X_08278_ _02651_ _02652_ _02659_ VGND VGND VPWR VPWR _07642_ sky130_fd_sc_hd__o21bai_1
X_10240_ cpuregs\[2\]\[18\] cpuregs\[3\]\[18\] _03898_ VGND VGND VPWR VPWR _04458_
+ sky130_fd_sc_hd__mux2_1
XFILLER_0_15_794 VPWR VGND VPWR VGND sky130_ef_sc_hd__decap_12
X_10171_ _03744_ _04386_ _04390_ _03885_ VGND VGND VPWR VPWR _04391_ sky130_fd_sc_hd__o211a_1
X_13930_ instr_addi _07325_ _07328_ _07364_ VGND VGND VPWR VPWR _07365_ sky130_fd_sc_hd__a22o_1
X_15600_ clknet_leaf_60_clk _00250_ VGND VGND VPWR VPWR cpuregs\[28\]\[22\] sky130_fd_sc_hd__dfxtp_1
X_13861_ _01098_ _01097_ _07316_ VGND VGND VPWR VPWR _07317_ sky130_fd_sc_hd__and3_1
X_13792_ cpuregs\[12\]\[31\] cpuregs\[13\]\[31\] cpuregs\[14\]\[31\] cpuregs\[15\]\[31\]
+ _07027_ _06392_ VGND VGND VPWR VPWR _07260_ sky130_fd_sc_hd__mux4_1
X_12812_ net520 net82 _06313_ VGND VGND VPWR VPWR _06321_ sky130_fd_sc_hd__mux2_1
X_16580_ clknet_leaf_140_clk _00004_ VGND VGND VPWR VPWR reg_sh\[2\] sky130_fd_sc_hd__dfxtp_1
XFILLER_0_84_403 VGND VGND VPWR VPWR sky130_fd_sc_hd__fill_2
X_12743_ cpuregs\[28\]\[31\] cpuregs\[29\]\[31\] _04058_ VGND VGND VPWR VPWR _06277_
+ sky130_fd_sc_hd__mux2_1
X_15531_ clknet_leaf_104_clk _00181_ VGND VGND VPWR VPWR cpuregs\[13\]\[17\] sky130_fd_sc_hd__dfxtp_1
XTAP_1131 VGND VPWR sky130_fd_sc_hd__tapvpwrvgnd_1
XTAP_1120 VGND VPWR sky130_fd_sc_hd__tapvpwrvgnd_1
X_15462_ clknet_leaf_107_clk _00112_ VGND VGND VPWR VPWR cpuregs\[12\]\[12\] sky130_fd_sc_hd__dfxtp_1
XTAP_1164 VGND VPWR sky130_fd_sc_hd__tapvpwrvgnd_1
XTAP_1153 VGND VPWR sky130_fd_sc_hd__tapvpwrvgnd_1
XTAP_1142 VGND VPWR sky130_fd_sc_hd__tapvpwrvgnd_1
XFILLER_0_56_138 VGND VGND VPWR VPWR sky130_fd_sc_hd__fill_2
X_14413_ _01567_ VGND VGND VPWR VPWR _01053_ sky130_fd_sc_hd__clkbuf_1
XTAP_1197 VGND VPWR sky130_fd_sc_hd__tapvpwrvgnd_1
XTAP_1186 VGND VPWR sky130_fd_sc_hd__tapvpwrvgnd_1
XTAP_1175 VGND VPWR sky130_fd_sc_hd__tapvpwrvgnd_1
X_12674_ _06221_ VGND VGND VPWR VPWR _00757_ sky130_fd_sc_hd__clkbuf_1
XFILLER_0_121_9 VGND VGND VPWR VPWR sky130_fd_sc_hd__decap_6
X_11625_ _05429_ VGND VGND VPWR VPWR _00500_ sky130_fd_sc_hd__clkbuf_1
X_15393_ clknet_leaf_103_clk _00048_ VGND VGND VPWR VPWR cpuregs\[11\]\[11\] sky130_fd_sc_hd__dfxtp_1
XFILLER_0_80_642 VGND VGND VPWR VPWR sky130_fd_sc_hd__fill_2
X_11556_ _05018_ net1065 _05386_ VGND VGND VPWR VPWR _05393_ sky130_fd_sc_hd__mux2_1
X_14344_ _07320_ decoded_imm_j\[6\] _07588_ mem_rdata_q\[26\] _07357_ VGND VGND VPWR
+ VPWR _07605_ sky130_fd_sc_hd__a221o_1
X_10507_ _02241_ _04690_ _04717_ _03717_ VGND VGND VPWR VPWR _04718_ sky130_fd_sc_hd__a22o_1
XFILLER_0_107_7 VGND VGND VPWR VPWR sky130_fd_sc_hd__fill_2
X_14275_ reg_sh\[0\] _03653_ _02207_ VGND VGND VPWR VPWR _07563_ sky130_fd_sc_hd__o21ai_1
XFILLER_0_123_777 VGND VGND VPWR VPWR sky130_fd_sc_hd__fill_1
XFILLER_0_122_265 VGND VGND VPWR VPWR sky130_fd_sc_hd__decap_3
X_16014_ clknet_leaf_33_clk _00664_ VGND VGND VPWR VPWR reg_pc\[20\] sky130_fd_sc_hd__dfxtp_2
X_11487_ net766 _05194_ _05349_ VGND VGND VPWR VPWR _05356_ sky130_fd_sc_hd__mux2_1
XFILLER_0_69_49 VGND VGND VPWR VPWR sky130_fd_sc_hd__fill_1
X_13226_ _06631_ _06703_ _06711_ VGND VGND VPWR VPWR _06712_ sky130_fd_sc_hd__or3_2
XFILLER_0_52_399 VGND VGND VPWR VPWR sky130_fd_sc_hd__fill_2
XFILLER_0_122_298 VGND VGND VPWR VPWR sky130_fd_sc_hd__decap_4
X_10438_ _03984_ _04649_ _03661_ VGND VGND VPWR VPWR _04650_ sky130_fd_sc_hd__a21o_1
X_10369_ _04580_ _04581_ VGND VGND VPWR VPWR _04583_ sky130_fd_sc_hd__or2_1
X_13157_ _06580_ _06644_ VGND VGND VPWR VPWR _06645_ sky130_fd_sc_hd__or2_1
XTAP_904 VGND VPWR sky130_fd_sc_hd__tapvpwrvgnd_1
XTAP_915 VGND VPWR sky130_fd_sc_hd__tapvpwrvgnd_1
XTAP_926 VGND VPWR sky130_fd_sc_hd__tapvpwrvgnd_1
X_12108_ _02108_ _05745_ VGND VGND VPWR VPWR _05746_ sky130_fd_sc_hd__or2_1
XTAP_959 VGND VPWR sky130_fd_sc_hd__tapvpwrvgnd_1
XTAP_948 VGND VPWR sky130_fd_sc_hd__tapvpwrvgnd_1
XTAP_937 VGND VPWR sky130_fd_sc_hd__tapvpwrvgnd_1
X_13088_ cpuregs\[6\]\[9\] cpuregs\[7\]\[9\] _06511_ VGND VGND VPWR VPWR _06578_ sky130_fd_sc_hd__mux2_1
XFILLER_0_109_44 VPWR VGND VPWR VGND sky130_ef_sc_hd__decap_12
X_16916_ clknet_leaf_113_clk _01480_ VGND VGND VPWR VPWR cpuregs\[0\]\[3\] sky130_fd_sc_hd__dfxtp_1
X_12039_ _05530_ VGND VGND VPWR VPWR _05697_ sky130_fd_sc_hd__buf_4
XFILLER_0_18_75 VGND VGND VPWR VPWR sky130_fd_sc_hd__decap_4
X_16847_ clknet_leaf_92_clk _01411_ VGND VGND VPWR VPWR cpuregs\[7\]\[30\] sky130_fd_sc_hd__dfxtp_1
XFILLER_0_79_208 VPWR VGND VPWR VGND sky130_ef_sc_hd__decap_12
Xclkbuf_4_1_0_clk clknet_0_clk VGND VGND VPWR VPWR clknet_4_1_0_clk sky130_fd_sc_hd__clkbuf_8
X_16778_ clknet_leaf_73_clk _01342_ VGND VGND VPWR VPWR cpuregs\[5\]\[25\] sky130_fd_sc_hd__dfxtp_1
XFILLER_0_88_753 VGND VGND VPWR VPWR sky130_fd_sc_hd__decap_3
XFILLER_0_88_731 VGND VGND VPWR VPWR sky130_fd_sc_hd__fill_2
X_15729_ clknet_leaf_62_clk _00379_ VGND VGND VPWR VPWR cpuregs\[21\]\[23\] sky130_fd_sc_hd__dfxtp_1
XFILLER_0_118_505 VGND VGND VPWR VPWR sky130_fd_sc_hd__fill_1
X_09250_ _03467_ _03507_ VGND VGND VPWR VPWR _03508_ sky130_fd_sc_hd__nor2_1
XFILLER_0_34_85 VGND VGND VPWR VPWR sky130_fd_sc_hd__fill_2
X_08201_ reg_pc\[24\] decoded_imm\[24\] _02574_ VGND VGND VPWR VPWR _02588_ sky130_fd_sc_hd__a21oi_1
X_09181_ reg_out\[1\] alu_out_q\[1\] _03435_ VGND VGND VPWR VPWR _03448_ sky130_fd_sc_hd__mux2_1
XFILLER_0_8_769 VPWR VGND VPWR VGND sky130_ef_sc_hd__decap_12
X_08132_ _02309_ _02522_ _02446_ _02523_ VGND VGND VPWR VPWR _02524_ sky130_fd_sc_hd__o2bb2a_1
XFILLER_0_7_279 VGND VGND VPWR VPWR sky130_fd_sc_hd__fill_1
X_08063_ reg_pc\[17\] decoded_imm\[17\] VGND VGND VPWR VPWR _02459_ sky130_fd_sc_hd__nand2_1
XFILLER_0_70_185 VGND VGND VPWR VPWR sky130_fd_sc_hd__decap_8
Xpicorv32_352 VGND VGND VPWR VPWR picorv32_352/HI trace_data[30] sky130_fd_sc_hd__conb_1
Xpicorv32_330 VGND VGND VPWR VPWR picorv32_330/HI trace_data[8] sky130_fd_sc_hd__conb_1
Xpicorv32_341 VGND VGND VPWR VPWR picorv32_341/HI trace_data[19] sky130_fd_sc_hd__conb_1
XFILLER_0_12_742 VGND VGND VPWR VPWR sky130_fd_sc_hd__fill_1
XFILLER_0_12_797 VPWR VGND VPWR VGND sky130_ef_sc_hd__decap_12
X_08965_ _02111_ VGND VGND VPWR VPWR _03268_ sky130_fd_sc_hd__buf_4
X_07916_ _02304_ _02307_ _02306_ VGND VGND VPWR VPWR _02322_ sky130_fd_sc_hd__a21oi_1
X_08896_ net224 _02448_ _03210_ VGND VGND VPWR VPWR net118 sky130_fd_sc_hd__a21o_2
X_07847_ reg_pc\[2\] decoded_imm\[2\] _02256_ VGND VGND VPWR VPWR _02257_ sky130_fd_sc_hd__o21ai_1
XFILLER_0_79_753 VGND VGND VPWR VPWR sky130_fd_sc_hd__fill_2
X_07778_ _02172_ _02131_ VGND VGND VPWR VPWR _02193_ sky130_fd_sc_hd__and2_1
XFILLER_0_94_712 VGND VGND VPWR VPWR sky130_fd_sc_hd__fill_1
XFILLER_0_94_701 VGND VGND VPWR VPWR sky130_fd_sc_hd__fill_2
XFILLER_0_78_241 VGND VGND VPWR VPWR sky130_fd_sc_hd__decap_8
X_09517_ cpuregs\[12\]\[1\] cpuregs\[13\]\[1\] _03751_ VGND VGND VPWR VPWR _03752_
+ sky130_fd_sc_hd__mux2_1
XFILLER_0_39_617 VGND VGND VPWR VPWR sky130_fd_sc_hd__fill_1
XPHY_225 VGND VGND VPWR VPWR sky130_fd_sc_hd__decap_3
XPHY_214 VGND VGND VPWR VPWR sky130_fd_sc_hd__decap_3
XPHY_203 VGND VGND VPWR VPWR sky130_fd_sc_hd__decap_3
XFILLER_0_91_91 VPWR VGND VPWR VGND sky130_ef_sc_hd__decap_12
XPHY_258 VGND VGND VPWR VPWR sky130_fd_sc_hd__decap_3
XPHY_247 VGND VGND VPWR VPWR sky130_fd_sc_hd__decap_3
XPHY_236 VGND VGND VPWR VPWR sky130_fd_sc_hd__decap_3
X_09448_ _00015_ VGND VGND VPWR VPWR _03684_ sky130_fd_sc_hd__buf_4
XFILLER_0_66_458 VGND VGND VPWR VPWR sky130_fd_sc_hd__fill_2
XPHY_269 VGND VGND VPWR VPWR sky130_fd_sc_hd__decap_3
X_09379_ reg_pc\[27\] _03612_ _03459_ VGND VGND VPWR VPWR _03620_ sky130_fd_sc_hd__o21a_1
X_12390_ _05773_ _05980_ VGND VGND VPWR VPWR _05999_ sky130_fd_sc_hd__nor2_1
X_11410_ _05315_ VGND VGND VPWR VPWR _00399_ sky130_fd_sc_hd__clkbuf_1
X_11341_ _05008_ net1536 _05277_ VGND VGND VPWR VPWR _05279_ sky130_fd_sc_hd__mux2_1
XFILLER_0_34_399 VPWR VGND VPWR VGND sky130_ef_sc_hd__decap_12
XFILLER_0_104_298 VGND VGND VPWR VPWR sky130_fd_sc_hd__decap_6
X_11272_ net663 _05184_ _05240_ VGND VGND VPWR VPWR _05242_ sky130_fd_sc_hd__mux2_1
X_14060_ _07446_ VGND VGND VPWR VPWR _00899_ sky130_fd_sc_hd__clkbuf_1
X_10223_ _04439_ _04440_ VGND VGND VPWR VPWR _04441_ sky130_fd_sc_hd__and2_1
XFILLER_0_30_572 VGND VGND VPWR VPWR sky130_fd_sc_hd__decap_4
X_13011_ cpuregs\[8\]\[7\] cpuregs\[9\]\[7\] _06422_ VGND VGND VPWR VPWR _06503_ sky130_fd_sc_hd__mux2_1
X_10154_ _04370_ _04373_ VGND VGND VPWR VPWR _04374_ sky130_fd_sc_hd__or2_1
X_14962_ _01858_ VGND VGND VPWR VPWR _01343_ sky130_fd_sc_hd__clkbuf_1
X_10085_ _03878_ _04304_ _04306_ VGND VGND VPWR VPWR _04307_ sky130_fd_sc_hd__a21o_1
X_14893_ _03616_ net1392 _01815_ VGND VGND VPWR VPWR _01822_ sky130_fd_sc_hd__mux2_1
X_16701_ clknet_leaf_82_clk _01268_ VGND VGND VPWR VPWR cpuregs\[3\]\[15\] sky130_fd_sc_hd__dfxtp_1
X_13913_ _01106_ _01105_ _01107_ VGND VGND VPWR VPWR _07356_ sky130_fd_sc_hd__nor3_1
X_16632_ clknet_leaf_137_clk _01199_ VGND VGND VPWR VPWR cpuregs\[23\]\[10\] sky130_fd_sc_hd__dfxtp_1
X_13844_ _07305_ VGND VGND VPWR VPWR _07306_ sky130_fd_sc_hd__buf_2
X_10987_ _05075_ VGND VGND VPWR VPWR _00216_ sky130_fd_sc_hd__clkbuf_1
X_13775_ _06962_ _07236_ _07243_ VGND VGND VPWR VPWR _07244_ sky130_fd_sc_hd__or3_2
X_16563_ clknet_leaf_55_clk _01140_ VGND VGND VPWR VPWR cpuregs\[24\]\[15\] sky130_fd_sc_hd__dfxtp_1
XFILLER_0_57_425 VGND VGND VPWR VPWR sky130_fd_sc_hd__fill_1
X_16494_ clknet_leaf_54_clk _01076_ VGND VGND VPWR VPWR cpuregs\[19\]\[15\] sky130_fd_sc_hd__dfxtp_1
XFILLER_0_85_756 VGND VGND VPWR VPWR sky130_fd_sc_hd__fill_2
XFILLER_0_84_233 VGND VGND VPWR VPWR sky130_fd_sc_hd__decap_8
X_12726_ _04045_ _06259_ _03674_ VGND VGND VPWR VPWR _06260_ sky130_fd_sc_hd__a21o_1
X_15514_ clknet_leaf_119_clk _00164_ VGND VGND VPWR VPWR cpuregs\[13\]\[0\] sky130_fd_sc_hd__dfxtp_1
XFILLER_0_139_195 VGND VGND VPWR VPWR sky130_fd_sc_hd__decap_8
X_15445_ clknet_leaf_50_clk _00095_ VGND VGND VPWR VPWR net189 sky130_fd_sc_hd__dfxtp_4
XFILLER_0_84_277 VGND VGND VPWR VPWR sky130_fd_sc_hd__decap_4
X_12657_ _06207_ _06179_ _06208_ VGND VGND VPWR VPWR _06209_ sky130_fd_sc_hd__and3b_1
X_15376_ _02075_ VGND VGND VPWR VPWR _01540_ sky130_fd_sc_hd__clkbuf_1
X_11608_ _05420_ VGND VGND VPWR VPWR _00492_ sky130_fd_sc_hd__clkbuf_1
XFILLER_0_37_182 VGND VGND VPWR VPWR sky130_fd_sc_hd__decap_4
XFILLER_0_123_530 VGND VGND VPWR VPWR sky130_fd_sc_hd__fill_2
X_14327_ _06025_ decoded_imm_j\[14\] _07570_ _07327_ _07388_ VGND VGND VPWR VPWR _07596_
+ sky130_fd_sc_hd__a221o_1
XFILLER_0_52_141 VGND VGND VPWR VPWR sky130_fd_sc_hd__decap_6
X_12588_ count_cycle\[26\] _06156_ VGND VGND VPWR VPWR _06160_ sky130_fd_sc_hd__nand2_1
XFILLER_0_40_303 VGND VGND VPWR VPWR sky130_fd_sc_hd__decap_4
Xhold407 cpuregs\[26\]\[24\] VGND VGND VPWR VPWR net765 sky130_fd_sc_hd__dlygate4sd3_1
XFILLER_0_80_494 VGND VGND VPWR VPWR sky130_fd_sc_hd__decap_8
Xhold418 cpuregs\[3\]\[16\] VGND VGND VPWR VPWR net776 sky130_fd_sc_hd__dlygate4sd3_1
X_11539_ _05001_ net1567 _05375_ VGND VGND VPWR VPWR _05384_ sky130_fd_sc_hd__mux2_1
X_14258_ net555 _06294_ _07554_ _06290_ VGND VGND VPWR VPWR _00987_ sky130_fd_sc_hd__o22a_1
Xhold429 cpuregs\[3\]\[4\] VGND VGND VPWR VPWR net787 sky130_fd_sc_hd__dlygate4sd3_1
XFILLER_0_96_69 VGND VGND VPWR VPWR sky130_fd_sc_hd__fill_2
X_13209_ _06695_ VGND VGND VPWR VPWR _00818_ sky130_fd_sc_hd__clkbuf_1
X_14189_ net235 _02115_ VGND VGND VPWR VPWR _07518_ sky130_fd_sc_hd__nor2_4
XTAP_701 VGND VPWR sky130_fd_sc_hd__tapvpwrvgnd_1
XTAP_712 VGND VPWR sky130_fd_sc_hd__tapvpwrvgnd_1
XTAP_723 VGND VPWR sky130_fd_sc_hd__tapvpwrvgnd_1
XTAP_734 VGND VPWR sky130_fd_sc_hd__tapvpwrvgnd_1
XTAP_745 VGND VPWR sky130_fd_sc_hd__tapvpwrvgnd_1
XTAP_756 VGND VPWR sky130_fd_sc_hd__tapvpwrvgnd_1
XTAP_767 VGND VPWR sky130_fd_sc_hd__tapvpwrvgnd_1
Xhold1118 cpuregs\[7\]\[23\] VGND VGND VPWR VPWR net1476 sky130_fd_sc_hd__dlygate4sd3_1
Xhold1107 cpuregs\[18\]\[29\] VGND VGND VPWR VPWR net1465 sky130_fd_sc_hd__dlygate4sd3_1
X_08750_ _02700_ _03101_ _03107_ _03020_ VGND VGND VPWR VPWR alu_out\[23\] sky130_fd_sc_hd__a22o_1
XFILLER_0_31_7 VGND VGND VPWR VPWR sky130_fd_sc_hd__fill_2
XTAP_789 VGND VPWR sky130_fd_sc_hd__tapvpwrvgnd_1
XTAP_778 VGND VPWR sky130_fd_sc_hd__tapvpwrvgnd_1
Xhold1129 cpuregs\[1\]\[5\] VGND VGND VPWR VPWR net1487 sky130_fd_sc_hd__dlygate4sd3_1
X_08681_ net180 _03043_ VGND VGND VPWR VPWR _03044_ sky130_fd_sc_hd__and2_1
X_07701_ instr_and instr_or instr_bgeu instr_bge VGND VGND VPWR VPWR _02127_ sky130_fd_sc_hd__or4_1
XFILLER_0_45_62 VPWR VGND VPWR VGND sky130_ef_sc_hd__decap_12
XFILLER_0_136_97 VGND VGND VPWR VPWR sky130_fd_sc_hd__decap_6
XFILLER_0_88_550 VGND VGND VPWR VPWR sky130_fd_sc_hd__fill_2
X_09302_ _03553_ VGND VGND VPWR VPWR _00053_ sky130_fd_sc_hd__clkbuf_1
XFILLER_0_0_42 VGND VGND VPWR VPWR sky130_fd_sc_hd__fill_1
XFILLER_0_0_75 VGND VGND VPWR VPWR sky130_fd_sc_hd__decap_3
X_09233_ reg_out\[8\] alu_out_q\[8\] latched_stalu VGND VGND VPWR VPWR _03493_ sky130_fd_sc_hd__mux2_1
XFILLER_0_35_119 VGND VGND VPWR VPWR sky130_fd_sc_hd__decap_6
X_09164_ latched_branch latched_store VGND VGND VPWR VPWR _03432_ sky130_fd_sc_hd__and2b_1
XFILLER_0_75_299 VGND VGND VPWR VPWR sky130_fd_sc_hd__decap_4
XFILLER_0_16_333 VGND VGND VPWR VPWR sky130_fd_sc_hd__fill_1
X_08115_ _02160_ VGND VGND VPWR VPWR _02508_ sky130_fd_sc_hd__buf_4
XFILLER_0_9_62 VGND VGND VPWR VPWR sky130_fd_sc_hd__fill_2
XFILLER_0_71_472 VGND VGND VPWR VPWR sky130_fd_sc_hd__decap_6
X_09095_ _03328_ _03374_ _03332_ VGND VGND VPWR VPWR _03375_ sky130_fd_sc_hd__o21a_1
XFILLER_0_114_585 VGND VGND VPWR VPWR sky130_fd_sc_hd__decap_3
X_08046_ _02437_ _02438_ _02441_ VGND VGND VPWR VPWR _02443_ sky130_fd_sc_hd__a21oi_1
Xhold930 cpuregs\[1\]\[16\] VGND VGND VPWR VPWR net1288 sky130_fd_sc_hd__dlygate4sd3_1
Xhold963 cpuregs\[10\]\[29\] VGND VGND VPWR VPWR net1321 sky130_fd_sc_hd__dlygate4sd3_1
XFILLER_0_102_769 VGND VGND VPWR VPWR sky130_fd_sc_hd__decap_4
Xhold941 cpuregs\[3\]\[18\] VGND VGND VPWR VPWR net1299 sky130_fd_sc_hd__dlygate4sd3_1
Xhold952 count_instr\[54\] VGND VGND VPWR VPWR net1310 sky130_fd_sc_hd__dlygate4sd3_1
XFILLER_0_3_293 VGND VGND VPWR VPWR sky130_fd_sc_hd__fill_1
Xhold985 cpuregs\[31\]\[25\] VGND VGND VPWR VPWR net1343 sky130_fd_sc_hd__dlygate4sd3_1
Xhold996 decoded_imm\[21\] VGND VGND VPWR VPWR net1354 sky130_fd_sc_hd__dlygate4sd3_1
Xhold974 cpuregs\[1\]\[8\] VGND VGND VPWR VPWR net1332 sky130_fd_sc_hd__dlygate4sd3_1
X_09997_ _02160_ _04191_ _04221_ _03717_ VGND VGND VPWR VPWR _04222_ sky130_fd_sc_hd__a22oi_1
X_08948_ _03256_ VGND VGND VPWR VPWR net71 sky130_fd_sc_hd__buf_4
XFILLER_0_99_826 VGND VGND VPWR VPWR sky130_fd_sc_hd__fill_2
X_08879_ net252 net246 _02447_ VGND VGND VPWR VPWR _03215_ sky130_fd_sc_hd__mux2_1
X_10910_ _05029_ net1034 _05027_ VGND VGND VPWR VPWR _05030_ sky130_fd_sc_hd__mux2_1
X_11890_ count_instr\[25\] count_instr\[24\] VGND VGND VPWR VPWR _05589_ sky130_fd_sc_hd__and2_1
X_10841_ latched_rd\[1\] _03442_ latched_rd\[0\] VGND VGND VPWR VPWR _04982_ sky130_fd_sc_hd__or3b_1
X_13560_ cpuregs\[6\]\[23\] cpuregs\[7\]\[23\] _06842_ VGND VGND VPWR VPWR _07036_
+ sky130_fd_sc_hd__mux2_1
X_10772_ _04942_ _04944_ VGND VGND VPWR VPWR _04945_ sky130_fd_sc_hd__nor2_2
XFILLER_0_82_715 VGND VGND VPWR VPWR sky130_fd_sc_hd__fill_1
XFILLER_0_81_214 VGND VGND VPWR VPWR sky130_fd_sc_hd__decap_8
X_13491_ _03311_ VGND VGND VPWR VPWR _06969_ sky130_fd_sc_hd__buf_4
X_12511_ _06104_ _06105_ VGND VGND VPWR VPWR _00710_ sky130_fd_sc_hd__nor2_1
XFILLER_0_136_165 VPWR VGND VPWR VGND sky130_ef_sc_hd__decap_12
X_12442_ _05852_ net419 _05816_ _06046_ VGND VGND VPWR VPWR _00700_ sky130_fd_sc_hd__o211a_1
X_15230_ _02000_ VGND VGND VPWR VPWR _01469_ sky130_fd_sc_hd__clkbuf_1
XFILLER_0_81_247 VGND VGND VPWR VPWR sky130_fd_sc_hd__fill_2
XFILLER_0_81_225 VGND VGND VPWR VPWR sky130_fd_sc_hd__fill_1
XFILLER_0_124_338 VGND VGND VPWR VPWR sky130_fd_sc_hd__decap_4
XFILLER_0_34_141 VGND VGND VPWR VPWR sky130_fd_sc_hd__decap_8
X_15161_ net720 _03602_ _01959_ VGND VGND VPWR VPWR _01964_ sky130_fd_sc_hd__mux2_1
X_12373_ _05969_ _05973_ _05982_ VGND VGND VPWR VPWR _05983_ sky130_fd_sc_hd__or3_1
X_15092_ _01927_ VGND VGND VPWR VPWR _01404_ sky130_fd_sc_hd__clkbuf_1
X_11324_ _04991_ net1282 _05266_ VGND VGND VPWR VPWR _05270_ sky130_fd_sc_hd__mux2_1
X_14112_ _07475_ VGND VGND VPWR VPWR _00920_ sky130_fd_sc_hd__clkbuf_1
X_14043_ decoded_imm_j\[19\] _01112_ _07420_ VGND VGND VPWR VPWR _07438_ sky130_fd_sc_hd__mux2_1
X_11255_ net906 _05167_ _05229_ VGND VGND VPWR VPWR _05233_ sky130_fd_sc_hd__mux2_1
X_10206_ _04045_ _04424_ _03674_ VGND VGND VPWR VPWR _04425_ sky130_fd_sc_hd__a21o_1
X_11186_ net725 _05186_ _05182_ VGND VGND VPWR VPWR _05187_ sky130_fd_sc_hd__mux2_1
X_10137_ _03780_ _04330_ _04357_ _03793_ VGND VGND VPWR VPWR _04358_ sky130_fd_sc_hd__a22o_1
X_15994_ clknet_leaf_2_clk _00644_ VGND VGND VPWR VPWR count_instr\[63\] sky130_fd_sc_hd__dfxtp_1
X_10068_ _03780_ _04263_ _04290_ _03793_ VGND VGND VPWR VPWR _04291_ sky130_fd_sc_hd__a22o_1
X_14945_ _01849_ VGND VGND VPWR VPWR _01335_ sky130_fd_sc_hd__clkbuf_1
X_14876_ _03564_ net1391 _01804_ VGND VGND VPWR VPWR _01813_ sky130_fd_sc_hd__mux2_1
X_16615_ clknet_leaf_71_clk _01182_ VGND VGND VPWR VPWR cpuregs\[9\]\[25\] sky130_fd_sc_hd__dfxtp_1
XFILLER_0_97_380 VGND VGND VPWR VPWR sky130_fd_sc_hd__decap_3
X_13827_ latched_store _02161_ _07289_ _07293_ _05526_ VGND VGND VPWR VPWR _00838_
+ sky130_fd_sc_hd__o311a_1
X_13758_ _06377_ _07217_ _07221_ _07227_ _06341_ VGND VGND VPWR VPWR _07228_ sky130_fd_sc_hd__a311o_1
X_16546_ clknet_leaf_26_clk _01123_ VGND VGND VPWR VPWR mem_rdata_q\[30\] sky130_fd_sc_hd__dfxtp_1
XFILLER_0_58_745 VGND VGND VPWR VPWR sky130_fd_sc_hd__decap_3
XFILLER_0_57_222 VGND VGND VPWR VPWR sky130_fd_sc_hd__fill_2
XFILLER_0_15_76 VGND VGND VPWR VPWR sky130_fd_sc_hd__fill_2
XFILLER_0_57_266 VGND VGND VPWR VPWR sky130_fd_sc_hd__fill_1
X_12709_ net409 _06242_ _06246_ VGND VGND VPWR VPWR _00767_ sky130_fd_sc_hd__o21a_1
XFILLER_0_128_677 VGND VGND VPWR VPWR sky130_fd_sc_hd__decap_4
X_13689_ cpuregs\[22\]\[27\] cpuregs\[23\]\[27\] _06386_ VGND VGND VPWR VPWR _07161_
+ sky130_fd_sc_hd__mux2_1
X_16477_ clknet_leaf_57_clk _01059_ VGND VGND VPWR VPWR cpuregs\[18\]\[30\] sky130_fd_sc_hd__dfxtp_1
XFILLER_0_115_349 VGND VGND VPWR VPWR sky130_fd_sc_hd__fill_1
XFILLER_0_115_327 VGND VGND VPWR VPWR sky130_fd_sc_hd__decap_3
X_15428_ clknet_leaf_19_clk _00078_ VGND VGND VPWR VPWR net202 sky130_fd_sc_hd__dfxtp_2
XFILLER_0_72_258 VGND VGND VPWR VPWR sky130_fd_sc_hd__fill_2
XFILLER_0_14_804 VGND VGND VPWR VPWR sky130_fd_sc_hd__decap_8
X_15359_ _03597_ net1305 _02063_ VGND VGND VPWR VPWR _02067_ sky130_fd_sc_hd__mux2_1
XFILLER_0_25_163 VGND VGND VPWR VPWR sky130_fd_sc_hd__decap_4
XFILLER_0_40_111 VGND VGND VPWR VPWR sky130_fd_sc_hd__decap_3
Xhold226 cpuregs\[27\]\[22\] VGND VGND VPWR VPWR net584 sky130_fd_sc_hd__dlygate4sd3_1
Xhold204 mem_rdata_q\[17\] VGND VGND VPWR VPWR net562 sky130_fd_sc_hd__dlygate4sd3_1
Xhold215 cpuregs\[12\]\[12\] VGND VGND VPWR VPWR net573 sky130_fd_sc_hd__dlygate4sd3_1
XFILLER_0_1_720 VGND VGND VPWR VPWR sky130_fd_sc_hd__fill_2
XFILLER_0_25_196 VGND VGND VPWR VPWR sky130_fd_sc_hd__fill_2
Xhold248 cpuregs\[27\]\[25\] VGND VGND VPWR VPWR net606 sky130_fd_sc_hd__dlygate4sd3_1
XFILLER_0_123_393 VGND VGND VPWR VPWR sky130_fd_sc_hd__fill_1
X_09920_ _03794_ _04133_ _04146_ _03775_ reg_pc\[9\] VGND VGND VPWR VPWR _04147_ sky130_fd_sc_hd__a32o_1
Xhold259 mem_rdata_q\[9\] VGND VGND VPWR VPWR net617 sky130_fd_sc_hd__dlygate4sd3_1
Xhold237 cpuregs\[22\]\[7\] VGND VGND VPWR VPWR net595 sky130_fd_sc_hd__dlygate4sd3_1
X_09851_ decoded_imm\[8\] net201 VGND VGND VPWR VPWR _04079_ sky130_fd_sc_hd__nand2_1
XFILLER_0_1_797 VPWR VGND VPWR VGND sky130_ef_sc_hd__decap_12
XTAP_520 VGND VPWR sky130_fd_sc_hd__tapvpwrvgnd_1
XTAP_531 VGND VPWR sky130_fd_sc_hd__tapvpwrvgnd_1
XTAP_542 VGND VPWR sky130_fd_sc_hd__tapvpwrvgnd_1
X_08802_ _02732_ _02986_ _03155_ VGND VGND VPWR VPWR _03156_ sky130_fd_sc_hd__a21o_1
XTAP_553 VGND VPWR sky130_fd_sc_hd__tapvpwrvgnd_1
XTAP_564 VGND VPWR sky130_fd_sc_hd__tapvpwrvgnd_1
XTAP_575 VGND VPWR sky130_fd_sc_hd__tapvpwrvgnd_1
X_09782_ cpuregs\[14\]\[6\] cpuregs\[15\]\[6\] _03898_ VGND VGND VPWR VPWR _04012_
+ sky130_fd_sc_hd__mux2_1
X_08733_ _02522_ VGND VGND VPWR VPWR _03092_ sky130_fd_sc_hd__inv_2
XFILLER_0_56_83 VGND VGND VPWR VPWR sky130_fd_sc_hd__fill_1
XTAP_586 VGND VPWR sky130_fd_sc_hd__tapvpwrvgnd_1
XTAP_597 VGND VPWR sky130_fd_sc_hd__tapvpwrvgnd_1
X_08664_ _02445_ _02716_ _02839_ _02857_ VGND VGND VPWR VPWR _03029_ sky130_fd_sc_hd__a31o_1
XTAP_1719 VGND VPWR sky130_fd_sc_hd__tapvpwrvgnd_1
XTAP_1708 VGND VPWR sky130_fd_sc_hd__tapvpwrvgnd_1
X_08595_ _02780_ _02964_ VGND VGND VPWR VPWR _02965_ sky130_fd_sc_hd__xnor2_1
XFILLER_0_76_531 VGND VGND VPWR VPWR sky130_fd_sc_hd__fill_1
XFILLER_0_118_110 VGND VGND VPWR VPWR sky130_fd_sc_hd__decap_3
XFILLER_0_64_704 VGND VGND VPWR VPWR sky130_fd_sc_hd__fill_2
XFILLER_0_63_247 VGND VGND VPWR VPWR sky130_fd_sc_hd__fill_2
X_09216_ net1128 _03478_ _03446_ VGND VGND VPWR VPWR _03479_ sky130_fd_sc_hd__mux2_1
XFILLER_0_16_141 VGND VGND VPWR VPWR sky130_fd_sc_hd__decap_8
X_09147_ mem_rdata_q\[21\] net14 _03292_ VGND VGND VPWR VPWR _03423_ sky130_fd_sc_hd__mux2_1
XFILLER_0_32_645 VGND VGND VPWR VPWR sky130_fd_sc_hd__fill_2
X_09078_ decoded_imm_j\[3\] decoded_imm_j\[2\] decoded_imm_j\[1\] VGND VGND VPWR VPWR
+ _03359_ sky130_fd_sc_hd__or3_1
X_08029_ latched_is_lb latched_is_lh VGND VGND VPWR VPWR _02427_ sky130_fd_sc_hd__or2_1
Xhold782 cpuregs\[2\]\[27\] VGND VGND VPWR VPWR net1140 sky130_fd_sc_hd__dlygate4sd3_1
Xhold771 cpuregs\[11\]\[16\] VGND VGND VPWR VPWR net1129 sky130_fd_sc_hd__dlygate4sd3_1
Xhold760 cpuregs\[6\]\[10\] VGND VGND VPWR VPWR net1118 sky130_fd_sc_hd__dlygate4sd3_1
Xhold793 cpuregs\[6\]\[26\] VGND VGND VPWR VPWR net1151 sky130_fd_sc_hd__dlygate4sd3_1
X_11040_ _05103_ VGND VGND VPWR VPWR _00241_ sky130_fd_sc_hd__clkbuf_1
X_12991_ _03321_ _06483_ VGND VGND VPWR VPWR _06484_ sky130_fd_sc_hd__or2_1
X_14730_ _01735_ VGND VGND VPWR VPWR _01234_ sky130_fd_sc_hd__clkbuf_1
X_11942_ _05625_ _05620_ _05626_ VGND VGND VPWR VPWR _05627_ sky130_fd_sc_hd__and3b_1
X_14661_ net1115 _05188_ _01695_ VGND VGND VPWR VPWR _01699_ sky130_fd_sc_hd__mux2_1
X_11873_ count_instr\[20\] _05572_ VGND VGND VPWR VPWR _05577_ sky130_fd_sc_hd__or2_1
X_16400_ clknet_leaf_45_clk _00982_ VGND VGND VPWR VPWR net154 sky130_fd_sc_hd__dfxtp_1
X_13612_ cpuregs\[12\]\[25\] cpuregs\[13\]\[25\] cpuregs\[14\]\[25\] cpuregs\[15\]\[25\]
+ _07027_ _06392_ VGND VGND VPWR VPWR _07086_ sky130_fd_sc_hd__mux4_1
X_10824_ net775 _03603_ _04968_ VGND VGND VPWR VPWR _04973_ sky130_fd_sc_hd__mux2_1
XFILLER_0_79_391 VGND VGND VPWR VPWR sky130_fd_sc_hd__fill_1
X_14592_ _01662_ VGND VGND VPWR VPWR _01169_ sky130_fd_sc_hd__clkbuf_1
X_13543_ cpuregs\[30\]\[22\] cpuregs\[31\]\[22\] _06754_ VGND VGND VPWR VPWR _07020_
+ sky130_fd_sc_hd__mux2_1
XFILLER_0_55_715 VGND VGND VPWR VPWR sky130_fd_sc_hd__fill_1
X_16331_ clknet_leaf_3_clk net653 VGND VGND VPWR VPWR is_sll_srl_sra sky130_fd_sc_hd__dfxtp_1
XFILLER_0_137_474 VGND VGND VPWR VPWR sky130_fd_sc_hd__fill_2
XFILLER_0_125_614 VGND VGND VPWR VPWR sky130_fd_sc_hd__fill_2
X_10755_ net856 _03610_ _04929_ VGND VGND VPWR VPWR _04935_ sky130_fd_sc_hd__mux2_1
X_13474_ cpuregs\[28\]\[20\] cpuregs\[29\]\[20\] _06687_ VGND VGND VPWR VPWR _06953_
+ sky130_fd_sc_hd__mux2_1
X_10686_ cpuregs\[24\]\[30\] cpuregs\[25\]\[30\] cpuregs\[26\]\[30\] cpuregs\[27\]\[30\]
+ _04192_ _04200_ VGND VGND VPWR VPWR _04892_ sky130_fd_sc_hd__mux4_1
X_16262_ clknet_leaf_4_clk _00847_ VGND VGND VPWR VPWR instr_beq sky130_fd_sc_hd__dfxtp_1
X_12425_ _06025_ _06028_ _06030_ VGND VGND VPWR VPWR _06031_ sky130_fd_sc_hd__a21oi_1
X_15213_ _01991_ VGND VGND VPWR VPWR _01461_ sky130_fd_sc_hd__clkbuf_1
X_16193_ clknet_leaf_141_clk _00810_ VGND VGND VPWR VPWR net123 sky130_fd_sc_hd__dfxtp_2
X_12356_ _05737_ net1627 VGND VGND VPWR VPWR _05968_ sky130_fd_sc_hd__or2_1
X_15144_ net983 _03551_ _01948_ VGND VGND VPWR VPWR _01955_ sky130_fd_sc_hd__mux2_1
X_11307_ net611 _05219_ _05251_ VGND VGND VPWR VPWR _05260_ sky130_fd_sc_hd__mux2_1
XFILLER_0_77_16 VPWR VGND VPWR VGND sky130_ef_sc_hd__decap_12
XFILLER_0_50_475 VGND VGND VPWR VPWR sky130_fd_sc_hd__fill_1
XFILLER_0_22_177 VGND VGND VPWR VPWR sky130_fd_sc_hd__fill_2
X_12287_ _05878_ _05888_ _05901_ _05903_ _05887_ VGND VGND VPWR VPWR _05904_ sky130_fd_sc_hd__a221o_1
X_15075_ _01918_ VGND VGND VPWR VPWR _01396_ sky130_fd_sc_hd__clkbuf_1
X_11238_ net858 _05221_ _05203_ VGND VGND VPWR VPWR _05222_ sky130_fd_sc_hd__mux2_1
X_14026_ _07429_ VGND VGND VPWR VPWR _01121_ sky130_fd_sc_hd__clkbuf_1
X_11169_ _03490_ VGND VGND VPWR VPWR _05175_ sky130_fd_sc_hd__clkbuf_4
XFILLER_0_93_48 VGND VGND VPWR VPWR sky130_fd_sc_hd__fill_1
XFILLER_0_93_15 VGND VGND VPWR VPWR sky130_fd_sc_hd__fill_2
X_15977_ clknet_leaf_147_clk _00627_ VGND VGND VPWR VPWR count_instr\[46\] sky130_fd_sc_hd__dfxtp_1
X_14928_ _03511_ net1445 _01840_ VGND VGND VPWR VPWR _01841_ sky130_fd_sc_hd__mux2_1
X_14859_ _01792_ VGND VGND VPWR VPWR _01804_ sky130_fd_sc_hd__buf_4
X_08380_ _02653_ net227 VGND VGND VPWR VPWR _02761_ sky130_fd_sc_hd__and2b_1
XFILLER_0_9_105 VGND VGND VPWR VPWR sky130_fd_sc_hd__decap_6
XFILLER_0_133_43 VPWR VGND VPWR VGND sky130_ef_sc_hd__decap_12
XFILLER_0_92_309 VGND VGND VPWR VPWR sky130_fd_sc_hd__decap_8
XFILLER_0_58_564 VGND VGND VPWR VPWR sky130_fd_sc_hd__fill_2
XFILLER_0_9_149 VGND VGND VPWR VPWR sky130_fd_sc_hd__decap_4
XFILLER_0_85_383 VGND VGND VPWR VPWR sky130_fd_sc_hd__fill_1
X_16529_ clknet_leaf_27_clk _01106_ VGND VGND VPWR VPWR mem_rdata_q\[13\] sky130_fd_sc_hd__dfxtp_4
XFILLER_0_73_523 VGND VGND VPWR VPWR sky130_fd_sc_hd__decap_4
XFILLER_0_45_225 VGND VGND VPWR VPWR sky130_fd_sc_hd__fill_2
XFILLER_0_6_801 VGND VGND VPWR VPWR sky130_fd_sc_hd__decap_8
XFILLER_0_128_496 VGND VGND VPWR VPWR sky130_fd_sc_hd__decap_6
XFILLER_0_128_485 VGND VGND VPWR VPWR sky130_fd_sc_hd__decap_3
XFILLER_0_115_113 VGND VGND VPWR VPWR sky130_fd_sc_hd__fill_2
XFILLER_0_115_102 VGND VGND VPWR VPWR sky130_fd_sc_hd__fill_1
X_09001_ mem_rdata_q\[15\] net7 _03292_ VGND VGND VPWR VPWR _03293_ sky130_fd_sc_hd__mux2_1
XFILLER_0_5_333 VGND VGND VPWR VPWR sky130_fd_sc_hd__decap_3
XFILLER_0_130_116 VGND VGND VPWR VPWR sky130_fd_sc_hd__fill_1
XFILLER_0_5_377 VGND VGND VPWR VPWR sky130_fd_sc_hd__fill_1
X_09903_ _03823_ _04129_ _03730_ VGND VGND VPWR VPWR _04130_ sky130_fd_sc_hd__a21o_1
XFILLER_0_67_60 VGND VGND VPWR VPWR sky130_fd_sc_hd__decap_8
XFILLER_0_6_85 VGND VGND VPWR VPWR sky130_fd_sc_hd__decap_6
XTAP_350 VGND VPWR sky130_fd_sc_hd__tapvpwrvgnd_1
X_09834_ _00015_ VGND VGND VPWR VPWR _04063_ sky130_fd_sc_hd__clkbuf_8
XTAP_394 VGND VPWR sky130_fd_sc_hd__tapvpwrvgnd_1
XTAP_383 VGND VPWR sky130_fd_sc_hd__tapvpwrvgnd_1
XTAP_372 VGND VPWR sky130_fd_sc_hd__tapvpwrvgnd_1
XTAP_361 VGND VPWR sky130_fd_sc_hd__tapvpwrvgnd_1
X_09765_ _03995_ _02294_ _03715_ VGND VGND VPWR VPWR _03996_ sky130_fd_sc_hd__mux2_1
XTAP_2217 VGND VPWR sky130_fd_sc_hd__tapvpwrvgnd_1
XTAP_2206 VGND VPWR sky130_fd_sc_hd__tapvpwrvgnd_1
X_08716_ _02522_ net216 _02942_ _03031_ VGND VGND VPWR VPWR _03076_ sky130_fd_sc_hd__a31o_1
X_09696_ _03720_ _03927_ VGND VGND VPWR VPWR _03928_ sky130_fd_sc_hd__nand2_1
XTAP_2239 VGND VPWR sky130_fd_sc_hd__tapvpwrvgnd_1
XTAP_2228 VGND VPWR sky130_fd_sc_hd__tapvpwrvgnd_1
X_08647_ _02688_ _02998_ _02922_ VGND VGND VPWR VPWR _03013_ sky130_fd_sc_hd__o21a_1
XTAP_1505 VGND VPWR sky130_fd_sc_hd__tapvpwrvgnd_1
XPHY_12 VGND VGND VPWR VPWR sky130_fd_sc_hd__decap_3
XFILLER_0_139_717 VGND VGND VPWR VPWR sky130_fd_sc_hd__fill_2
XFILLER_0_95_136 VGND VGND VPWR VPWR sky130_fd_sc_hd__decap_8
XTAP_1538 VGND VPWR sky130_fd_sc_hd__tapvpwrvgnd_1
XTAP_1527 VGND VPWR sky130_fd_sc_hd__tapvpwrvgnd_1
XTAP_1516 VGND VPWR sky130_fd_sc_hd__tapvpwrvgnd_1
XPHY_23 VGND VGND VPWR VPWR sky130_fd_sc_hd__decap_3
XPHY_34 VGND VGND VPWR VPWR sky130_fd_sc_hd__decap_3
XPHY_45 VGND VGND VPWR VPWR sky130_fd_sc_hd__decap_3
XPHY_56 VGND VGND VPWR VPWR sky130_fd_sc_hd__decap_3
XFILLER_0_95_169 VGND VGND VPWR VPWR sky130_fd_sc_hd__decap_6
X_08578_ _02933_ _02939_ _02938_ VGND VGND VPWR VPWR _02950_ sky130_fd_sc_hd__a21bo_1
XTAP_1549 VGND VPWR sky130_fd_sc_hd__tapvpwrvgnd_1
XFILLER_0_49_553 VGND VGND VPWR VPWR sky130_fd_sc_hd__fill_2
XPHY_89 VGND VGND VPWR VPWR sky130_fd_sc_hd__decap_3
XPHY_67 VGND VGND VPWR VPWR sky130_fd_sc_hd__decap_3
XFILLER_0_37_726 VGND VGND VPWR VPWR sky130_fd_sc_hd__fill_2
XPHY_78 VGND VGND VPWR VPWR sky130_fd_sc_hd__decap_3
X_10540_ _04749_ _02593_ _04509_ VGND VGND VPWR VPWR _04750_ sky130_fd_sc_hd__mux2_1
XFILLER_0_107_614 VGND VGND VPWR VPWR sky130_fd_sc_hd__fill_2
XFILLER_0_107_658 VGND VGND VPWR VPWR sky130_fd_sc_hd__decap_3
X_10471_ _04668_ _04682_ _03946_ VGND VGND VPWR VPWR _04683_ sky130_fd_sc_hd__mux2_1
XFILLER_0_64_589 VGND VGND VPWR VPWR sky130_fd_sc_hd__fill_2
X_12210_ _05829_ _05831_ VGND VGND VPWR VPWR _05833_ sky130_fd_sc_hd__and2_1
XFILLER_0_51_239 VGND VGND VPWR VPWR sky130_fd_sc_hd__fill_1
XFILLER_0_103_831 VGND VGND VPWR VPWR sky130_fd_sc_hd__fill_1
X_13190_ _06638_ _06672_ _06674_ _06342_ _06676_ VGND VGND VPWR VPWR _06677_ sky130_fd_sc_hd__o311a_1
XFILLER_0_114_190 VGND VGND VPWR VPWR sky130_fd_sc_hd__decap_6
X_12141_ _02153_ _02165_ VGND VGND VPWR VPWR _05769_ sky130_fd_sc_hd__nor2_4
Xhold590 cpuregs\[7\]\[21\] VGND VGND VPWR VPWR net948 sky130_fd_sc_hd__dlygate4sd3_1
XFILLER_0_102_385 VGND VGND VPWR VPWR sky130_fd_sc_hd__decap_3
X_12072_ _05688_ _05718_ _05719_ _02142_ VGND VGND VPWR VPWR _00657_ sky130_fd_sc_hd__o211a_1
X_11023_ _05094_ VGND VGND VPWR VPWR _00233_ sky130_fd_sc_hd__clkbuf_1
X_15900_ clknet_leaf_133_clk _00550_ VGND VGND VPWR VPWR cpuregs\[17\]\[2\] sky130_fd_sc_hd__dfxtp_1
X_16880_ clknet_leaf_55_clk _01444_ VGND VGND VPWR VPWR cpuregs\[22\]\[31\] sky130_fd_sc_hd__dfxtp_1
X_15831_ clknet_leaf_44_clk _00481_ VGND VGND VPWR VPWR cpuregs\[16\]\[29\] sky130_fd_sc_hd__dfxtp_1
XFILLER_0_99_420 VGND VGND VPWR VPWR sky130_fd_sc_hd__decap_4
X_15762_ clknet_leaf_60_clk _00412_ VGND VGND VPWR VPWR cpuregs\[15\]\[24\] sky130_fd_sc_hd__dfxtp_1
X_12974_ _06341_ VGND VGND VPWR VPWR _06468_ sky130_fd_sc_hd__buf_4
XFILLER_0_99_497 VGND VGND VPWR VPWR sky130_fd_sc_hd__fill_1
Xhold1290 cpuregs\[9\]\[30\] VGND VGND VPWR VPWR net1648 sky130_fd_sc_hd__dlygate4sd3_1
XFILLER_0_87_637 VGND VGND VPWR VPWR sky130_fd_sc_hd__fill_2
XFILLER_0_59_306 VGND VGND VPWR VPWR sky130_fd_sc_hd__fill_2
X_11925_ count_instr\[35\] count_instr\[34\] _05609_ VGND VGND VPWR VPWR _05614_ sky130_fd_sc_hd__and3_1
X_14713_ _01726_ VGND VGND VPWR VPWR _01226_ sky130_fd_sc_hd__clkbuf_1
X_15693_ clknet_leaf_96_clk _00343_ VGND VGND VPWR VPWR cpuregs\[27\]\[19\] sky130_fd_sc_hd__dfxtp_1
XFILLER_0_129_249 VGND VGND VPWR VPWR sky130_fd_sc_hd__decap_3
XFILLER_0_74_309 VPWR VGND VPWR VGND sky130_ef_sc_hd__decap_12
X_11856_ _05564_ VGND VGND VPWR VPWR _00596_ sky130_fd_sc_hd__clkbuf_1
X_14644_ net1189 _05171_ _01684_ VGND VGND VPWR VPWR _01690_ sky130_fd_sc_hd__mux2_1
X_11787_ _05045_ net1231 _05505_ VGND VGND VPWR VPWR _05515_ sky130_fd_sc_hd__mux2_1
XFILLER_0_103_13 VGND VGND VPWR VPWR sky130_fd_sc_hd__fill_2
X_10807_ net703 _03552_ _04957_ VGND VGND VPWR VPWR _04964_ sky130_fd_sc_hd__mux2_1
X_14575_ _01653_ VGND VGND VPWR VPWR _01161_ sky130_fd_sc_hd__clkbuf_1
X_13526_ _06970_ _07002_ VGND VGND VPWR VPWR _07003_ sky130_fd_sc_hd__and2_1
XFILLER_0_103_57 VGND VGND VPWR VPWR sky130_fd_sc_hd__decap_4
XFILLER_0_82_342 VGND VGND VPWR VPWR sky130_fd_sc_hd__fill_2
X_10738_ net686 _03558_ _04918_ VGND VGND VPWR VPWR _04926_ sky130_fd_sc_hd__mux2_1
X_16314_ clknet_leaf_139_clk _00899_ VGND VGND VPWR VPWR decoded_rd\[2\] sky130_fd_sc_hd__dfxtp_1
XFILLER_0_6_119 VGND VGND VPWR VPWR sky130_fd_sc_hd__fill_1
XFILLER_0_27_258 VGND VGND VPWR VPWR sky130_fd_sc_hd__decap_4
X_13457_ _06866_ _06931_ _06935_ _06873_ VGND VGND VPWR VPWR _06936_ sky130_fd_sc_hd__o211a_1
X_16245_ clknet_leaf_22_clk alu_out\[18\] VGND VGND VPWR VPWR alu_out_q\[18\] sky130_fd_sc_hd__dfxtp_1
X_12408_ _06013_ _06014_ VGND VGND VPWR VPWR _06015_ sky130_fd_sc_hd__nor2_1
X_10669_ net192 _02653_ _03997_ VGND VGND VPWR VPWR _04875_ sky130_fd_sc_hd__mux2_1
XFILLER_0_88_26 VGND VGND VPWR VPWR sky130_fd_sc_hd__fill_2
X_16176_ clknet_leaf_38_clk _00794_ VGND VGND VPWR VPWR net49 sky130_fd_sc_hd__dfxtp_1
XFILLER_0_112_138 VGND VGND VPWR VPWR sky130_fd_sc_hd__fill_2
X_13388_ cpuregs\[8\]\[18\] cpuregs\[9\]\[18\] _06764_ VGND VGND VPWR VPWR _06869_
+ sky130_fd_sc_hd__mux2_1
Xoutput106 net106 VGND VGND VPWR VPWR mem_la_wdata[18] sky130_fd_sc_hd__clkbuf_4
X_12339_ _05951_ VGND VGND VPWR VPWR _05952_ sky130_fd_sc_hd__inv_2
Xoutput128 net128 VGND VGND VPWR VPWR mem_la_wdata[9] sky130_fd_sc_hd__clkbuf_4
XFILLER_0_50_294 VGND VGND VPWR VPWR sky130_fd_sc_hd__fill_2
XFILLER_0_50_272 VGND VGND VPWR VPWR sky130_fd_sc_hd__decap_4
Xoutput117 net117 VGND VGND VPWR VPWR mem_la_wdata[28] sky130_fd_sc_hd__clkbuf_4
Xoutput139 net139 VGND VGND VPWR VPWR mem_wdata[13] sky130_fd_sc_hd__clkbuf_4
X_15127_ net1576 _03497_ _01937_ VGND VGND VPWR VPWR _01946_ sky130_fd_sc_hd__mux2_1
XFILLER_0_10_158 VGND VGND VPWR VPWR sky130_fd_sc_hd__decap_4
X_15058_ _01909_ VGND VGND VPWR VPWR _01388_ sky130_fd_sc_hd__clkbuf_1
XFILLER_0_120_193 VGND VGND VPWR VPWR sky130_fd_sc_hd__decap_3
X_14009_ _03295_ VGND VGND VPWR VPWR _07420_ sky130_fd_sc_hd__buf_4
X_07880_ count_instr\[37\] _02269_ count_cycle\[5\] _02202_ _02287_ VGND VGND VPWR
+ VPWR _02288_ sky130_fd_sc_hd__a221o_1
X_09550_ _03717_ _03777_ _03781_ _03784_ VGND VGND VPWR VPWR _03785_ sky130_fd_sc_hd__a211o_1
X_09481_ _03716_ VGND VGND VPWR VPWR _00069_ sky130_fd_sc_hd__clkbuf_1
X_08501_ instr_xor instr_xori VGND VGND VPWR VPWR _02879_ sky130_fd_sc_hd__nor2_2
X_08432_ net220 VGND VGND VPWR VPWR _02813_ sky130_fd_sc_hd__inv_2
XFILLER_0_77_169 VGND VGND VPWR VPWR sky130_fd_sc_hd__decap_3
XFILLER_0_53_84 VGND VGND VPWR VPWR sky130_fd_sc_hd__decap_8
X_08363_ _02742_ _02743_ VGND VGND VPWR VPWR _02744_ sky130_fd_sc_hd__and2_2
XFILLER_0_46_523 VGND VGND VPWR VPWR sky130_fd_sc_hd__fill_2
XFILLER_0_19_737 VPWR VGND VPWR VGND sky130_ef_sc_hd__decap_12
X_08294_ net172 net247 VGND VGND VPWR VPWR _02675_ sky130_fd_sc_hd__nand2_1
XFILLER_0_18_247 VGND VGND VPWR VPWR sky130_fd_sc_hd__decap_4
XFILLER_0_128_282 VGND VGND VPWR VPWR sky130_fd_sc_hd__fill_1
XFILLER_0_103_149 VGND VGND VPWR VPWR sky130_fd_sc_hd__fill_1
X_09817_ cpuregs\[0\]\[7\] cpuregs\[1\]\[7\] _03664_ VGND VGND VPWR VPWR _04046_ sky130_fd_sc_hd__mux2_1
X_09748_ _03900_ VGND VGND VPWR VPWR _03979_ sky130_fd_sc_hd__clkbuf_8
XTAP_2014 VGND VPWR sky130_fd_sc_hd__tapvpwrvgnd_1
XTAP_2025 VGND VPWR sky130_fd_sc_hd__tapvpwrvgnd_1
XTAP_2003 VGND VPWR sky130_fd_sc_hd__tapvpwrvgnd_1
XFILLER_0_139_503 VGND VGND VPWR VPWR sky130_fd_sc_hd__fill_1
XTAP_2058 VGND VPWR sky130_fd_sc_hd__tapvpwrvgnd_1
XTAP_2047 VGND VPWR sky130_fd_sc_hd__tapvpwrvgnd_1
XTAP_2036 VGND VPWR sky130_fd_sc_hd__tapvpwrvgnd_1
X_11710_ _05474_ VGND VGND VPWR VPWR _00540_ sky130_fd_sc_hd__clkbuf_1
XTAP_1313 VGND VPWR sky130_fd_sc_hd__tapvpwrvgnd_1
XTAP_1302 VGND VPWR sky130_fd_sc_hd__tapvpwrvgnd_1
X_09679_ decoded_imm\[4\] net197 VGND VGND VPWR VPWR _03911_ sky130_fd_sc_hd__nand2_1
XTAP_2069 VGND VPWR sky130_fd_sc_hd__tapvpwrvgnd_1
XFILLER_0_96_489 VGND VGND VPWR VPWR sky130_fd_sc_hd__decap_4
XTAP_1346 VGND VPWR sky130_fd_sc_hd__tapvpwrvgnd_1
XTAP_1357 VGND VPWR sky130_fd_sc_hd__tapvpwrvgnd_1
XTAP_1335 VGND VPWR sky130_fd_sc_hd__tapvpwrvgnd_1
XTAP_1324 VGND VPWR sky130_fd_sc_hd__tapvpwrvgnd_1
XFILLER_0_56_309 VPWR VGND VPWR VGND sky130_ef_sc_hd__decap_12
X_12690_ count_cycle\[55\] _06230_ _05539_ VGND VGND VPWR VPWR _06233_ sky130_fd_sc_hd__a21oi_1
XFILLER_0_37_501 VGND VGND VPWR VPWR sky130_fd_sc_hd__decap_3
X_11641_ _05035_ net761 _05433_ VGND VGND VPWR VPWR _05438_ sky130_fd_sc_hd__mux2_1
XTAP_1379 VGND VPWR sky130_fd_sc_hd__tapvpwrvgnd_1
XTAP_1368 VGND VPWR sky130_fd_sc_hd__tapvpwrvgnd_1
X_11572_ _05401_ VGND VGND VPWR VPWR _00475_ sky130_fd_sc_hd__clkbuf_1
XFILLER_0_64_353 VGND VGND VPWR VPWR sky130_fd_sc_hd__decap_8
XFILLER_0_64_331 VGND VGND VPWR VPWR sky130_fd_sc_hd__fill_2
X_14360_ _04944_ _05373_ VGND VGND VPWR VPWR _07615_ sky130_fd_sc_hd__or2_4
XFILLER_0_135_753 VGND VGND VPWR VPWR sky130_fd_sc_hd__decap_6
X_10523_ _03878_ _04730_ _04732_ VGND VGND VPWR VPWR _04733_ sky130_fd_sc_hd__a21o_1
XFILLER_0_92_695 VGND VGND VPWR VPWR sky130_fd_sc_hd__decap_4
X_13311_ cpuregs\[30\]\[15\] cpuregs\[31\]\[15\] _06754_ VGND VGND VPWR VPWR _06795_
+ sky130_fd_sc_hd__mux2_1
Xinput19 mem_rdata[26] VGND VGND VPWR VPWR net19 sky130_fd_sc_hd__clkbuf_4
X_14291_ _07569_ _07573_ _07574_ _07575_ net1489 VGND VGND VPWR VPWR _00999_ sky130_fd_sc_hd__o32a_1
X_10454_ _04662_ _04663_ _04664_ _04665_ _03676_ _03659_ VGND VGND VPWR VPWR _04666_
+ sky130_fd_sc_hd__mux4_1
X_13242_ _06727_ VGND VGND VPWR VPWR _00819_ sky130_fd_sc_hd__clkbuf_1
X_16030_ clknet_leaf_10_clk _00680_ VGND VGND VPWR VPWR reg_next_pc\[5\] sky130_fd_sc_hd__dfxtp_1
X_10385_ _03897_ _04596_ _04598_ VGND VGND VPWR VPWR _04599_ sky130_fd_sc_hd__a21o_1
X_13173_ _06441_ _06650_ _06654_ _06660_ _06468_ VGND VGND VPWR VPWR _06661_ sky130_fd_sc_hd__a311o_1
XFILLER_0_0_807 VGND VGND VPWR VPWR sky130_fd_sc_hd__decap_4
X_12124_ _05741_ net934 _05725_ _05756_ VGND VGND VPWR VPWR _00672_ sky130_fd_sc_hd__o211a_1
X_16932_ clknet_leaf_90_clk _01496_ VGND VGND VPWR VPWR cpuregs\[0\]\[19\] sky130_fd_sc_hd__dfxtp_1
X_12055_ _03493_ reg_next_pc\[8\] _03221_ VGND VGND VPWR VPWR _05708_ sky130_fd_sc_hd__mux2_1
X_11006_ _05047_ net1308 _05051_ VGND VGND VPWR VPWR _05085_ sky130_fd_sc_hd__mux2_1
X_16863_ clknet_leaf_18_clk _01427_ VGND VGND VPWR VPWR cpuregs\[22\]\[14\] sky130_fd_sc_hd__dfxtp_1
X_15814_ clknet_leaf_136_clk _00464_ VGND VGND VPWR VPWR cpuregs\[16\]\[12\] sky130_fd_sc_hd__dfxtp_1
X_16794_ clknet_leaf_110_clk _01358_ VGND VGND VPWR VPWR cpuregs\[6\]\[9\] sky130_fd_sc_hd__dfxtp_1
X_12957_ cpuregs\[22\]\[5\] cpuregs\[23\]\[5\] _06450_ VGND VGND VPWR VPWR _06451_
+ sky130_fd_sc_hd__mux2_1
X_15745_ clknet_leaf_112_clk _00395_ VGND VGND VPWR VPWR cpuregs\[15\]\[7\] sky130_fd_sc_hd__dfxtp_1
X_12888_ _03322_ VGND VGND VPWR VPWR _06386_ sky130_fd_sc_hd__buf_6
X_11908_ count_instr\[30\] count_instr\[29\] count_instr\[28\] _05594_ VGND VGND VPWR
+ VPWR _05602_ sky130_fd_sc_hd__and4_2
X_15676_ clknet_leaf_133_clk _00326_ VGND VGND VPWR VPWR cpuregs\[27\]\[2\] sky130_fd_sc_hd__dfxtp_1
X_14627_ _01680_ VGND VGND VPWR VPWR _01186_ sky130_fd_sc_hd__clkbuf_1
X_11839_ count_instr\[11\] count_instr\[10\] _05547_ VGND VGND VPWR VPWR _05552_ sky130_fd_sc_hd__and3_1
XTAP_1891 VGND VPWR sky130_fd_sc_hd__tapvpwrvgnd_1
XTAP_1880 VGND VPWR sky130_fd_sc_hd__tapvpwrvgnd_1
XFILLER_0_67_180 VGND VGND VPWR VPWR sky130_fd_sc_hd__fill_1
XFILLER_0_7_417 VGND VGND VPWR VPWR sky130_fd_sc_hd__decap_4
XFILLER_0_23_76 VGND VGND VPWR VPWR sky130_fd_sc_hd__fill_2
X_14558_ net1005 _05221_ _01634_ VGND VGND VPWR VPWR _01644_ sky130_fd_sc_hd__mux2_1
XFILLER_0_99_25 VGND VGND VPWR VPWR sky130_fd_sc_hd__fill_2
X_14489_ _01607_ VGND VGND VPWR VPWR _01089_ sky130_fd_sc_hd__clkbuf_1
X_13509_ cpuregs\[28\]\[21\] cpuregs\[29\]\[21\] _06687_ VGND VGND VPWR VPWR _06987_
+ sky130_fd_sc_hd__mux2_1
XFILLER_0_99_69 VGND VGND VPWR VPWR sky130_fd_sc_hd__decap_4
XFILLER_0_82_194 VGND VGND VPWR VPWR sky130_fd_sc_hd__fill_2
XFILLER_0_43_559 VGND VGND VPWR VPWR sky130_fd_sc_hd__fill_1
XFILLER_0_140_233 VGND VGND VPWR VPWR sky130_fd_sc_hd__fill_1
XFILLER_0_113_447 VGND VGND VPWR VPWR sky130_fd_sc_hd__fill_1
X_16228_ clknet_leaf_15_clk alu_out\[1\] VGND VGND VPWR VPWR alu_out_q\[1\] sky130_fd_sc_hd__dfxtp_1
XFILLER_0_140_244 VGND VGND VPWR VPWR sky130_fd_sc_hd__decap_8
X_16159_ clknet_leaf_43_clk _00777_ VGND VGND VPWR VPWR net62 sky130_fd_sc_hd__dfxtp_2
XFILLER_0_70_389 VGND VGND VPWR VPWR sky130_fd_sc_hd__decap_8
XFILLER_0_100_119 VPWR VGND VPWR VGND sky130_ef_sc_hd__decap_12
X_08981_ reg_out\[26\] reg_next_pc\[26\] _03270_ VGND VGND VPWR VPWR _03279_ sky130_fd_sc_hd__mux2_1
X_07932_ _02224_ _02187_ net17 net31 _02210_ VGND VGND VPWR VPWR _02337_ sky130_fd_sc_hd__a32o_1
X_07863_ count_instr\[36\] _02269_ count_cycle\[4\] _02202_ _02271_ VGND VGND VPWR
+ VPWR _02272_ sky130_fd_sc_hd__a221o_1
X_09602_ cpuregs\[30\]\[2\] cpuregs\[31\]\[2\] _03835_ VGND VGND VPWR VPWR _03836_
+ sky130_fd_sc_hd__mux2_1
X_07794_ _02134_ VGND VGND VPWR VPWR _02208_ sky130_fd_sc_hd__inv_2
X_09533_ _03767_ VGND VGND VPWR VPWR _03768_ sky130_fd_sc_hd__buf_8
XFILLER_0_66_618 VGND VGND VPWR VPWR sky130_fd_sc_hd__fill_1
X_09464_ _03677_ _03699_ _03660_ VGND VGND VPWR VPWR _03700_ sky130_fd_sc_hd__o21ai_1
X_09395_ _03631_ _03632_ _03449_ _03633_ VGND VGND VPWR VPWR _03634_ sky130_fd_sc_hd__a2bb2o_2
X_08415_ net202 net248 VGND VGND VPWR VPWR _02796_ sky130_fd_sc_hd__and2b_1
XFILLER_0_19_501 VGND VGND VPWR VPWR sky130_fd_sc_hd__decap_3
X_08346_ _02725_ _02726_ VGND VGND VPWR VPWR _02727_ sky130_fd_sc_hd__and2_1
XFILLER_0_80_82 VGND VGND VPWR VPWR sky130_fd_sc_hd__fill_2
XFILLER_0_117_764 VGND VGND VPWR VPWR sky130_fd_sc_hd__decap_4
X_08277_ _02508_ _02653_ _02284_ _02656_ _02658_ VGND VGND VPWR VPWR _02659_ sky130_fd_sc_hd__a221o_1
XFILLER_0_131_266 VGND VGND VPWR VPWR sky130_fd_sc_hd__fill_2
XFILLER_0_61_389 VGND VGND VPWR VPWR sky130_fd_sc_hd__decap_3
X_10170_ _03897_ _04387_ _04389_ VGND VGND VPWR VPWR _04390_ sky130_fd_sc_hd__a21o_1
X_13860_ net417 _03291_ _07315_ VGND VGND VPWR VPWR _07316_ sky130_fd_sc_hd__o21ai_2
XFILLER_0_97_732 VGND VGND VPWR VPWR sky130_fd_sc_hd__fill_1
X_13791_ _07259_ VGND VGND VPWR VPWR _00836_ sky130_fd_sc_hd__clkbuf_1
X_12811_ _06320_ VGND VGND VPWR VPWR _00795_ sky130_fd_sc_hd__clkbuf_1
X_15530_ clknet_leaf_87_clk _00180_ VGND VGND VPWR VPWR cpuregs\[13\]\[16\] sky130_fd_sc_hd__dfxtp_1
X_12742_ cpuregs\[24\]\[31\] cpuregs\[25\]\[31\] cpuregs\[26\]\[31\] cpuregs\[27\]\[31\]
+ _03875_ _03726_ VGND VGND VPWR VPWR _06276_ sky130_fd_sc_hd__mux4_1
XTAP_1132 VGND VPWR sky130_fd_sc_hd__tapvpwrvgnd_1
XTAP_1121 VGND VPWR sky130_fd_sc_hd__tapvpwrvgnd_1
XTAP_1110 VGND VPWR sky130_fd_sc_hd__tapvpwrvgnd_1
XTAP_1165 VGND VPWR sky130_fd_sc_hd__tapvpwrvgnd_1
X_15461_ clknet_leaf_99_clk _00111_ VGND VGND VPWR VPWR cpuregs\[12\]\[11\] sky130_fd_sc_hd__dfxtp_1
XTAP_1154 VGND VPWR sky130_fd_sc_hd__tapvpwrvgnd_1
XTAP_1143 VGND VPWR sky130_fd_sc_hd__tapvpwrvgnd_1
XFILLER_0_56_106 VGND VGND VPWR VPWR sky130_fd_sc_hd__fill_1
X_12673_ _06219_ _06179_ _06220_ VGND VGND VPWR VPWR _06221_ sky130_fd_sc_hd__and3b_1
X_14412_ _05035_ net929 _01562_ VGND VGND VPWR VPWR _01567_ sky130_fd_sc_hd__mux2_1
X_11624_ _05018_ net1313 _05422_ VGND VGND VPWR VPWR _05429_ sky130_fd_sc_hd__mux2_1
XTAP_1198 VGND VPWR sky130_fd_sc_hd__tapvpwrvgnd_1
XTAP_1187 VGND VPWR sky130_fd_sc_hd__tapvpwrvgnd_1
XTAP_1176 VGND VPWR sky130_fd_sc_hd__tapvpwrvgnd_1
X_15392_ clknet_leaf_108_clk _00047_ VGND VGND VPWR VPWR cpuregs\[11\]\[10\] sky130_fd_sc_hd__dfxtp_1
XFILLER_0_25_515 VGND VGND VPWR VPWR sky130_fd_sc_hd__decap_6
XFILLER_0_135_561 VGND VGND VPWR VPWR sky130_fd_sc_hd__fill_2
X_11555_ _05392_ VGND VGND VPWR VPWR _00467_ sky130_fd_sc_hd__clkbuf_1
XFILLER_0_64_194 VGND VGND VPWR VPWR sky130_fd_sc_hd__fill_2
X_14343_ net1614 _07459_ _07604_ VGND VGND VPWR VPWR _01022_ sky130_fd_sc_hd__o21a_1
XFILLER_0_122_211 VGND VGND VPWR VPWR sky130_fd_sc_hd__fill_2
X_10506_ _03959_ _04703_ _04716_ _03992_ reg_pc\[25\] VGND VGND VPWR VPWR _04717_
+ sky130_fd_sc_hd__a32o_1
XFILLER_0_108_797 VGND VGND VPWR VPWR sky130_fd_sc_hd__fill_1
X_11486_ _05355_ VGND VGND VPWR VPWR _00435_ sky130_fd_sc_hd__clkbuf_1
XFILLER_0_69_28 VGND VGND VPWR VPWR sky130_fd_sc_hd__decap_3
XFILLER_0_69_17 VGND VGND VPWR VPWR sky130_fd_sc_hd__fill_2
X_14274_ _06372_ decoded_imm_j\[11\] is_slli_srli_srai VGND VGND VPWR VPWR _07562_
+ sky130_fd_sc_hd__mux2_1
X_16013_ clknet_leaf_33_clk _00663_ VGND VGND VPWR VPWR reg_pc\[19\] sky130_fd_sc_hd__dfxtp_2
X_10437_ cpuregs\[10\]\[24\] cpuregs\[11\]\[24\] _04058_ VGND VGND VPWR VPWR _04649_
+ sky130_fd_sc_hd__mux2_1
XFILLER_0_69_39 VGND VGND VPWR VPWR sky130_fd_sc_hd__fill_1
X_13225_ _06638_ _06705_ _06707_ _06342_ _06710_ VGND VGND VPWR VPWR _06711_ sky130_fd_sc_hd__o311a_1
XFILLER_0_0_615 VGND VGND VPWR VPWR sky130_fd_sc_hd__fill_1
X_10368_ _04580_ _04581_ VGND VGND VPWR VPWR _04582_ sky130_fd_sc_hd__nand2_1
X_13156_ cpuregs\[0\]\[11\] cpuregs\[1\]\[11\] cpuregs\[2\]\[11\] cpuregs\[3\]\[11\]
+ _06364_ _03400_ VGND VGND VPWR VPWR _06644_ sky130_fd_sc_hd__mux4_1
XTAP_905 VGND VPWR sky130_fd_sc_hd__tapvpwrvgnd_1
XTAP_916 VGND VPWR sky130_fd_sc_hd__tapvpwrvgnd_1
X_12107_ _03595_ reg_next_pc\[23\] _03223_ VGND VGND VPWR VPWR _05745_ sky130_fd_sc_hd__mux2_1
X_10299_ _04511_ _04514_ VGND VGND VPWR VPWR _04515_ sky130_fd_sc_hd__or2_1
XTAP_949 VGND VPWR sky130_fd_sc_hd__tapvpwrvgnd_1
XTAP_938 VGND VPWR sky130_fd_sc_hd__tapvpwrvgnd_1
X_13087_ _06431_ _06576_ VGND VGND VPWR VPWR _06577_ sky130_fd_sc_hd__and2_1
XTAP_927 VGND VPWR sky130_fd_sc_hd__tapvpwrvgnd_1
X_12038_ _05695_ VGND VGND VPWR VPWR _05696_ sky130_fd_sc_hd__clkbuf_4
X_16915_ clknet_leaf_101_clk _01479_ VGND VGND VPWR VPWR cpuregs\[0\]\[2\] sky130_fd_sc_hd__dfxtp_1
X_16846_ clknet_leaf_70_clk _01410_ VGND VGND VPWR VPWR cpuregs\[7\]\[29\] sky130_fd_sc_hd__dfxtp_1
X_16777_ clknet_leaf_92_clk _01341_ VGND VGND VPWR VPWR cpuregs\[5\]\[24\] sky130_fd_sc_hd__dfxtp_1
X_13989_ _02141_ _07405_ VGND VGND VPWR VPWR _07406_ sky130_fd_sc_hd__and2_1
X_15728_ clknet_leaf_48_clk _00378_ VGND VGND VPWR VPWR cpuregs\[21\]\[22\] sky130_fd_sc_hd__dfxtp_1
XFILLER_0_87_264 VGND VGND VPWR VPWR sky130_fd_sc_hd__fill_1
XFILLER_0_87_297 VGND VGND VPWR VPWR sky130_fd_sc_hd__decap_4
X_08200_ _02585_ _02586_ VGND VGND VPWR VPWR _02587_ sky130_fd_sc_hd__nand2_1
X_15659_ clknet_leaf_89_clk _00309_ VGND VGND VPWR VPWR cpuregs\[14\]\[17\] sky130_fd_sc_hd__dfxtp_1
XFILLER_0_44_802 VGND VGND VPWR VPWR sky130_fd_sc_hd__fill_1
X_09180_ _03447_ VGND VGND VPWR VPWR _00037_ sky130_fd_sc_hd__clkbuf_1
XFILLER_0_16_504 VGND VGND VPWR VPWR sky130_fd_sc_hd__decap_4
X_08131_ net14 _02466_ _02429_ VGND VGND VPWR VPWR _02523_ sky130_fd_sc_hd__a21oi_1
XFILLER_0_114_745 VGND VGND VPWR VPWR sky130_fd_sc_hd__fill_2
X_08062_ count_cycle\[17\] _02454_ _02455_ _02457_ VGND VGND VPWR VPWR _02458_ sky130_fd_sc_hd__a211o_2
Xpicorv32_320 VGND VGND VPWR VPWR picorv32_320/HI pcpi_insn[31] sky130_fd_sc_hd__conb_1
XFILLER_0_113_233 VGND VGND VPWR VPWR sky130_fd_sc_hd__fill_1
Xpicorv32_353 VGND VGND VPWR VPWR picorv32_353/HI trace_data[31] sky130_fd_sc_hd__conb_1
Xpicorv32_342 VGND VGND VPWR VPWR picorv32_342/HI trace_data[20] sky130_fd_sc_hd__conb_1
Xpicorv32_331 VGND VGND VPWR VPWR picorv32_331/HI trace_data[9] sky130_fd_sc_hd__conb_1
XFILLER_0_59_72 VGND VGND VPWR VPWR sky130_fd_sc_hd__decap_4
X_08964_ reg_out\[21\] reg_next_pc\[21\] _03248_ VGND VGND VPWR VPWR _03267_ sky130_fd_sc_hd__mux2_1
XFILLER_0_52_3 VGND VGND VPWR VPWR sky130_fd_sc_hd__fill_2
X_07915_ _02319_ _02320_ VGND VGND VPWR VPWR _02321_ sky130_fd_sc_hd__or2b_1
X_08895_ net223 _02448_ _03209_ VGND VGND VPWR VPWR net117 sky130_fd_sc_hd__a21o_4
XFILLER_0_98_518 VGND VGND VPWR VPWR sky130_fd_sc_hd__fill_1
X_07846_ reg_pc\[1\] decoded_imm\[1\] decoded_imm\[2\] reg_pc\[2\] VGND VGND VPWR
+ VPWR _02256_ sky130_fd_sc_hd__a22o_1
XFILLER_0_79_721 VGND VGND VPWR VPWR sky130_fd_sc_hd__decap_6
X_07777_ _02186_ _02192_ VGND VGND VPWR VPWR _00022_ sky130_fd_sc_hd__nor2_1
X_09516_ _03750_ VGND VGND VPWR VPWR _03751_ sky130_fd_sc_hd__buf_8
XFILLER_0_78_253 VGND VGND VPWR VPWR sky130_fd_sc_hd__fill_2
XPHY_215 VGND VGND VPWR VPWR sky130_fd_sc_hd__decap_3
XPHY_204 VGND VGND VPWR VPWR sky130_fd_sc_hd__decap_3
X_09447_ _03662_ _03682_ VGND VGND VPWR VPWR _03683_ sky130_fd_sc_hd__or2_1
XPHY_259 VGND VGND VPWR VPWR sky130_fd_sc_hd__decap_3
XPHY_248 VGND VGND VPWR VPWR sky130_fd_sc_hd__decap_3
XPHY_237 VGND VGND VPWR VPWR sky130_fd_sc_hd__decap_3
XPHY_226 VGND VGND VPWR VPWR sky130_fd_sc_hd__decap_3
XFILLER_0_94_757 VGND VGND VPWR VPWR sky130_fd_sc_hd__fill_1
XFILLER_0_93_245 VGND VGND VPWR VPWR sky130_fd_sc_hd__fill_1
X_09378_ reg_pc\[27\] _03612_ VGND VGND VPWR VPWR _03619_ sky130_fd_sc_hd__nand2_1
XFILLER_0_93_278 VGND VGND VPWR VPWR sky130_fd_sc_hd__fill_2
XFILLER_0_19_353 VGND VGND VPWR VPWR sky130_fd_sc_hd__decap_4
XFILLER_0_124_509 VGND VGND VPWR VPWR sky130_fd_sc_hd__decap_6
X_08329_ _02703_ _02706_ _02709_ VGND VGND VPWR VPWR _02710_ sky130_fd_sc_hd__or3b_1
XFILLER_0_19_397 VGND VGND VPWR VPWR sky130_fd_sc_hd__fill_1
X_11340_ _05278_ VGND VGND VPWR VPWR _00366_ sky130_fd_sc_hd__clkbuf_1
XFILLER_0_15_570 VGND VGND VPWR VPWR sky130_fd_sc_hd__decap_6
X_11271_ _05241_ VGND VGND VPWR VPWR _00334_ sky130_fd_sc_hd__clkbuf_1
X_13010_ cpuregs\[12\]\[7\] cpuregs\[13\]\[7\] cpuregs\[14\]\[7\] cpuregs\[15\]\[7\]
+ _06418_ _06419_ VGND VGND VPWR VPWR _06502_ sky130_fd_sc_hd__mux4_1
X_10222_ decoded_imm\[18\] net180 VGND VGND VPWR VPWR _04440_ sky130_fd_sc_hd__nand2_1
X_10153_ _04371_ _04372_ VGND VGND VPWR VPWR _04373_ sky130_fd_sc_hd__and2_1
XFILLER_0_100_483 VGND VGND VPWR VPWR sky130_fd_sc_hd__fill_2
X_14961_ _03616_ net1262 _01851_ VGND VGND VPWR VPWR _01858_ sky130_fd_sc_hd__mux2_1
X_16700_ clknet_leaf_87_clk _01267_ VGND VGND VPWR VPWR cpuregs\[3\]\[14\] sky130_fd_sc_hd__dfxtp_1
X_10084_ _03901_ _04305_ _03870_ VGND VGND VPWR VPWR _04306_ sky130_fd_sc_hd__a21o_1
X_14892_ _01821_ VGND VGND VPWR VPWR _01310_ sky130_fd_sc_hd__clkbuf_1
X_13912_ _07355_ VGND VGND VPWR VPWR _01107_ sky130_fd_sc_hd__buf_1
X_13843_ _03294_ _02101_ VGND VGND VPWR VPWR _07305_ sky130_fd_sc_hd__or2_1
X_16631_ clknet_leaf_134_clk _01198_ VGND VGND VPWR VPWR cpuregs\[23\]\[9\] sky130_fd_sc_hd__dfxtp_1
XFILLER_0_71_18 VGND VGND VPWR VPWR sky130_fd_sc_hd__fill_2
X_16562_ clknet_leaf_136_clk _01139_ VGND VGND VPWR VPWR cpuregs\[24\]\[14\] sky130_fd_sc_hd__dfxtp_1
X_10986_ _05026_ net833 _05074_ VGND VGND VPWR VPWR _05075_ sky130_fd_sc_hd__mux2_1
X_13774_ _06969_ _07238_ _07240_ _03309_ _07242_ VGND VGND VPWR VPWR _07243_ sky130_fd_sc_hd__o311a_1
X_15513_ clknet_leaf_99_clk _00163_ VGND VGND VPWR VPWR cpuregs\[30\]\[31\] sky130_fd_sc_hd__dfxtp_1
X_12725_ cpuregs\[12\]\[31\] cpuregs\[13\]\[31\] _03749_ VGND VGND VPWR VPWR _06259_
+ sky130_fd_sc_hd__mux2_1
X_16493_ clknet_leaf_18_clk _01075_ VGND VGND VPWR VPWR cpuregs\[19\]\[14\] sky130_fd_sc_hd__dfxtp_1
X_15444_ clknet_leaf_42_clk _00094_ VGND VGND VPWR VPWR net188 sky130_fd_sc_hd__dfxtp_4
X_12656_ count_cycle\[46\] _06204_ VGND VGND VPWR VPWR _06208_ sky130_fd_sc_hd__or2_1
XFILLER_0_25_301 VGND VGND VPWR VPWR sky130_fd_sc_hd__decap_8
XFILLER_0_38_662 VGND VGND VPWR VPWR sky130_fd_sc_hd__fill_1
X_15375_ _03646_ net1452 _02040_ VGND VGND VPWR VPWR _02075_ sky130_fd_sc_hd__mux2_1
XFILLER_0_5_729 VPWR VGND VPWR VGND sky130_ef_sc_hd__decap_12
X_11607_ _05001_ net1271 _05411_ VGND VGND VPWR VPWR _05420_ sky130_fd_sc_hd__mux2_1
X_12587_ count_cycle\[26\] _06156_ VGND VGND VPWR VPWR _06159_ sky130_fd_sc_hd__or2_1
XFILLER_0_123_520 VGND VGND VPWR VPWR sky130_fd_sc_hd__fill_1
X_14326_ net1617 _07587_ _07590_ _07595_ VGND VGND VPWR VPWR _01014_ sky130_fd_sc_hd__o22a_1
XFILLER_0_111_68 VGND VGND VPWR VPWR sky130_fd_sc_hd__fill_1
XFILLER_0_111_57 VGND VGND VPWR VPWR sky130_fd_sc_hd__fill_1
Xhold408 cpuregs\[26\]\[16\] VGND VGND VPWR VPWR net766 sky130_fd_sc_hd__dlygate4sd3_1
X_11538_ _05383_ VGND VGND VPWR VPWR _00459_ sky130_fd_sc_hd__clkbuf_1
XFILLER_0_40_315 VGND VGND VPWR VPWR sky130_fd_sc_hd__fill_1
XFILLER_0_123_586 VGND VGND VPWR VPWR sky130_fd_sc_hd__decap_3
Xhold419 cpuregs\[20\]\[29\] VGND VGND VPWR VPWR net777 sky130_fd_sc_hd__dlygate4sd3_1
X_14257_ _02115_ net130 _02113_ VGND VGND VPWR VPWR _07554_ sky130_fd_sc_hd__o21a_1
X_11469_ _05346_ VGND VGND VPWR VPWR _00427_ sky130_fd_sc_hd__clkbuf_1
X_13208_ _06694_ _02685_ _06629_ VGND VGND VPWR VPWR _06695_ sky130_fd_sc_hd__mux2_1
X_14188_ _07517_ VGND VGND VPWR VPWR _00954_ sky130_fd_sc_hd__clkbuf_1
XFILLER_0_21_551 VGND VGND VPWR VPWR sky130_fd_sc_hd__fill_1
X_13139_ _06416_ _06613_ _06627_ _06470_ decoded_imm\[10\] VGND VGND VPWR VPWR _06628_
+ sky130_fd_sc_hd__a32o_1
XFILLER_0_0_489 VGND VGND VPWR VPWR sky130_fd_sc_hd__fill_1
XTAP_702 VGND VPWR sky130_fd_sc_hd__tapvpwrvgnd_1
XTAP_713 VGND VPWR sky130_fd_sc_hd__tapvpwrvgnd_1
XTAP_724 VGND VPWR sky130_fd_sc_hd__tapvpwrvgnd_1
XTAP_735 VGND VPWR sky130_fd_sc_hd__tapvpwrvgnd_1
XTAP_746 VGND VPWR sky130_fd_sc_hd__tapvpwrvgnd_1
XTAP_757 VGND VPWR sky130_fd_sc_hd__tapvpwrvgnd_1
XTAP_768 VGND VPWR sky130_fd_sc_hd__tapvpwrvgnd_1
Xhold1119 cpuregs\[21\]\[15\] VGND VGND VPWR VPWR net1477 sky130_fd_sc_hd__dlygate4sd3_1
Xhold1108 cpuregs\[26\]\[6\] VGND VGND VPWR VPWR net1466 sky130_fd_sc_hd__dlygate4sd3_1
X_07700_ instr_rdcycleh instr_rdinstr instr_rdinstrh VGND VGND VPWR VPWR _02126_ sky130_fd_sc_hd__or3_2
XTAP_779 VGND VPWR sky130_fd_sc_hd__tapvpwrvgnd_1
X_08680_ net246 _03042_ VGND VGND VPWR VPWR _03043_ sky130_fd_sc_hd__xnor2_1
X_16829_ clknet_leaf_108_clk _01393_ VGND VGND VPWR VPWR cpuregs\[7\]\[12\] sky130_fd_sc_hd__dfxtp_1
XFILLER_0_24_7 VGND VGND VPWR VPWR sky130_fd_sc_hd__decap_4
X_09301_ net1129 _03552_ _03512_ VGND VGND VPWR VPWR _03553_ sky130_fd_sc_hd__mux2_1
XFILLER_0_0_21 VGND VGND VPWR VPWR sky130_fd_sc_hd__fill_1
XFILLER_0_75_245 VGND VGND VPWR VPWR sky130_fd_sc_hd__fill_1
XFILLER_0_61_51 VGND VGND VPWR VPWR sky130_fd_sc_hd__fill_1
XFILLER_0_48_448 VGND VGND VPWR VPWR sky130_fd_sc_hd__decap_6
Xclkbuf_leaf_154_clk clknet_4_0_0_clk VGND VGND VPWR VPWR clknet_leaf_154_clk sky130_fd_sc_hd__clkbuf_16
XFILLER_0_0_98 VGND VGND VPWR VPWR sky130_fd_sc_hd__fill_1
XFILLER_0_17_824 VGND VGND VPWR VPWR sky130_fd_sc_hd__fill_2
X_09232_ _03492_ VGND VGND VPWR VPWR _00044_ sky130_fd_sc_hd__clkbuf_1
XFILLER_0_90_237 VGND VGND VPWR VPWR sky130_fd_sc_hd__fill_1
X_09163_ _03431_ VGND VGND VPWR VPWR _00031_ sky130_fd_sc_hd__clkbuf_1
X_08114_ net13 _02448_ _02429_ VGND VGND VPWR VPWR _02507_ sky130_fd_sc_hd__a21o_1
XFILLER_0_9_30 VGND VGND VPWR VPWR sky130_fd_sc_hd__decap_6
XFILLER_0_43_131 VGND VGND VPWR VPWR sky130_fd_sc_hd__decap_6
XFILLER_0_114_531 VGND VGND VPWR VPWR sky130_fd_sc_hd__fill_1
XFILLER_0_9_96 VGND VGND VPWR VPWR sky130_fd_sc_hd__decap_4
X_09094_ cpuregs\[12\]\[3\] cpuregs\[13\]\[3\] cpuregs\[14\]\[3\] cpuregs\[15\]\[3\]
+ _03329_ _03330_ VGND VGND VPWR VPWR _03374_ sky130_fd_sc_hd__mux4_1
XFILLER_0_114_597 VGND VGND VPWR VPWR sky130_fd_sc_hd__fill_1
X_08045_ _02437_ _02438_ _02441_ VGND VGND VPWR VPWR _02442_ sky130_fd_sc_hd__and3_1
Xhold920 cpuregs\[18\]\[1\] VGND VGND VPWR VPWR net1278 sky130_fd_sc_hd__dlygate4sd3_1
Xhold931 cpuregs\[31\]\[6\] VGND VGND VPWR VPWR net1289 sky130_fd_sc_hd__dlygate4sd3_1
XFILLER_0_31_348 VGND VGND VPWR VPWR sky130_fd_sc_hd__fill_1
Xhold964 cpuregs\[5\]\[25\] VGND VGND VPWR VPWR net1322 sky130_fd_sc_hd__dlygate4sd3_1
Xhold953 cpuregs\[11\]\[23\] VGND VGND VPWR VPWR net1311 sky130_fd_sc_hd__dlygate4sd3_1
Xhold942 cpuregs\[30\]\[30\] VGND VGND VPWR VPWR net1300 sky130_fd_sc_hd__dlygate4sd3_1
Xhold986 cpuregs\[25\]\[28\] VGND VGND VPWR VPWR net1344 sky130_fd_sc_hd__dlygate4sd3_1
Xhold997 cpuregs\[13\]\[31\] VGND VGND VPWR VPWR net1355 sky130_fd_sc_hd__dlygate4sd3_1
Xhold975 cpuregs\[25\]\[0\] VGND VGND VPWR VPWR net1333 sky130_fd_sc_hd__dlygate4sd3_1
XFILLER_0_110_792 VGND VGND VPWR VPWR sky130_fd_sc_hd__fill_2
X_09996_ _03657_ _04207_ _04220_ _03776_ reg_pc\[11\] VGND VGND VPWR VPWR _04221_
+ sky130_fd_sc_hd__a32o_1
X_08947_ _02426_ _03255_ _03246_ VGND VGND VPWR VPWR _03256_ sky130_fd_sc_hd__mux2_1
X_08878_ _03214_ VGND VGND VPWR VPWR net105 sky130_fd_sc_hd__clkbuf_4
X_07829_ _02200_ _02231_ _02240_ VGND VGND VPWR VPWR _07629_ sky130_fd_sc_hd__o21a_1
XFILLER_0_98_359 VGND VGND VPWR VPWR sky130_fd_sc_hd__decap_4
X_10840_ _03439_ VGND VGND VPWR VPWR _04981_ sky130_fd_sc_hd__buf_2
XFILLER_0_79_584 VGND VGND VPWR VPWR sky130_fd_sc_hd__decap_6
XFILLER_0_66_201 VGND VGND VPWR VPWR sky130_fd_sc_hd__decap_3
Xclkbuf_leaf_145_clk clknet_4_2_0_clk VGND VGND VPWR VPWR clknet_leaf_145_clk sky130_fd_sc_hd__clkbuf_16
X_10771_ _04943_ VGND VGND VPWR VPWR _04944_ sky130_fd_sc_hd__buf_4
X_13490_ _06866_ _06963_ _06967_ _06873_ VGND VGND VPWR VPWR _06968_ sky130_fd_sc_hd__o211a_1
X_12510_ net446 _06101_ _05526_ VGND VGND VPWR VPWR _06105_ sky130_fd_sc_hd__o21ai_1
XFILLER_0_124_306 VGND VGND VPWR VPWR sky130_fd_sc_hd__fill_2
X_12441_ _06044_ _06045_ _05695_ VGND VGND VPWR VPWR _06046_ sky130_fd_sc_hd__o21ai_1
XFILLER_0_66_289 VPWR VGND VPWR VGND sky130_ef_sc_hd__decap_12
XFILLER_0_136_177 VGND VGND VPWR VPWR sky130_fd_sc_hd__decap_4
XFILLER_0_34_120 VPWR VGND VPWR VGND sky130_ef_sc_hd__decap_12
XFILLER_0_35_676 VGND VGND VPWR VPWR sky130_fd_sc_hd__fill_2
X_15160_ _01963_ VGND VGND VPWR VPWR _01436_ sky130_fd_sc_hd__clkbuf_1
X_12372_ _05981_ _05736_ VGND VGND VPWR VPWR _05982_ sky130_fd_sc_hd__xor2_1
X_15091_ net1476 _05209_ _01923_ VGND VGND VPWR VPWR _01927_ sky130_fd_sc_hd__mux2_1
X_11323_ _05269_ VGND VGND VPWR VPWR _00358_ sky130_fd_sc_hd__clkbuf_1
X_14111_ _04991_ net1105 _07471_ VGND VGND VPWR VPWR _07475_ sky130_fd_sc_hd__mux2_1
Xclkbuf_4_0_0_clk clknet_0_clk VGND VGND VPWR VPWR clknet_4_0_0_clk sky130_fd_sc_hd__clkbuf_8
XFILLER_0_34_197 VGND VGND VPWR VPWR sky130_fd_sc_hd__fill_1
X_14042_ _07437_ VGND VGND VPWR VPWR _00894_ sky130_fd_sc_hd__clkbuf_1
X_11254_ _05232_ VGND VGND VPWR VPWR _00326_ sky130_fd_sc_hd__clkbuf_1
X_10205_ cpuregs\[20\]\[17\] cpuregs\[21\]\[17\] _03664_ VGND VGND VPWR VPWR _04424_
+ sky130_fd_sc_hd__mux2_1
XFILLER_0_30_392 VGND VGND VPWR VPWR sky130_fd_sc_hd__fill_1
X_11185_ _03524_ VGND VGND VPWR VPWR _05186_ sky130_fd_sc_hd__clkbuf_4
X_10136_ _03794_ _04343_ _04356_ _03775_ reg_pc\[15\] VGND VGND VPWR VPWR _04357_
+ sky130_fd_sc_hd__a32o_1
X_15993_ clknet_leaf_2_clk _00643_ VGND VGND VPWR VPWR count_instr\[62\] sky130_fd_sc_hd__dfxtp_1
X_14944_ _03564_ net1116 _01840_ VGND VGND VPWR VPWR _01849_ sky130_fd_sc_hd__mux2_1
X_10067_ _03794_ _04276_ _04289_ _03775_ reg_pc\[13\] VGND VGND VPWR VPWR _04290_
+ sky130_fd_sc_hd__a32o_1
X_16614_ clknet_leaf_81_clk _01181_ VGND VGND VPWR VPWR cpuregs\[9\]\[24\] sky130_fd_sc_hd__dfxtp_1
X_14875_ _01812_ VGND VGND VPWR VPWR _01302_ sky130_fd_sc_hd__clkbuf_1
XFILLER_0_58_735 VGND VGND VPWR VPWR sky130_fd_sc_hd__fill_2
X_13826_ _02194_ _06330_ _07291_ _07292_ VGND VGND VPWR VPWR _07293_ sky130_fd_sc_hd__or4_1
XFILLER_0_15_33 VGND VGND VPWR VPWR sky130_fd_sc_hd__decap_3
X_13757_ _06442_ _07222_ _07226_ _06428_ VGND VGND VPWR VPWR _07227_ sky130_fd_sc_hd__o211a_1
X_16545_ clknet_leaf_27_clk _01122_ VGND VGND VPWR VPWR mem_rdata_q\[29\] sky130_fd_sc_hd__dfxtp_1
Xclkbuf_leaf_136_clk clknet_4_9_0_clk VGND VGND VPWR VPWR clknet_leaf_136_clk sky130_fd_sc_hd__clkbuf_16
XFILLER_0_57_234 VPWR VGND VPWR VGND sky130_ef_sc_hd__decap_12
X_10969_ _05010_ net1147 _05063_ VGND VGND VPWR VPWR _05066_ sky130_fd_sc_hd__mux2_1
X_16476_ clknet_leaf_43_clk _01058_ VGND VGND VPWR VPWR cpuregs\[18\]\[29\] sky130_fd_sc_hd__dfxtp_1
XFILLER_0_127_122 VGND VGND VPWR VPWR sky130_fd_sc_hd__decap_3
X_12708_ _05631_ _06245_ VGND VGND VPWR VPWR _06246_ sky130_fd_sc_hd__nor2_1
XFILLER_0_128_689 VGND VGND VPWR VPWR sky130_fd_sc_hd__fill_1
X_13688_ cpuregs\[20\]\[27\] cpuregs\[21\]\[27\] _06456_ VGND VGND VPWR VPWR _07160_
+ sky130_fd_sc_hd__mux2_1
X_15427_ clknet_leaf_17_clk _00077_ VGND VGND VPWR VPWR net201 sky130_fd_sc_hd__dfxtp_4
XFILLER_0_127_188 VGND VGND VPWR VPWR sky130_fd_sc_hd__decap_4
X_12639_ net443 _06193_ _02185_ VGND VGND VPWR VPWR _06196_ sky130_fd_sc_hd__o21ai_1
XFILLER_0_25_120 VGND VGND VPWR VPWR sky130_fd_sc_hd__fill_2
X_15358_ _02066_ VGND VGND VPWR VPWR _01531_ sky130_fd_sc_hd__clkbuf_1
XFILLER_0_81_782 VGND VGND VPWR VPWR sky130_fd_sc_hd__fill_2
XFILLER_0_130_309 VGND VGND VPWR VPWR sky130_fd_sc_hd__decap_6
Xhold216 cpuregs\[19\]\[29\] VGND VGND VPWR VPWR net574 sky130_fd_sc_hd__dlygate4sd3_1
X_15289_ net468 VGND VGND VPWR VPWR _02030_ sky130_fd_sc_hd__clkbuf_1
Xhold205 _01012_ VGND VGND VPWR VPWR net563 sky130_fd_sc_hd__dlygate4sd3_1
X_14309_ mem_rdata_q\[21\] _07576_ VGND VGND VPWR VPWR _07585_ sky130_fd_sc_hd__and2_1
XFILLER_0_40_134 VGND VGND VPWR VPWR sky130_fd_sc_hd__decap_3
XFILLER_0_41_657 VGND VGND VPWR VPWR sky130_fd_sc_hd__fill_2
Xhold249 cpuregs\[12\]\[23\] VGND VGND VPWR VPWR net607 sky130_fd_sc_hd__dlygate4sd3_1
Xhold238 cpuregs\[28\]\[26\] VGND VGND VPWR VPWR net596 sky130_fd_sc_hd__dlygate4sd3_1
Xhold227 mem_rdata_q\[10\] VGND VGND VPWR VPWR net585 sky130_fd_sc_hd__dlygate4sd3_1
XFILLER_0_111_556 VGND VGND VPWR VPWR sky130_fd_sc_hd__fill_1
XFILLER_0_40_189 VGND VGND VPWR VPWR sky130_fd_sc_hd__decap_4
X_09850_ decoded_imm\[8\] net201 VGND VGND VPWR VPWR _04078_ sky130_fd_sc_hd__or2_1
XTAP_510 VGND VPWR sky130_fd_sc_hd__tapvpwrvgnd_1
XTAP_521 VGND VPWR sky130_fd_sc_hd__tapvpwrvgnd_1
XTAP_532 VGND VPWR sky130_fd_sc_hd__tapvpwrvgnd_1
XTAP_543 VGND VPWR sky130_fd_sc_hd__tapvpwrvgnd_1
X_08801_ _02605_ net222 _02915_ _03031_ VGND VGND VPWR VPWR _03155_ sky130_fd_sc_hd__a31o_1
XTAP_554 VGND VPWR sky130_fd_sc_hd__tapvpwrvgnd_1
XTAP_565 VGND VPWR sky130_fd_sc_hd__tapvpwrvgnd_1
XTAP_576 VGND VPWR sky130_fd_sc_hd__tapvpwrvgnd_1
X_09781_ cpuregs\[8\]\[6\] cpuregs\[9\]\[6\] cpuregs\[10\]\[6\] cpuregs\[11\]\[6\]
+ _03894_ _03895_ VGND VGND VPWR VPWR _04011_ sky130_fd_sc_hd__mux4_1
X_08732_ _03068_ _03080_ VGND VGND VPWR VPWR _03091_ sky130_fd_sc_hd__nand2_1
XTAP_587 VGND VPWR sky130_fd_sc_hd__tapvpwrvgnd_1
XTAP_598 VGND VPWR sky130_fd_sc_hd__tapvpwrvgnd_1
X_08663_ _03021_ _03026_ _02867_ VGND VGND VPWR VPWR _03028_ sky130_fd_sc_hd__o21ai_1
XTAP_1709 VGND VPWR sky130_fd_sc_hd__tapvpwrvgnd_1
XFILLER_0_95_329 VGND VGND VPWR VPWR sky130_fd_sc_hd__decap_6
XFILLER_0_95_307 VGND VGND VPWR VPWR sky130_fd_sc_hd__fill_2
X_08594_ _02922_ net247 _02954_ VGND VGND VPWR VPWR _02964_ sky130_fd_sc_hd__a21o_1
XFILLER_0_72_83 VGND VGND VPWR VPWR sky130_fd_sc_hd__fill_1
XFILLER_0_48_223 VGND VGND VPWR VPWR sky130_fd_sc_hd__fill_2
XFILLER_0_48_212 VGND VGND VPWR VPWR sky130_fd_sc_hd__decap_3
Xclkbuf_leaf_127_clk clknet_4_8_0_clk VGND VGND VPWR VPWR clknet_leaf_127_clk sky130_fd_sc_hd__clkbuf_16
XFILLER_0_36_418 VGND VGND VPWR VPWR sky130_fd_sc_hd__fill_2
X_09215_ _03477_ VGND VGND VPWR VPWR _03478_ sky130_fd_sc_hd__buf_2
XFILLER_0_106_339 VGND VGND VPWR VPWR sky130_fd_sc_hd__fill_1
XFILLER_0_106_306 VGND VGND VPWR VPWR sky130_fd_sc_hd__fill_2
X_09146_ _03422_ VGND VGND VPWR VPWR _00027_ sky130_fd_sc_hd__clkbuf_1
XFILLER_0_133_169 VGND VGND VPWR VPWR sky130_fd_sc_hd__decap_3
XFILLER_0_130_810 VGND VGND VPWR VPWR sky130_fd_sc_hd__fill_2
XFILLER_0_71_281 VGND VGND VPWR VPWR sky130_fd_sc_hd__decap_4
XFILLER_0_16_197 VGND VGND VPWR VPWR sky130_fd_sc_hd__decap_4
X_09077_ _03335_ _03339_ _03350_ _03356_ _03357_ VGND VGND VPWR VPWR _03358_ sky130_fd_sc_hd__a311o_1
X_08028_ net177 VGND VGND VPWR VPWR _02426_ sky130_fd_sc_hd__clkbuf_4
Xhold761 cpuregs\[23\]\[27\] VGND VGND VPWR VPWR net1119 sky130_fd_sc_hd__dlygate4sd3_1
XFILLER_0_97_91 VGND VGND VPWR VPWR sky130_fd_sc_hd__decap_3
Xhold750 cpuregs\[27\]\[17\] VGND VGND VPWR VPWR net1108 sky130_fd_sc_hd__dlygate4sd3_1
Xhold772 cpuregs\[15\]\[31\] VGND VGND VPWR VPWR net1130 sky130_fd_sc_hd__dlygate4sd3_1
Xhold783 cpuregs\[30\]\[28\] VGND VGND VPWR VPWR net1141 sky130_fd_sc_hd__dlygate4sd3_1
Xhold794 cpuregs\[2\]\[14\] VGND VGND VPWR VPWR net1152 sky130_fd_sc_hd__dlygate4sd3_1
XFILLER_0_6_6 VGND VGND VPWR VPWR sky130_fd_sc_hd__fill_1
X_09979_ _03723_ _04203_ _03661_ VGND VGND VPWR VPWR _04204_ sky130_fd_sc_hd__a21o_1
X_12990_ cpuregs\[0\]\[6\] cpuregs\[1\]\[6\] cpuregs\[2\]\[6\] cpuregs\[3\]\[6\] _06364_
+ _03400_ VGND VGND VPWR VPWR _06483_ sky130_fd_sc_hd__mux4_1
X_11941_ count_instr\[39\] _05623_ VGND VGND VPWR VPWR _05626_ sky130_fd_sc_hd__or2_1
XFILLER_0_98_167 VGND VGND VPWR VPWR sky130_fd_sc_hd__fill_1
XFILLER_0_86_307 VGND VGND VPWR VPWR sky130_fd_sc_hd__fill_1
XFILLER_0_79_370 VGND VGND VPWR VPWR sky130_fd_sc_hd__decap_6
X_14660_ _01698_ VGND VGND VPWR VPWR _01201_ sky130_fd_sc_hd__clkbuf_1
X_11872_ _02140_ VGND VGND VPWR VPWR _05576_ sky130_fd_sc_hd__buf_2
X_10823_ _04972_ VGND VGND VPWR VPWR _00155_ sky130_fd_sc_hd__clkbuf_1
X_13611_ _07085_ VGND VGND VPWR VPWR _00830_ sky130_fd_sc_hd__clkbuf_1
X_14591_ _05010_ net1083 _01659_ VGND VGND VPWR VPWR _01662_ sky130_fd_sc_hd__mux2_1
Xclkbuf_leaf_118_clk clknet_4_10_0_clk VGND VGND VPWR VPWR clknet_leaf_118_clk sky130_fd_sc_hd__clkbuf_16
XFILLER_0_39_234 VGND VGND VPWR VPWR sky130_fd_sc_hd__decap_8
X_13542_ cpuregs\[28\]\[22\] cpuregs\[29\]\[22\] _07018_ VGND VGND VPWR VPWR _07019_
+ sky130_fd_sc_hd__mux2_1
X_16330_ clknet_leaf_2_clk _00914_ VGND VGND VPWR VPWR is_sb_sh_sw sky130_fd_sc_hd__dfxtp_1
X_10754_ _04934_ VGND VGND VPWR VPWR _00124_ sky130_fd_sc_hd__clkbuf_1
XFILLER_0_54_204 VGND VGND VPWR VPWR sky130_fd_sc_hd__decap_8
X_13473_ cpuregs\[24\]\[20\] cpuregs\[25\]\[20\] cpuregs\[26\]\[20\] cpuregs\[27\]\[20\]
+ _06856_ _06889_ VGND VGND VPWR VPWR _06952_ sky130_fd_sc_hd__mux4_1
X_10685_ cpuregs\[28\]\[30\] cpuregs\[29\]\[30\] cpuregs\[30\]\[30\] cpuregs\[31\]\[30\]
+ _03941_ _03942_ VGND VGND VPWR VPWR _04891_ sky130_fd_sc_hd__mux4_1
X_16261_ clknet_leaf_6_clk _00846_ VGND VGND VPWR VPWR instr_jal sky130_fd_sc_hd__dfxtp_4
X_12424_ _05747_ _06022_ _06029_ VGND VGND VPWR VPWR _06030_ sky130_fd_sc_hd__o21a_1
X_15212_ _03552_ net1470 _01984_ VGND VGND VPWR VPWR _01991_ sky130_fd_sc_hd__mux2_1
X_16192_ clknet_leaf_140_clk _00809_ VGND VGND VPWR VPWR net122 sky130_fd_sc_hd__dfxtp_2
XFILLER_0_105_361 VGND VGND VPWR VPWR sky130_fd_sc_hd__decap_8
X_12355_ _05832_ _05964_ _05966_ VGND VGND VPWR VPWR _05967_ sky130_fd_sc_hd__o21a_1
X_15143_ _01954_ VGND VGND VPWR VPWR _01428_ sky130_fd_sc_hd__clkbuf_1
XFILLER_0_50_421 VGND VGND VPWR VPWR sky130_fd_sc_hd__fill_1
X_11306_ _05259_ VGND VGND VPWR VPWR _00351_ sky130_fd_sc_hd__clkbuf_1
X_15074_ net1235 _05192_ _01912_ VGND VGND VPWR VPWR _01918_ sky130_fd_sc_hd__mux2_1
X_12286_ decoded_imm_j\[9\] _05710_ _05869_ _05902_ VGND VGND VPWR VPWR _05903_ sky130_fd_sc_hd__a31o_1
XFILLER_0_77_28 VGND VGND VPWR VPWR sky130_fd_sc_hd__decap_3
X_11237_ _03634_ VGND VGND VPWR VPWR _05221_ sky130_fd_sc_hd__clkbuf_4
X_14025_ mem_rdata_q\[28\] net21 _07422_ VGND VGND VPWR VPWR _07429_ sky130_fd_sc_hd__mux2_1
X_11168_ _05174_ VGND VGND VPWR VPWR _00298_ sky130_fd_sc_hd__clkbuf_1
XFILLER_0_117_12 VGND VGND VPWR VPWR sky130_fd_sc_hd__fill_2
X_10119_ _03823_ _04339_ _03730_ VGND VGND VPWR VPWR _04340_ sky130_fd_sc_hd__a21o_1
X_15976_ clknet_leaf_146_clk _00626_ VGND VGND VPWR VPWR count_instr\[45\] sky130_fd_sc_hd__dfxtp_1
X_11099_ _05134_ VGND VGND VPWR VPWR _00269_ sky130_fd_sc_hd__clkbuf_1
X_14927_ _01828_ VGND VGND VPWR VPWR _01840_ sky130_fd_sc_hd__buf_4
XFILLER_0_89_167 VGND VGND VPWR VPWR sky130_fd_sc_hd__fill_1
XFILLER_0_58_510 VGND VGND VPWR VPWR sky130_fd_sc_hd__fill_1
X_14858_ _01803_ VGND VGND VPWR VPWR _01294_ sky130_fd_sc_hd__clkbuf_1
X_13809_ cpuregs\[22\]\[31\] cpuregs\[23\]\[31\] _06386_ VGND VGND VPWR VPWR _07277_
+ sky130_fd_sc_hd__mux2_1
Xclkbuf_leaf_109_clk clknet_4_11_0_clk VGND VGND VPWR VPWR clknet_leaf_109_clk sky130_fd_sc_hd__clkbuf_16
XFILLER_0_133_55 VGND VGND VPWR VPWR sky130_fd_sc_hd__fill_1
X_16528_ clknet_leaf_27_clk _01105_ VGND VGND VPWR VPWR mem_rdata_q\[12\] sky130_fd_sc_hd__dfxtp_4
X_14789_ _01766_ VGND VGND VPWR VPWR _01262_ sky130_fd_sc_hd__clkbuf_1
XFILLER_0_128_475 VGND VGND VPWR VPWR sky130_fd_sc_hd__fill_1
X_16459_ clknet_leaf_136_clk _01041_ VGND VGND VPWR VPWR cpuregs\[18\]\[12\] sky130_fd_sc_hd__dfxtp_1
X_09000_ _03291_ VGND VGND VPWR VPWR _03292_ sky130_fd_sc_hd__buf_4
XFILLER_0_6_813 VGND VGND VPWR VPWR sky130_fd_sc_hd__fill_2
XFILLER_0_41_410 VGND VGND VPWR VPWR sky130_fd_sc_hd__fill_2
XFILLER_0_130_139 VGND VGND VPWR VPWR sky130_fd_sc_hd__fill_1
X_09902_ cpuregs\[0\]\[9\] cpuregs\[1\]\[9\] _03824_ VGND VGND VPWR VPWR _04129_ sky130_fd_sc_hd__mux2_1
XTAP_351 VGND VPWR sky130_fd_sc_hd__tapvpwrvgnd_1
XTAP_340 VGND VPWR sky130_fd_sc_hd__tapvpwrvgnd_1
X_09833_ _03984_ _04059_ _04061_ VGND VGND VPWR VPWR _04062_ sky130_fd_sc_hd__a21o_1
XTAP_384 VGND VPWR sky130_fd_sc_hd__tapvpwrvgnd_1
XTAP_373 VGND VPWR sky130_fd_sc_hd__tapvpwrvgnd_1
XTAP_362 VGND VPWR sky130_fd_sc_hd__tapvpwrvgnd_1
X_09764_ _02242_ _03952_ _03994_ VGND VGND VPWR VPWR _03995_ sky130_fd_sc_hd__a21o_1
XTAP_395 VGND VPWR sky130_fd_sc_hd__tapvpwrvgnd_1
XTAP_2207 VGND VPWR sky130_fd_sc_hd__tapvpwrvgnd_1
X_08715_ _02701_ _03062_ _03075_ _03020_ VGND VGND VPWR VPWR alu_out\[20\] sky130_fd_sc_hd__a22o_1
X_09695_ cpuregs\[22\]\[4\] cpuregs\[23\]\[4\] _03667_ VGND VGND VPWR VPWR _03927_
+ sky130_fd_sc_hd__mux2_1
Xrebuffer20 _05575_ VGND VGND VPWR VPWR net378 sky130_fd_sc_hd__clkbuf_1
XTAP_2218 VGND VPWR sky130_fd_sc_hd__tapvpwrvgnd_1
XTAP_2229 VGND VPWR sky130_fd_sc_hd__tapvpwrvgnd_1
X_08646_ _02693_ _02895_ _03011_ VGND VGND VPWR VPWR _03012_ sky130_fd_sc_hd__a21o_1
XTAP_1506 VGND VPWR sky130_fd_sc_hd__tapvpwrvgnd_1
XFILLER_0_68_307 VGND VGND VPWR VPWR sky130_fd_sc_hd__fill_1
XPHY_13 VGND VGND VPWR VPWR sky130_fd_sc_hd__decap_3
XTAP_1539 VGND VPWR sky130_fd_sc_hd__tapvpwrvgnd_1
XTAP_1528 VGND VPWR sky130_fd_sc_hd__tapvpwrvgnd_1
XTAP_1517 VGND VPWR sky130_fd_sc_hd__tapvpwrvgnd_1
XFILLER_0_49_543 VGND VGND VPWR VPWR sky130_fd_sc_hd__fill_2
XPHY_24 VGND VGND VPWR VPWR sky130_fd_sc_hd__decap_3
XPHY_35 VGND VGND VPWR VPWR sky130_fd_sc_hd__decap_3
XPHY_46 VGND VGND VPWR VPWR sky130_fd_sc_hd__decap_3
XFILLER_0_92_811 VGND VGND VPWR VPWR sky130_fd_sc_hd__fill_1
X_08577_ _02947_ _02948_ VGND VGND VPWR VPWR _02949_ sky130_fd_sc_hd__nand2_1
XPHY_57 VGND VGND VPWR VPWR sky130_fd_sc_hd__decap_3
XPHY_68 VGND VGND VPWR VPWR sky130_fd_sc_hd__decap_3
XPHY_79 VGND VGND VPWR VPWR sky130_fd_sc_hd__decap_3
XFILLER_0_119_442 VGND VGND VPWR VPWR sky130_fd_sc_hd__decap_6
XFILLER_0_91_321 VGND VGND VPWR VPWR sky130_fd_sc_hd__fill_1
XFILLER_0_107_648 VGND VGND VPWR VPWR sky130_fd_sc_hd__fill_2
X_10470_ _02081_ _04676_ _04677_ _04681_ VGND VGND VPWR VPWR _04682_ sky130_fd_sc_hd__a31o_1
XFILLER_0_45_771 VGND VGND VPWR VPWR sky130_fd_sc_hd__fill_1
XFILLER_0_115_670 VGND VGND VPWR VPWR sky130_fd_sc_hd__fill_2
X_09129_ cpuregs\[30\]\[4\] cpuregs\[31\]\[4\] _03343_ VGND VGND VPWR VPWR _03408_
+ sky130_fd_sc_hd__mux2_1
X_12140_ _05763_ net421 _05766_ _05767_ _05768_ VGND VGND VPWR VPWR _00676_ sky130_fd_sc_hd__o221a_1
XFILLER_0_20_605 VGND VGND VPWR VPWR sky130_fd_sc_hd__decap_4
X_12071_ _05690_ reg_pc\[13\] VGND VGND VPWR VPWR _05719_ sky130_fd_sc_hd__or2_1
Xhold580 cpuregs\[14\]\[8\] VGND VGND VPWR VPWR net938 sky130_fd_sc_hd__dlygate4sd3_1
Xhold591 cpuregs\[18\]\[26\] VGND VGND VPWR VPWR net949 sky130_fd_sc_hd__dlygate4sd3_1
X_11022_ net598 _03478_ _05088_ VGND VGND VPWR VPWR _05094_ sky130_fd_sc_hd__mux2_1
X_15830_ clknet_leaf_65_clk _00480_ VGND VGND VPWR VPWR cpuregs\[16\]\[28\] sky130_fd_sc_hd__dfxtp_1
X_15761_ clknet_leaf_77_clk _00411_ VGND VGND VPWR VPWR cpuregs\[15\]\[23\] sky130_fd_sc_hd__dfxtp_1
X_12973_ _06455_ _06458_ _06465_ _06466_ VGND VGND VPWR VPWR _06467_ sky130_fd_sc_hd__o211a_1
Xhold1280 cpuregs\[29\]\[27\] VGND VGND VPWR VPWR net1638 sky130_fd_sc_hd__dlygate4sd3_1
XFILLER_0_99_465 VGND VGND VPWR VPWR sky130_fd_sc_hd__fill_2
X_15692_ clknet_leaf_58_clk _00342_ VGND VGND VPWR VPWR cpuregs\[27\]\[18\] sky130_fd_sc_hd__dfxtp_1
X_11924_ _05612_ _05613_ VGND VGND VPWR VPWR _00615_ sky130_fd_sc_hd__nor2_1
X_14712_ _04995_ net1548 _01720_ VGND VGND VPWR VPWR _01726_ sky130_fd_sc_hd__mux2_1
Xhold1291 reg_sh\[4\] VGND VGND VPWR VPWR net1649 sky130_fd_sc_hd__dlygate4sd3_1
X_14643_ _01689_ VGND VGND VPWR VPWR _01193_ sky130_fd_sc_hd__clkbuf_1
X_11855_ _05562_ _05530_ _05563_ VGND VGND VPWR VPWR _05564_ sky130_fd_sc_hd__and3b_1
X_11786_ _05514_ VGND VGND VPWR VPWR _00576_ sky130_fd_sc_hd__clkbuf_1
XFILLER_0_103_25 VGND VGND VPWR VPWR sky130_fd_sc_hd__fill_2
X_10806_ _04963_ VGND VGND VPWR VPWR _00147_ sky130_fd_sc_hd__clkbuf_1
XFILLER_0_55_513 VGND VGND VPWR VPWR sky130_fd_sc_hd__fill_1
X_14574_ _04993_ net1219 _01648_ VGND VGND VPWR VPWR _01653_ sky130_fd_sc_hd__mux2_1
XFILLER_0_137_250 VGND VGND VPWR VPWR sky130_fd_sc_hd__decap_3
X_13525_ cpuregs\[4\]\[22\] cpuregs\[5\]\[22\] _06906_ VGND VGND VPWR VPWR _07002_
+ sky130_fd_sc_hd__mux2_1
X_10737_ _04925_ VGND VGND VPWR VPWR _00116_ sky130_fd_sc_hd__clkbuf_1
X_16313_ clknet_leaf_139_clk _00898_ VGND VGND VPWR VPWR decoded_rd\[1\] sky130_fd_sc_hd__dfxtp_1
X_16244_ clknet_leaf_41_clk alu_out\[17\] VGND VGND VPWR VPWR alu_out_q\[17\] sky130_fd_sc_hd__dfxtp_1
X_13456_ _06868_ _06932_ _06934_ VGND VGND VPWR VPWR _06935_ sky130_fd_sc_hd__a21o_1
XFILLER_0_82_387 VGND VGND VPWR VPWR sky130_fd_sc_hd__decap_8
XFILLER_0_82_365 VGND VGND VPWR VPWR sky130_fd_sc_hd__fill_1
X_12407_ _05981_ _05745_ VGND VGND VPWR VPWR _06014_ sky130_fd_sc_hd__nor2_1
X_10668_ _02593_ _03651_ _04787_ VGND VGND VPWR VPWR _04874_ sky130_fd_sc_hd__o21ba_1
X_10599_ cpuregs\[2\]\[28\] cpuregs\[3\]\[28\] _03755_ VGND VGND VPWR VPWR _04807_
+ sky130_fd_sc_hd__mux2_1
X_13387_ _03346_ VGND VGND VPWR VPWR _06868_ sky130_fd_sc_hd__buf_4
X_16175_ clknet_leaf_117_clk _00793_ VGND VGND VPWR VPWR net48 sky130_fd_sc_hd__dfxtp_1
XFILLER_0_2_315 VGND VGND VPWR VPWR sky130_fd_sc_hd__fill_2
Xoutput107 net107 VGND VGND VPWR VPWR mem_la_wdata[19] sky130_fd_sc_hd__clkbuf_4
Xoutput118 net118 VGND VGND VPWR VPWR mem_la_wdata[29] sky130_fd_sc_hd__clkbuf_4
X_12338_ decoded_imm_j\[17\] _05728_ VGND VGND VPWR VPWR _05951_ sky130_fd_sc_hd__xor2_1
XFILLER_0_10_115 VGND VGND VPWR VPWR sky130_fd_sc_hd__fill_2
X_15126_ _01945_ VGND VGND VPWR VPWR _01420_ sky130_fd_sc_hd__clkbuf_1
Xoutput129 net129 VGND VGND VPWR VPWR mem_la_write sky130_fd_sc_hd__clkbuf_4
X_12269_ decoded_imm_j\[12\] _05716_ VGND VGND VPWR VPWR _05887_ sky130_fd_sc_hd__and2_1
X_15057_ net1031 _05175_ _01901_ VGND VGND VPWR VPWR _01909_ sky130_fd_sc_hd__mux2_1
X_14008_ _02269_ _07382_ _07418_ _07419_ VGND VGND VPWR VPWR _00884_ sky130_fd_sc_hd__a22o_1
XFILLER_0_128_55 VGND VGND VPWR VPWR sky130_fd_sc_hd__fill_2
X_15959_ clknet_leaf_0_clk _00609_ VGND VGND VPWR VPWR count_instr\[28\] sky130_fd_sc_hd__dfxtp_1
XFILLER_0_78_627 VGND VGND VPWR VPWR sky130_fd_sc_hd__decap_3
X_08500_ _02875_ _02876_ VGND VGND VPWR VPWR _02878_ sky130_fd_sc_hd__or2_1
X_09480_ _03708_ _02132_ _03715_ VGND VGND VPWR VPWR _03716_ sky130_fd_sc_hd__mux2_1
X_08431_ net224 VGND VGND VPWR VPWR _02812_ sky130_fd_sc_hd__inv_2
X_08362_ net195 net227 VGND VGND VPWR VPWR _02743_ sky130_fd_sc_hd__or2_1
X_08293_ net172 net247 VGND VGND VPWR VPWR _02674_ sky130_fd_sc_hd__or2_1
XFILLER_0_61_505 VGND VGND VPWR VPWR sky130_fd_sc_hd__fill_1
XFILLER_0_33_207 VGND VGND VPWR VPWR sky130_fd_sc_hd__fill_1
XFILLER_0_82_3 VGND VGND VPWR VPWR sky130_fd_sc_hd__decap_6
XFILLER_0_5_153 VGND VGND VPWR VPWR sky130_fd_sc_hd__decap_3
XFILLER_0_14_432 VGND VGND VPWR VPWR sky130_fd_sc_hd__decap_4
XFILLER_0_111_161 VGND VGND VPWR VPWR sky130_fd_sc_hd__fill_2
XFILLER_0_111_194 VGND VGND VPWR VPWR sky130_fd_sc_hd__decap_4
XFILLER_0_94_81 VGND VGND VPWR VPWR sky130_fd_sc_hd__decap_3
X_09816_ _03722_ VGND VGND VPWR VPWR _04045_ sky130_fd_sc_hd__buf_4
X_09747_ cpuregs\[30\]\[5\] cpuregs\[31\]\[5\] _03977_ VGND VGND VPWR VPWR _03978_
+ sky130_fd_sc_hd__mux2_1
XTAP_2015 VGND VPWR sky130_fd_sc_hd__tapvpwrvgnd_1
XTAP_2004 VGND VPWR sky130_fd_sc_hd__tapvpwrvgnd_1
XTAP_2059 VGND VPWR sky130_fd_sc_hd__tapvpwrvgnd_1
XTAP_2048 VGND VPWR sky130_fd_sc_hd__tapvpwrvgnd_1
XTAP_2037 VGND VPWR sky130_fd_sc_hd__tapvpwrvgnd_1
XTAP_2026 VGND VPWR sky130_fd_sc_hd__tapvpwrvgnd_1
XTAP_1314 VGND VPWR sky130_fd_sc_hd__tapvpwrvgnd_1
XTAP_1303 VGND VPWR sky130_fd_sc_hd__tapvpwrvgnd_1
X_09678_ _02263_ _03715_ _03910_ VGND VGND VPWR VPWR _00072_ sky130_fd_sc_hd__a21o_1
X_08629_ _02995_ _02996_ VGND VGND VPWR VPWR _02997_ sky130_fd_sc_hd__xor2_1
XTAP_1347 VGND VPWR sky130_fd_sc_hd__tapvpwrvgnd_1
XTAP_1336 VGND VPWR sky130_fd_sc_hd__tapvpwrvgnd_1
XTAP_1325 VGND VPWR sky130_fd_sc_hd__tapvpwrvgnd_1
XFILLER_0_139_559 VGND VGND VPWR VPWR sky130_fd_sc_hd__fill_1
X_11640_ _05437_ VGND VGND VPWR VPWR _00507_ sky130_fd_sc_hd__clkbuf_1
XFILLER_0_83_107 VGND VGND VPWR VPWR sky130_fd_sc_hd__decap_4
XFILLER_0_77_671 VGND VGND VPWR VPWR sky130_fd_sc_hd__fill_1
XTAP_1369 VGND VPWR sky130_fd_sc_hd__tapvpwrvgnd_1
XTAP_1358 VGND VPWR sky130_fd_sc_hd__tapvpwrvgnd_1
X_11571_ _05033_ net1287 _05397_ VGND VGND VPWR VPWR _05401_ sky130_fd_sc_hd__mux2_1
XFILLER_0_126_209 VPWR VGND VPWR VGND sky130_ef_sc_hd__decap_12
XFILLER_0_119_250 VGND VGND VPWR VPWR sky130_fd_sc_hd__fill_2
XFILLER_0_37_546 VGND VGND VPWR VPWR sky130_fd_sc_hd__fill_2
X_10522_ _03868_ _04731_ _03870_ VGND VGND VPWR VPWR _04732_ sky130_fd_sc_hd__a21o_1
XFILLER_0_91_162 VGND VGND VPWR VPWR sky130_fd_sc_hd__decap_6
X_13310_ _03324_ VGND VGND VPWR VPWR _06794_ sky130_fd_sc_hd__buf_2
XFILLER_0_9_481 VGND VGND VPWR VPWR sky130_fd_sc_hd__fill_2
XFILLER_0_134_253 VGND VGND VPWR VPWR sky130_fd_sc_hd__decap_3
X_14290_ _07359_ VGND VGND VPWR VPWR _07575_ sky130_fd_sc_hd__clkbuf_4
XFILLER_0_17_281 VGND VGND VPWR VPWR sky130_fd_sc_hd__decap_8
X_10453_ cpuregs\[16\]\[24\] cpuregs\[17\]\[24\] cpuregs\[18\]\[24\] cpuregs\[19\]\[24\]
+ _03751_ _03929_ VGND VGND VPWR VPWR _04665_ sky130_fd_sc_hd__mux4_1
X_13241_ _06726_ net207 _06629_ VGND VGND VPWR VPWR _06727_ sky130_fd_sc_hd__mux2_1
X_10384_ _03979_ _04597_ _03731_ VGND VGND VPWR VPWR _04598_ sky130_fd_sc_hd__a21o_1
X_13172_ _06455_ _06655_ _06659_ _06466_ VGND VGND VPWR VPWR _06660_ sky130_fd_sc_hd__o211a_1
X_12123_ _05686_ _05755_ VGND VGND VPWR VPWR _05756_ sky130_fd_sc_hd__or2_1
XFILLER_0_102_161 VGND VGND VPWR VPWR sky130_fd_sc_hd__decap_4
XFILLER_0_102_172 VGND VGND VPWR VPWR sky130_fd_sc_hd__fill_1
X_16931_ clknet_leaf_84_clk _01495_ VGND VGND VPWR VPWR cpuregs\[0\]\[18\] sky130_fd_sc_hd__dfxtp_1
X_12054_ _05696_ net821 _05697_ _05707_ VGND VGND VPWR VPWR _00651_ sky130_fd_sc_hd__o211a_1
X_11005_ _05084_ VGND VGND VPWR VPWR _00225_ sky130_fd_sc_hd__clkbuf_1
XFILLER_0_74_29 VGND VGND VPWR VPWR sky130_fd_sc_hd__fill_1
X_16862_ clknet_leaf_136_clk _01426_ VGND VGND VPWR VPWR cpuregs\[22\]\[13\] sky130_fd_sc_hd__dfxtp_1
X_15813_ clknet_leaf_98_clk _00463_ VGND VGND VPWR VPWR cpuregs\[16\]\[11\] sky130_fd_sc_hd__dfxtp_1
X_16793_ clknet_leaf_113_clk _01357_ VGND VGND VPWR VPWR cpuregs\[6\]\[8\] sky130_fd_sc_hd__dfxtp_1
X_15744_ clknet_leaf_121_clk _00394_ VGND VGND VPWR VPWR cpuregs\[15\]\[6\] sky130_fd_sc_hd__dfxtp_1
X_12956_ _03342_ VGND VGND VPWR VPWR _06450_ sky130_fd_sc_hd__buf_4
X_11907_ _05601_ VGND VGND VPWR VPWR _00610_ sky130_fd_sc_hd__clkbuf_1
X_15675_ clknet_leaf_144_clk _00325_ VGND VGND VPWR VPWR cpuregs\[27\]\[1\] sky130_fd_sc_hd__dfxtp_1
X_12887_ _06382_ _06384_ VGND VGND VPWR VPWR _06385_ sky130_fd_sc_hd__or2_1
X_14626_ _05045_ net1348 _01670_ VGND VGND VPWR VPWR _01680_ sky130_fd_sc_hd__mux2_1
XTAP_1870 VGND VPWR sky130_fd_sc_hd__tapvpwrvgnd_1
XFILLER_0_56_811 VGND VGND VPWR VPWR sky130_fd_sc_hd__fill_1
X_11838_ net531 net376 _05551_ VGND VGND VPWR VPWR _00591_ sky130_fd_sc_hd__o21a_1
X_14557_ _01643_ VGND VGND VPWR VPWR _01153_ sky130_fd_sc_hd__clkbuf_1
XFILLER_0_114_79 VGND VGND VPWR VPWR sky130_fd_sc_hd__decap_4
XTAP_1892 VGND VPWR sky130_fd_sc_hd__tapvpwrvgnd_1
XTAP_1881 VGND VPWR sky130_fd_sc_hd__tapvpwrvgnd_1
XFILLER_0_23_88 VGND VGND VPWR VPWR sky130_fd_sc_hd__decap_3
X_13508_ cpuregs\[24\]\[21\] cpuregs\[25\]\[21\] cpuregs\[26\]\[21\] cpuregs\[27\]\[21\]
+ _06856_ _06889_ VGND VGND VPWR VPWR _06986_ sky130_fd_sc_hd__mux4_1
XFILLER_0_126_754 VGND VGND VPWR VPWR sky130_fd_sc_hd__fill_2
Xclkbuf_leaf_40_clk clknet_4_5_0_clk VGND VGND VPWR VPWR clknet_leaf_40_clk sky130_fd_sc_hd__clkbuf_16
X_11769_ _05026_ net802 _05505_ VGND VGND VPWR VPWR _05506_ sky130_fd_sc_hd__mux2_1
XFILLER_0_23_99 VGND VGND VPWR VPWR sky130_fd_sc_hd__decap_3
X_14488_ net1425 _05219_ _01598_ VGND VGND VPWR VPWR _01607_ sky130_fd_sc_hd__mux2_1
XFILLER_0_130_23 VGND VGND VPWR VPWR sky130_fd_sc_hd__decap_4
XFILLER_0_126_765 VGND VGND VPWR VPWR sky130_fd_sc_hd__decap_3
XFILLER_0_140_223 VGND VGND VPWR VPWR sky130_fd_sc_hd__fill_1
XFILLER_0_125_286 VGND VGND VPWR VPWR sky130_fd_sc_hd__fill_2
X_13439_ cpuregs\[22\]\[19\] cpuregs\[23\]\[19\] _06786_ VGND VGND VPWR VPWR _06919_
+ sky130_fd_sc_hd__mux2_1
X_16227_ clknet_leaf_14_clk alu_out\[0\] VGND VGND VPWR VPWR alu_out_q\[0\] sky130_fd_sc_hd__dfxtp_1
XFILLER_0_2_101 VGND VGND VPWR VPWR sky130_fd_sc_hd__fill_2
X_16158_ clknet_leaf_36_clk _00776_ VGND VGND VPWR VPWR net61 sky130_fd_sc_hd__dfxtp_1
X_15109_ _04944_ _05264_ VGND VGND VPWR VPWR _01936_ sky130_fd_sc_hd__nor2_2
X_08980_ _03278_ VGND VGND VPWR VPWR net81 sky130_fd_sc_hd__clkbuf_2
X_16089_ clknet_leaf_3_clk _00739_ VGND VGND VPWR VPWR count_cycle\[32\] sky130_fd_sc_hd__dfxtp_1
X_07931_ latched_is_lh latched_is_lb VGND VGND VPWR VPWR _02336_ sky130_fd_sc_hd__or2b_2
XFILLER_0_48_63 VGND VGND VPWR VPWR sky130_fd_sc_hd__fill_2
X_07862_ count_instr\[4\] _02270_ count_cycle\[36\] _02204_ VGND VGND VPWR VPWR _02271_
+ sky130_fd_sc_hd__a22o_1
X_09601_ _03754_ VGND VGND VPWR VPWR _03835_ sky130_fd_sc_hd__clkbuf_8
X_09532_ _00012_ VGND VGND VPWR VPWR _03767_ sky130_fd_sc_hd__clkbuf_8
X_07793_ _02160_ VGND VGND VPWR VPWR _02207_ sky130_fd_sc_hd__clkbuf_4
X_09463_ cpuregs\[4\]\[0\] cpuregs\[5\]\[0\] cpuregs\[6\]\[0\] cpuregs\[7\]\[0\] _03680_
+ _03670_ VGND VGND VPWR VPWR _03699_ sky130_fd_sc_hd__mux4_1
X_09394_ reg_out\[29\] alu_out_q\[29\] _03437_ VGND VGND VPWR VPWR _03633_ sky130_fd_sc_hd__mux2_1
X_08414_ net201 VGND VGND VPWR VPWR _02795_ sky130_fd_sc_hd__inv_2
X_08345_ net188 net220 VGND VGND VPWR VPWR _02726_ sky130_fd_sc_hd__or2_1
XFILLER_0_46_321 VGND VGND VPWR VPWR sky130_fd_sc_hd__fill_2
XFILLER_0_129_592 VGND VGND VPWR VPWR sky130_fd_sc_hd__decap_3
Xclkbuf_leaf_31_clk clknet_4_4_0_clk VGND VGND VPWR VPWR clknet_leaf_31_clk sky130_fd_sc_hd__clkbuf_16
XFILLER_0_73_151 VGND VGND VPWR VPWR sky130_fd_sc_hd__decap_3
XFILLER_0_116_253 VPWR VGND VPWR VGND sky130_ef_sc_hd__decap_12
X_08276_ _02446_ _02657_ VGND VGND VPWR VPWR _02658_ sky130_fd_sc_hd__nor2_1
XFILLER_0_73_184 VGND VGND VPWR VPWR sky130_fd_sc_hd__fill_1
XFILLER_0_116_286 VPWR VGND VPWR VGND sky130_ef_sc_hd__decap_12
XFILLER_0_131_234 VGND VGND VPWR VPWR sky130_fd_sc_hd__fill_1
XFILLER_0_14_251 VGND VGND VPWR VPWR sky130_fd_sc_hd__fill_1
XFILLER_0_14_273 VGND VGND VPWR VPWR sky130_fd_sc_hd__fill_1
XFILLER_0_30_755 VGND VGND VPWR VPWR sky130_fd_sc_hd__fill_1
XFILLER_0_30_766 VGND VGND VPWR VPWR sky130_fd_sc_hd__fill_1
XFILLER_0_100_687 VGND VGND VPWR VPWR sky130_fd_sc_hd__decap_3
Xclkbuf_leaf_98_clk clknet_4_9_0_clk VGND VGND VPWR VPWR clknet_leaf_98_clk sky130_fd_sc_hd__clkbuf_16
X_12810_ net507 net81 _06313_ VGND VGND VPWR VPWR _06320_ sky130_fd_sc_hd__mux2_1
XFILLER_0_97_744 VGND VGND VPWR VPWR sky130_fd_sc_hd__fill_2
X_13790_ _07258_ net226 _06374_ VGND VGND VPWR VPWR _07259_ sky130_fd_sc_hd__mux2_1
XFILLER_0_96_243 VGND VGND VPWR VPWR sky130_fd_sc_hd__fill_2
X_12741_ _03724_ _06272_ _06274_ _04125_ VGND VGND VPWR VPWR _06275_ sky130_fd_sc_hd__a211o_1
XTAP_1122 VGND VPWR sky130_fd_sc_hd__tapvpwrvgnd_1
XTAP_1111 VGND VPWR sky130_fd_sc_hd__tapvpwrvgnd_1
XTAP_1100 VGND VPWR sky130_fd_sc_hd__tapvpwrvgnd_1
XFILLER_0_96_298 VGND VGND VPWR VPWR sky130_fd_sc_hd__decap_8
XTAP_1155 VGND VPWR sky130_fd_sc_hd__tapvpwrvgnd_1
XTAP_1144 VGND VPWR sky130_fd_sc_hd__tapvpwrvgnd_1
XTAP_1133 VGND VPWR sky130_fd_sc_hd__tapvpwrvgnd_1
X_15460_ clknet_leaf_107_clk _00110_ VGND VGND VPWR VPWR cpuregs\[12\]\[10\] sky130_fd_sc_hd__dfxtp_1
X_12672_ count_cycle\[50\] _06218_ VGND VGND VPWR VPWR _06220_ sky130_fd_sc_hd__or2_1
X_14411_ _01566_ VGND VGND VPWR VPWR _01052_ sky130_fd_sc_hd__clkbuf_1
XFILLER_0_84_449 VGND VGND VPWR VPWR sky130_fd_sc_hd__fill_2
X_11623_ _05428_ VGND VGND VPWR VPWR _00499_ sky130_fd_sc_hd__clkbuf_1
XTAP_1199 VGND VPWR sky130_fd_sc_hd__tapvpwrvgnd_1
XTAP_1188 VGND VPWR sky130_fd_sc_hd__tapvpwrvgnd_1
XTAP_1177 VGND VPWR sky130_fd_sc_hd__tapvpwrvgnd_1
XTAP_1166 VGND VPWR sky130_fd_sc_hd__tapvpwrvgnd_1
XFILLER_0_37_332 VGND VGND VPWR VPWR sky130_fd_sc_hd__decap_4
Xclkbuf_leaf_22_clk clknet_4_4_0_clk VGND VGND VPWR VPWR clknet_leaf_22_clk sky130_fd_sc_hd__clkbuf_16
XFILLER_0_53_814 VGND VGND VPWR VPWR sky130_fd_sc_hd__fill_1
XFILLER_0_52_302 VGND VGND VPWR VPWR sky130_fd_sc_hd__decap_3
XFILLER_0_25_505 VGND VGND VPWR VPWR sky130_fd_sc_hd__fill_1
X_15391_ clknet_leaf_109_clk _00046_ VGND VGND VPWR VPWR cpuregs\[11\]\[9\] sky130_fd_sc_hd__dfxtp_1
X_11554_ _05016_ net1075 _05386_ VGND VGND VPWR VPWR _05392_ sky130_fd_sc_hd__mux2_1
X_14342_ _07320_ decoded_imm_j\[7\] _07588_ mem_rdata_q\[27\] _07357_ VGND VGND VPWR
+ VPWR _07604_ sky130_fd_sc_hd__a221o_1
XFILLER_0_25_549 VGND VGND VPWR VPWR sky130_fd_sc_hd__decap_8
X_10505_ _03817_ _04709_ _04715_ VGND VGND VPWR VPWR _04716_ sky130_fd_sc_hd__or3_2
X_11485_ net819 _05192_ _05349_ VGND VGND VPWR VPWR _05355_ sky130_fd_sc_hd__mux2_1
X_14273_ _04900_ _07560_ _07561_ net392 VGND VGND VPWR VPWR _00995_ sky130_fd_sc_hd__a22o_1
X_10436_ cpuregs\[8\]\[24\] cpuregs\[9\]\[24\] _04194_ VGND VGND VPWR VPWR _04648_
+ sky130_fd_sc_hd__mux2_1
X_16012_ clknet_leaf_30_clk _00662_ VGND VGND VPWR VPWR reg_pc\[18\] sky130_fd_sc_hd__dfxtp_2
X_13224_ _06580_ _06709_ VGND VGND VPWR VPWR _06710_ sky130_fd_sc_hd__or2_1
X_10367_ _04512_ _04516_ _04541_ _04542_ VGND VGND VPWR VPWR _04581_ sky130_fd_sc_hd__a31o_1
X_13155_ _06434_ _06642_ VGND VGND VPWR VPWR _06643_ sky130_fd_sc_hd__and2_1
XFILLER_0_20_243 VGND VGND VPWR VPWR sky130_fd_sc_hd__fill_1
XTAP_906 VGND VPWR sky130_fd_sc_hd__tapvpwrvgnd_1
XTAP_917 VGND VPWR sky130_fd_sc_hd__tapvpwrvgnd_1
X_12106_ _05741_ net575 _05725_ _05744_ VGND VGND VPWR VPWR _00666_ sky130_fd_sc_hd__o211a_1
X_10298_ _04512_ _04513_ VGND VGND VPWR VPWR _04514_ sky130_fd_sc_hd__and2_1
XTAP_939 VGND VPWR sky130_fd_sc_hd__tapvpwrvgnd_1
X_13086_ cpuregs\[4\]\[9\] cpuregs\[5\]\[9\] _06575_ VGND VGND VPWR VPWR _06576_ sky130_fd_sc_hd__mux2_1
XTAP_928 VGND VPWR sky130_fd_sc_hd__tapvpwrvgnd_1
X_12037_ _05519_ VGND VGND VPWR VPWR _05695_ sky130_fd_sc_hd__clkbuf_4
XFILLER_0_109_35 VGND VGND VPWR VPWR sky130_fd_sc_hd__decap_4
Xclkbuf_leaf_89_clk clknet_4_14_0_clk VGND VGND VPWR VPWR clknet_leaf_89_clk sky130_fd_sc_hd__clkbuf_16
X_16914_ clknet_leaf_119_clk _01478_ VGND VGND VPWR VPWR cpuregs\[0\]\[1\] sky130_fd_sc_hd__dfxtp_1
X_16845_ clknet_leaf_68_clk _01409_ VGND VGND VPWR VPWR cpuregs\[7\]\[28\] sky130_fd_sc_hd__dfxtp_1
X_16776_ clknet_leaf_76_clk _01340_ VGND VGND VPWR VPWR cpuregs\[5\]\[23\] sky130_fd_sc_hd__dfxtp_1
X_13988_ instr_and _07324_ _07350_ _07384_ VGND VGND VPWR VPWR _07405_ sky130_fd_sc_hd__a22o_1
X_15727_ clknet_leaf_62_clk _00377_ VGND VGND VPWR VPWR cpuregs\[21\]\[21\] sky130_fd_sc_hd__dfxtp_1
X_12939_ _06431_ _06432_ VGND VGND VPWR VPWR _06433_ sky130_fd_sc_hd__and2_1
XFILLER_0_140_3 VGND VGND VPWR VPWR sky130_fd_sc_hd__decap_4
XFILLER_0_87_287 VGND VGND VPWR VPWR sky130_fd_sc_hd__fill_1
X_15658_ clknet_leaf_88_clk _00308_ VGND VGND VPWR VPWR cpuregs\[14\]\[16\] sky130_fd_sc_hd__dfxtp_1
X_14609_ _01671_ VGND VGND VPWR VPWR _01177_ sky130_fd_sc_hd__clkbuf_1
XFILLER_0_28_332 VGND VGND VPWR VPWR sky130_fd_sc_hd__fill_1
X_08130_ net184 VGND VGND VPWR VPWR _02522_ sky130_fd_sc_hd__clkbuf_4
Xclkbuf_leaf_13_clk clknet_4_1_0_clk VGND VGND VPWR VPWR clknet_leaf_13_clk sky130_fd_sc_hd__clkbuf_16
X_15589_ clknet_leaf_100_clk _00239_ VGND VGND VPWR VPWR cpuregs\[28\]\[11\] sky130_fd_sc_hd__dfxtp_1
XFILLER_0_126_562 VGND VGND VPWR VPWR sky130_fd_sc_hd__decap_4
XFILLER_0_126_584 VGND VGND VPWR VPWR sky130_fd_sc_hd__decap_4
X_08061_ count_instr\[17\] _02201_ count_cycle\[49\] _02456_ VGND VGND VPWR VPWR _02457_
+ sky130_fd_sc_hd__a22o_1
XFILLER_0_113_245 VGND VGND VPWR VPWR sky130_fd_sc_hd__fill_2
Xpicorv32_310 VGND VGND VPWR VPWR picorv32_310/HI pcpi_insn[21] sky130_fd_sc_hd__conb_1
Xpicorv32_343 VGND VGND VPWR VPWR picorv32_343/HI trace_data[21] sky130_fd_sc_hd__conb_1
Xpicorv32_332 VGND VGND VPWR VPWR picorv32_332/HI trace_data[10] sky130_fd_sc_hd__conb_1
Xpicorv32_321 VGND VGND VPWR VPWR picorv32_321/HI pcpi_valid sky130_fd_sc_hd__conb_1
Xpicorv32_354 VGND VGND VPWR VPWR picorv32_354/HI trace_data[32] sky130_fd_sc_hd__conb_1
X_08963_ _03266_ VGND VGND VPWR VPWR net76 sky130_fd_sc_hd__buf_2
X_07914_ reg_pc\[7\] decoded_imm\[7\] VGND VGND VPWR VPWR _02320_ sky130_fd_sc_hd__nand2_1
X_08894_ net222 _02448_ _03208_ VGND VGND VPWR VPWR net116 sky130_fd_sc_hd__a21o_2
X_07845_ reg_pc\[3\] decoded_imm\[3\] VGND VGND VPWR VPWR _02255_ sky130_fd_sc_hd__nor2_1
X_07776_ _02174_ _02190_ _02191_ VGND VGND VPWR VPWR _02192_ sky130_fd_sc_hd__a21oi_1
X_09515_ _03749_ VGND VGND VPWR VPWR _03750_ sky130_fd_sc_hd__buf_8
XFILLER_0_137_805 VGND VGND VPWR VPWR sky130_fd_sc_hd__decap_8
XPHY_216 VGND VGND VPWR VPWR sky130_fd_sc_hd__decap_3
XPHY_205 VGND VGND VPWR VPWR sky130_fd_sc_hd__decap_3
XFILLER_0_66_427 VGND VGND VPWR VPWR sky130_fd_sc_hd__fill_1
X_09446_ cpuregs\[24\]\[0\] cpuregs\[25\]\[0\] cpuregs\[26\]\[0\] cpuregs\[27\]\[0\]
+ _03666_ _03669_ VGND VGND VPWR VPWR _03682_ sky130_fd_sc_hd__mux4_1
XPHY_249 VGND VGND VPWR VPWR sky130_fd_sc_hd__decap_3
XPHY_238 VGND VGND VPWR VPWR sky130_fd_sc_hd__decap_3
XPHY_227 VGND VGND VPWR VPWR sky130_fd_sc_hd__decap_3
XFILLER_0_38_129 VGND VGND VPWR VPWR sky130_fd_sc_hd__decap_4
X_09377_ reg_out\[27\] alu_out_q\[27\] _03437_ VGND VGND VPWR VPWR _03618_ sky130_fd_sc_hd__mux2_1
XFILLER_0_136_359 VGND VGND VPWR VPWR sky130_fd_sc_hd__fill_2
X_08328_ _02707_ _02708_ VGND VGND VPWR VPWR _02709_ sky130_fd_sc_hd__nand2_1
X_08259_ _02627_ _02629_ VGND VGND VPWR VPWR _02642_ sky130_fd_sc_hd__nand2_1
XFILLER_0_105_724 VGND VGND VPWR VPWR sky130_fd_sc_hd__decap_4
XFILLER_0_104_212 VGND VGND VPWR VPWR sky130_fd_sc_hd__decap_4
XFILLER_0_34_357 VGND VGND VPWR VPWR sky130_fd_sc_hd__fill_1
XFILLER_0_6_281 VGND VGND VPWR VPWR sky130_fd_sc_hd__decap_4
XFILLER_0_132_598 VGND VGND VPWR VPWR sky130_fd_sc_hd__fill_1
X_11270_ net651 _05181_ _05240_ VGND VGND VPWR VPWR _05241_ sky130_fd_sc_hd__mux2_1
X_10221_ decoded_imm\[18\] net180 VGND VGND VPWR VPWR _04439_ sky130_fd_sc_hd__or2_1
X_10152_ decoded_imm\[16\] net178 VGND VGND VPWR VPWR _04372_ sky130_fd_sc_hd__nand2_1
X_14960_ _01857_ VGND VGND VPWR VPWR _01342_ sky130_fd_sc_hd__clkbuf_1
X_10083_ cpuregs\[12\]\[14\] cpuregs\[13\]\[14\] _03976_ VGND VGND VPWR VPWR _04305_
+ sky130_fd_sc_hd__mux2_1
X_13911_ _07327_ net6 _03291_ VGND VGND VPWR VPWR _07355_ sky130_fd_sc_hd__mux2_1
X_14891_ _03610_ net1350 _01815_ VGND VGND VPWR VPWR _01821_ sky130_fd_sc_hd__mux2_1
XFILLER_0_89_508 VGND VGND VPWR VPWR sky130_fd_sc_hd__fill_1
X_16630_ clknet_leaf_141_clk _01197_ VGND VGND VPWR VPWR cpuregs\[23\]\[8\] sky130_fd_sc_hd__dfxtp_1
X_13842_ _07304_ VGND VGND VPWR VPWR _00843_ sky130_fd_sc_hd__clkbuf_1
X_13773_ _03318_ _07241_ VGND VGND VPWR VPWR _07242_ sky130_fd_sc_hd__or2_1
X_16561_ clknet_leaf_98_clk _01138_ VGND VGND VPWR VPWR cpuregs\[24\]\[13\] sky130_fd_sc_hd__dfxtp_1
X_10985_ _05051_ VGND VGND VPWR VPWR _05074_ sky130_fd_sc_hd__buf_4
X_15512_ clknet_leaf_58_clk _00162_ VGND VGND VPWR VPWR cpuregs\[30\]\[30\] sky130_fd_sc_hd__dfxtp_1
X_12724_ cpuregs\[14\]\[31\] cpuregs\[15\]\[31\] _04058_ VGND VGND VPWR VPWR _06258_
+ sky130_fd_sc_hd__mux2_1
XFILLER_0_29_107 VGND VGND VPWR VPWR sky130_fd_sc_hd__decap_4
X_16492_ clknet_leaf_97_clk _01074_ VGND VGND VPWR VPWR cpuregs\[19\]\[13\] sky130_fd_sc_hd__dfxtp_1
X_15443_ clknet_leaf_51_clk _00093_ VGND VGND VPWR VPWR net187 sky130_fd_sc_hd__dfxtp_4
X_12655_ count_cycle\[44\] count_cycle\[45\] count_cycle\[46\] _06200_ VGND VGND VPWR
+ VPWR _06207_ sky130_fd_sc_hd__and4_1
X_15374_ _02074_ VGND VGND VPWR VPWR _01539_ sky130_fd_sc_hd__clkbuf_1
X_12586_ _06158_ VGND VGND VPWR VPWR _00732_ sky130_fd_sc_hd__clkbuf_1
X_11606_ _05419_ VGND VGND VPWR VPWR _00491_ sky130_fd_sc_hd__clkbuf_1
XFILLER_0_108_584 VGND VGND VPWR VPWR sky130_fd_sc_hd__decap_4
X_14325_ _06025_ decoded_imm_j\[15\] _07570_ mem_rdata_q\[15\] _07388_ VGND VGND VPWR
+ VPWR _07595_ sky130_fd_sc_hd__a221o_1
X_11537_ _04999_ net1173 _05375_ VGND VGND VPWR VPWR _05383_ sky130_fd_sc_hd__mux2_1
Xhold409 cpuregs\[19\]\[15\] VGND VGND VPWR VPWR net767 sky130_fd_sc_hd__dlygate4sd3_1
XFILLER_0_80_474 VGND VGND VPWR VPWR sky130_fd_sc_hd__fill_2
XFILLER_0_80_463 VGND VGND VPWR VPWR sky130_fd_sc_hd__fill_2
X_14256_ _07553_ VGND VGND VPWR VPWR _00986_ sky130_fd_sc_hd__clkbuf_1
X_11468_ net924 _05175_ _05338_ VGND VGND VPWR VPWR _05346_ sky130_fd_sc_hd__mux2_1
X_10419_ cpuregs\[20\]\[23\] cpuregs\[21\]\[23\] _03767_ VGND VGND VPWR VPWR _04632_
+ sky130_fd_sc_hd__mux2_1
XFILLER_0_110_226 VGND VGND VPWR VPWR sky130_fd_sc_hd__fill_1
X_13207_ _06416_ _06678_ _06693_ _06470_ decoded_imm\[12\] VGND VGND VPWR VPWR _06694_
+ sky130_fd_sc_hd__a32o_1
X_14187_ mem_state\[1\] _07516_ _07514_ VGND VGND VPWR VPWR _07517_ sky130_fd_sc_hd__mux2_1
XFILLER_0_0_435 VGND VGND VPWR VPWR sky130_fd_sc_hd__fill_2
X_11399_ _05309_ VGND VGND VPWR VPWR _00394_ sky130_fd_sc_hd__clkbuf_1
X_13138_ _06441_ _06616_ _06620_ _06626_ _06468_ VGND VGND VPWR VPWR _06627_ sky130_fd_sc_hd__a311o_1
XFILLER_0_21_596 VGND VGND VPWR VPWR sky130_fd_sc_hd__decap_3
XTAP_703 VGND VPWR sky130_fd_sc_hd__tapvpwrvgnd_1
XTAP_714 VGND VPWR sky130_fd_sc_hd__tapvpwrvgnd_1
XTAP_725 VGND VPWR sky130_fd_sc_hd__tapvpwrvgnd_1
XTAP_736 VGND VPWR sky130_fd_sc_hd__tapvpwrvgnd_1
XTAP_747 VGND VPWR sky130_fd_sc_hd__tapvpwrvgnd_1
XTAP_758 VGND VPWR sky130_fd_sc_hd__tapvpwrvgnd_1
XFILLER_0_136_11 VGND VGND VPWR VPWR sky130_fd_sc_hd__fill_1
Xhold1109 cpuregs\[4\]\[4\] VGND VGND VPWR VPWR net1467 sky130_fd_sc_hd__dlygate4sd3_1
X_13069_ cpuregs\[28\]\[8\] cpuregs\[29\]\[8\] _06349_ VGND VGND VPWR VPWR _06560_
+ sky130_fd_sc_hd__mux2_1
Xclkbuf_leaf_2_clk clknet_4_0_0_clk VGND VGND VPWR VPWR clknet_leaf_2_clk sky130_fd_sc_hd__clkbuf_16
XTAP_769 VGND VPWR sky130_fd_sc_hd__tapvpwrvgnd_1
X_16828_ clknet_leaf_102_clk _01392_ VGND VGND VPWR VPWR cpuregs\[7\]\[11\] sky130_fd_sc_hd__dfxtp_1
XFILLER_0_88_585 VGND VGND VPWR VPWR sky130_fd_sc_hd__decap_3
X_09300_ _03551_ VGND VGND VPWR VPWR _03552_ sky130_fd_sc_hd__buf_2
XFILLER_0_0_11 VGND VGND VPWR VPWR sky130_fd_sc_hd__fill_1
X_16759_ clknet_leaf_116_clk _01323_ VGND VGND VPWR VPWR cpuregs\[5\]\[6\] sky130_fd_sc_hd__dfxtp_1
XFILLER_0_119_827 VGND VGND VPWR VPWR sky130_fd_sc_hd__fill_1
XFILLER_0_61_41 VGND VGND VPWR VPWR sky130_fd_sc_hd__decap_4
XFILLER_0_0_55 VGND VGND VPWR VPWR sky130_fd_sc_hd__fill_1
XFILLER_0_118_337 VGND VGND VPWR VPWR sky130_fd_sc_hd__fill_2
XFILLER_0_75_279 VGND VGND VPWR VPWR sky130_fd_sc_hd__fill_1
XFILLER_0_17_814 VGND VGND VPWR VPWR sky130_fd_sc_hd__fill_2
XFILLER_0_28_151 VGND VGND VPWR VPWR sky130_fd_sc_hd__decap_6
X_09231_ net1383 _03491_ _03446_ VGND VGND VPWR VPWR _03492_ sky130_fd_sc_hd__mux2_1
X_09162_ decoded_imm_j\[4\] _01117_ _03430_ VGND VGND VPWR VPWR _03431_ sky130_fd_sc_hd__mux2_1
XFILLER_0_28_173 VGND VGND VPWR VPWR sky130_fd_sc_hd__fill_1
XFILLER_0_114_510 VGND VGND VPWR VPWR sky130_fd_sc_hd__fill_1
X_08113_ _02147_ _02504_ _02505_ VGND VGND VPWR VPWR _02506_ sky130_fd_sc_hd__and3_1
XFILLER_0_71_463 VGND VGND VPWR VPWR sky130_fd_sc_hd__fill_1
X_09093_ _03321_ _03372_ VGND VGND VPWR VPWR _03373_ sky130_fd_sc_hd__or2_1
XFILLER_0_101_204 VPWR VGND VPWR VGND sky130_ef_sc_hd__decap_12
Xhold921 cpuregs\[18\]\[30\] VGND VGND VPWR VPWR net1279 sky130_fd_sc_hd__dlygate4sd3_1
X_08044_ _02439_ _02440_ VGND VGND VPWR VPWR _02441_ sky130_fd_sc_hd__nand2_1
Xhold910 cpuregs\[31\]\[7\] VGND VGND VPWR VPWR net1268 sky130_fd_sc_hd__dlygate4sd3_1
Xhold954 cpuregs\[1\]\[21\] VGND VGND VPWR VPWR net1312 sky130_fd_sc_hd__dlygate4sd3_1
Xhold932 cpuregs\[9\]\[23\] VGND VGND VPWR VPWR net1290 sky130_fd_sc_hd__dlygate4sd3_1
Xhold943 cpuregs\[14\]\[3\] VGND VGND VPWR VPWR net1301 sky130_fd_sc_hd__dlygate4sd3_1
Xhold965 cpuregs\[5\]\[29\] VGND VGND VPWR VPWR net1323 sky130_fd_sc_hd__dlygate4sd3_1
Xhold976 cpuregs\[16\]\[12\] VGND VGND VPWR VPWR net1334 sky130_fd_sc_hd__dlygate4sd3_1
Xhold987 cpuregs\[22\]\[0\] VGND VGND VPWR VPWR net1345 sky130_fd_sc_hd__dlygate4sd3_1
XFILLER_0_12_585 VGND VGND VPWR VPWR sky130_fd_sc_hd__decap_3
Xhold998 cpuregs\[5\]\[5\] VGND VGND VPWR VPWR net1356 sky130_fd_sc_hd__dlygate4sd3_1
X_09995_ _03688_ _04213_ _04219_ VGND VGND VPWR VPWR _04220_ sky130_fd_sc_hd__or3_2
X_08946_ reg_out\[15\] reg_next_pc\[15\] _03248_ VGND VGND VPWR VPWR _03255_ sky130_fd_sc_hd__mux2_1
X_08877_ _02748_ net211 _02447_ VGND VGND VPWR VPWR _03214_ sky130_fd_sc_hd__mux2_1
XFILLER_0_99_806 VGND VGND VPWR VPWR sky130_fd_sc_hd__fill_1
XFILLER_0_98_305 VGND VGND VPWR VPWR sky130_fd_sc_hd__decap_3
X_07828_ net415 _02232_ _02239_ VGND VGND VPWR VPWR _02240_ sky130_fd_sc_hd__a21o_1
X_07759_ _02141_ _02138_ _02177_ VGND VGND VPWR VPWR _02178_ sky130_fd_sc_hd__and3_1
XFILLER_0_66_213 VPWR VGND VPWR VGND sky130_ef_sc_hd__decap_12
X_10770_ _03442_ latched_rd\[0\] latched_rd\[1\] VGND VGND VPWR VPWR _04943_ sky130_fd_sc_hd__or3b_1
XFILLER_0_137_646 VGND VGND VPWR VPWR sky130_fd_sc_hd__fill_2
XFILLER_0_109_337 VGND VGND VPWR VPWR sky130_fd_sc_hd__fill_1
XFILLER_0_109_326 VGND VGND VPWR VPWR sky130_fd_sc_hd__fill_2
XFILLER_0_94_566 VGND VGND VPWR VPWR sky130_fd_sc_hd__fill_2
X_09429_ _03664_ VGND VGND VPWR VPWR _03665_ sky130_fd_sc_hd__clkbuf_8
XFILLER_0_125_808 VGND VGND VPWR VPWR sky130_fd_sc_hd__fill_1
X_12440_ _05773_ _06029_ _05749_ VGND VGND VPWR VPWR _06045_ sky130_fd_sc_hd__o21ba_1
XFILLER_0_34_132 VGND VGND VPWR VPWR sky130_fd_sc_hd__decap_8
XFILLER_0_133_830 VGND VGND VPWR VPWR sky130_fd_sc_hd__fill_2
X_12371_ decoded_imm_j\[20\] VGND VGND VPWR VPWR _05981_ sky130_fd_sc_hd__buf_2
XFILLER_0_23_817 VGND VGND VPWR VPWR sky130_fd_sc_hd__fill_1
X_14110_ _07474_ VGND VGND VPWR VPWR _00919_ sky130_fd_sc_hd__clkbuf_1
XFILLER_0_132_351 VGND VGND VPWR VPWR sky130_fd_sc_hd__fill_2
X_15090_ _01926_ VGND VGND VPWR VPWR _01403_ sky130_fd_sc_hd__clkbuf_1
X_11322_ _04989_ net1261 _05266_ VGND VGND VPWR VPWR _05269_ sky130_fd_sc_hd__mux2_1
XFILLER_0_120_524 VGND VGND VPWR VPWR sky130_fd_sc_hd__decap_8
X_14041_ decoded_imm_j\[14\] _01107_ _03430_ VGND VGND VPWR VPWR _07437_ sky130_fd_sc_hd__mux2_1
X_11253_ net738 _05165_ _05229_ VGND VGND VPWR VPWR _05232_ sky130_fd_sc_hd__mux2_1
X_10204_ cpuregs\[22\]\[17\] cpuregs\[23\]\[17\] _03665_ VGND VGND VPWR VPWR _04423_
+ sky130_fd_sc_hd__mux2_1
XFILLER_0_101_782 VGND VGND VPWR VPWR sky130_fd_sc_hd__fill_2
XFILLER_0_66_19 VGND VGND VPWR VPWR sky130_fd_sc_hd__fill_1
X_11184_ _05185_ VGND VGND VPWR VPWR _00303_ sky130_fd_sc_hd__clkbuf_1
X_10135_ _03817_ _04349_ _04355_ VGND VGND VPWR VPWR _04356_ sky130_fd_sc_hd__or3_1
X_15992_ clknet_leaf_2_clk _00642_ VGND VGND VPWR VPWR count_instr\[61\] sky130_fd_sc_hd__dfxtp_1
X_14943_ _01848_ VGND VGND VPWR VPWR _01334_ sky130_fd_sc_hd__clkbuf_1
X_10066_ _03817_ _04282_ _04288_ VGND VGND VPWR VPWR _04289_ sky130_fd_sc_hd__or3_1
XFILLER_0_82_29 VGND VGND VPWR VPWR sky130_fd_sc_hd__fill_1
X_14874_ _03558_ net1070 _01804_ VGND VGND VPWR VPWR _01812_ sky130_fd_sc_hd__mux2_1
X_16613_ clknet_leaf_77_clk _01180_ VGND VGND VPWR VPWR cpuregs\[9\]\[23\] sky130_fd_sc_hd__dfxtp_1
X_13825_ cpu_state\[3\] cpu_state\[1\] VGND VGND VPWR VPWR _07292_ sky130_fd_sc_hd__nor2_1
XFILLER_0_85_500 VGND VGND VPWR VPWR sky130_fd_sc_hd__fill_1
XFILLER_0_58_725 VGND VGND VPWR VPWR sky130_fd_sc_hd__fill_1
X_13756_ _06421_ _07223_ _07225_ _06343_ VGND VGND VPWR VPWR _07226_ sky130_fd_sc_hd__a211o_1
X_16544_ clknet_leaf_26_clk _01121_ VGND VGND VPWR VPWR mem_rdata_q\[28\] sky130_fd_sc_hd__dfxtp_1
X_10968_ _05065_ VGND VGND VPWR VPWR _00207_ sky130_fd_sc_hd__clkbuf_1
X_16475_ clknet_leaf_64_clk _01057_ VGND VGND VPWR VPWR cpuregs\[18\]\[28\] sky130_fd_sc_hd__dfxtp_1
X_13687_ _06382_ _07158_ VGND VGND VPWR VPWR _07159_ sky130_fd_sc_hd__or2_1
XFILLER_0_127_101 VGND VGND VPWR VPWR sky130_fd_sc_hd__fill_2
XFILLER_0_57_279 VGND VGND VPWR VPWR sky130_fd_sc_hd__fill_1
XFILLER_0_57_246 VGND VGND VPWR VPWR sky130_fd_sc_hd__decap_3
X_12707_ count_cycle\[59\] count_cycle\[60\] _06230_ _06241_ VGND VGND VPWR VPWR _06245_
+ sky130_fd_sc_hd__and4_1
X_10899_ _03563_ VGND VGND VPWR VPWR _05022_ sky130_fd_sc_hd__buf_2
X_15426_ clknet_leaf_16_clk _00076_ VGND VGND VPWR VPWR net200 sky130_fd_sc_hd__dfxtp_4
XFILLER_0_5_505 VGND VGND VPWR VPWR sky130_fd_sc_hd__fill_2
X_12638_ _06195_ VGND VGND VPWR VPWR _00747_ sky130_fd_sc_hd__clkbuf_1
XFILLER_0_127_167 VGND VGND VPWR VPWR sky130_fd_sc_hd__fill_1
X_15357_ _03591_ net1171 _02063_ VGND VGND VPWR VPWR _02066_ sky130_fd_sc_hd__mux2_1
XFILLER_0_53_474 VGND VGND VPWR VPWR sky130_fd_sc_hd__fill_1
XFILLER_0_13_305 VGND VGND VPWR VPWR sky130_fd_sc_hd__decap_3
X_12569_ _06145_ _06128_ _06146_ VGND VGND VPWR VPWR _06147_ sky130_fd_sc_hd__and3b_1
X_15288_ _02029_ VGND VGND VPWR VPWR _01498_ sky130_fd_sc_hd__clkbuf_1
Xhold217 reg_pc\[22\] VGND VGND VPWR VPWR net575 sky130_fd_sc_hd__dlygate4sd3_1
XFILLER_0_103_3 VGND VGND VPWR VPWR sky130_fd_sc_hd__fill_1
XFILLER_0_79_9 VGND VGND VPWR VPWR sky130_fd_sc_hd__fill_2
X_14308_ _07569_ _07573_ _07584_ _07359_ net576 VGND VGND VPWR VPWR _01007_ sky130_fd_sc_hd__o32a_1
Xhold206 instr_blt VGND VGND VPWR VPWR net564 sky130_fd_sc_hd__dlygate4sd3_1
XFILLER_0_111_513 VGND VGND VPWR VPWR sky130_fd_sc_hd__decap_4
Xhold228 cpuregs\[12\]\[15\] VGND VGND VPWR VPWR net586 sky130_fd_sc_hd__dlygate4sd3_1
X_14239_ net486 net112 _07541_ VGND VGND VPWR VPWR _07545_ sky130_fd_sc_hd__mux2_1
Xhold239 count_instr\[44\] VGND VGND VPWR VPWR net597 sky130_fd_sc_hd__dlygate4sd3_1
XFILLER_0_1_744 VPWR VGND VPWR VGND sky130_ef_sc_hd__decap_12
XFILLER_0_40_157 VGND VGND VPWR VPWR sky130_fd_sc_hd__decap_8
XTAP_500 VGND VPWR sky130_fd_sc_hd__tapvpwrvgnd_1
X_08800_ _02729_ _03143_ _03154_ _03020_ VGND VGND VPWR VPWR alu_out\[26\] sky130_fd_sc_hd__a22o_1
XTAP_511 VGND VPWR sky130_fd_sc_hd__tapvpwrvgnd_1
XTAP_522 VGND VPWR sky130_fd_sc_hd__tapvpwrvgnd_1
XTAP_533 VGND VPWR sky130_fd_sc_hd__tapvpwrvgnd_1
X_09780_ _02241_ _04000_ _04009_ VGND VGND VPWR VPWR _04010_ sky130_fd_sc_hd__a21bo_1
XTAP_544 VGND VPWR sky130_fd_sc_hd__tapvpwrvgnd_1
XTAP_555 VGND VPWR sky130_fd_sc_hd__tapvpwrvgnd_1
XTAP_566 VGND VPWR sky130_fd_sc_hd__tapvpwrvgnd_1
X_08731_ _03088_ _03089_ VGND VGND VPWR VPWR _03090_ sky130_fd_sc_hd__and2_1
XTAP_588 VGND VPWR sky130_fd_sc_hd__tapvpwrvgnd_1
XTAP_577 VGND VPWR sky130_fd_sc_hd__tapvpwrvgnd_1
XTAP_599 VGND VPWR sky130_fd_sc_hd__tapvpwrvgnd_1
X_08662_ _03021_ _03026_ VGND VGND VPWR VPWR _03027_ sky130_fd_sc_hd__and2_1
X_08593_ _02378_ VGND VGND VPWR VPWR _02963_ sky130_fd_sc_hd__inv_2
XFILLER_0_76_533 VGND VGND VPWR VPWR sky130_fd_sc_hd__decap_6
XFILLER_0_63_238 VGND VGND VPWR VPWR sky130_fd_sc_hd__fill_1
X_09214_ _03474_ _03475_ _03476_ _03449_ VGND VGND VPWR VPWR _03477_ sky130_fd_sc_hd__a2bb2o_2
XFILLER_0_17_644 VGND VGND VPWR VPWR sky130_fd_sc_hd__fill_1
X_09145_ decoded_imm_j\[11\] _01113_ _03296_ VGND VGND VPWR VPWR _03422_ sky130_fd_sc_hd__mux2_1
XFILLER_0_16_165 VGND VGND VPWR VPWR sky130_fd_sc_hd__decap_4
XFILLER_0_114_362 VGND VGND VPWR VPWR sky130_fd_sc_hd__fill_2
X_09076_ _00011_ VGND VGND VPWR VPWR _03357_ sky130_fd_sc_hd__inv_2
X_08027_ _02423_ _02424_ VGND VGND VPWR VPWR _02425_ sky130_fd_sc_hd__xnor2_1
Xhold751 cpuregs\[8\]\[27\] VGND VGND VPWR VPWR net1109 sky130_fd_sc_hd__dlygate4sd3_1
XFILLER_0_102_557 VGND VGND VPWR VPWR sky130_fd_sc_hd__fill_1
Xhold773 cpuregs\[19\]\[6\] VGND VGND VPWR VPWR net1131 sky130_fd_sc_hd__dlygate4sd3_1
Xhold740 cpuregs\[17\]\[6\] VGND VGND VPWR VPWR net1098 sky130_fd_sc_hd__dlygate4sd3_1
Xhold762 cpuregs\[10\]\[0\] VGND VGND VPWR VPWR net1120 sky130_fd_sc_hd__dlygate4sd3_1
Xhold784 cpuregs\[14\]\[11\] VGND VGND VPWR VPWR net1142 sky130_fd_sc_hd__dlygate4sd3_1
Xhold795 mem_rdata_q\[11\] VGND VGND VPWR VPWR net1153 sky130_fd_sc_hd__dlygate4sd3_1
X_09978_ cpuregs\[0\]\[11\] cpuregs\[1\]\[11\] _03750_ VGND VGND VPWR VPWR _04203_
+ sky130_fd_sc_hd__mux2_1
X_08929_ reg_out\[10\] reg_next_pc\[10\] _03225_ VGND VGND VPWR VPWR _03243_ sky130_fd_sc_hd__mux2_1
XFILLER_0_98_113 VGND VGND VPWR VPWR sky130_fd_sc_hd__fill_1
X_11940_ count_instr\[39\] count_instr\[38\] _05619_ VGND VGND VPWR VPWR _05625_ sky130_fd_sc_hd__and3_1
X_11871_ count_instr\[20\] count_instr\[19\] count_instr\[18\] _05567_ VGND VGND VPWR
+ VPWR _05575_ sky130_fd_sc_hd__and4_1
X_10822_ net768 _03597_ _04968_ VGND VGND VPWR VPWR _04972_ sky130_fd_sc_hd__mux2_1
X_13610_ _07084_ net219 _06960_ VGND VGND VPWR VPWR _07085_ sky130_fd_sc_hd__mux2_1
X_14590_ _01661_ VGND VGND VPWR VPWR _01168_ sky130_fd_sc_hd__clkbuf_1
X_13541_ _03347_ VGND VGND VPWR VPWR _07018_ sky130_fd_sc_hd__buf_4
X_10753_ net654 _03603_ _04929_ VGND VGND VPWR VPWR _04934_ sky130_fd_sc_hd__mux2_1
XFILLER_0_94_363 VGND VGND VPWR VPWR sky130_fd_sc_hd__fill_1
XFILLER_0_109_156 VGND VGND VPWR VPWR sky130_fd_sc_hd__decap_4
XFILLER_0_54_216 VGND VGND VPWR VPWR sky130_fd_sc_hd__decap_8
X_16260_ clknet_leaf_2_clk _00845_ VGND VGND VPWR VPWR instr_auipc sky130_fd_sc_hd__dfxtp_1
XFILLER_0_109_167 VGND VGND VPWR VPWR sky130_fd_sc_hd__fill_1
X_13472_ _06783_ _06948_ _06950_ _06789_ VGND VGND VPWR VPWR _06951_ sky130_fd_sc_hd__a211o_1
X_10684_ _03863_ _04883_ _04889_ VGND VGND VPWR VPWR _04890_ sky130_fd_sc_hd__or3_2
X_15211_ _01990_ VGND VGND VPWR VPWR _01460_ sky130_fd_sc_hd__clkbuf_1
XFILLER_0_47_290 VGND VGND VPWR VPWR sky130_fd_sc_hd__decap_6
XFILLER_0_124_148 VGND VGND VPWR VPWR sky130_fd_sc_hd__fill_1
X_12423_ _05747_ _06022_ _05791_ VGND VGND VPWR VPWR _06029_ sky130_fd_sc_hd__a21oi_1
X_16191_ clknet_leaf_141_clk _00808_ VGND VGND VPWR VPWR net119 sky130_fd_sc_hd__dfxtp_4
X_12354_ _05731_ _05957_ _05965_ _02154_ VGND VGND VPWR VPWR _05966_ sky130_fd_sc_hd__o22a_1
X_15142_ net705 _03543_ _01948_ VGND VGND VPWR VPWR _01954_ sky130_fd_sc_hd__mux2_1
XFILLER_0_22_124 VGND VGND VPWR VPWR sky130_fd_sc_hd__fill_1
X_11305_ net1072 _05217_ _05251_ VGND VGND VPWR VPWR _05259_ sky130_fd_sc_hd__mux2_1
X_15073_ _01917_ VGND VGND VPWR VPWR _01395_ sky130_fd_sc_hd__clkbuf_1
XFILLER_0_11_809 VGND VGND VPWR VPWR sky130_fd_sc_hd__decap_6
XFILLER_0_22_135 VGND VGND VPWR VPWR sky130_fd_sc_hd__decap_4
X_12285_ decoded_imm_j\[10\] _05712_ VGND VGND VPWR VPWR _05902_ sky130_fd_sc_hd__and2_1
X_14024_ _07428_ VGND VGND VPWR VPWR _00888_ sky130_fd_sc_hd__clkbuf_1
XFILLER_0_31_691 VGND VGND VPWR VPWR sky130_fd_sc_hd__fill_1
X_11236_ _05220_ VGND VGND VPWR VPWR _00320_ sky130_fd_sc_hd__clkbuf_1
X_11167_ net1125 _05173_ _05161_ VGND VGND VPWR VPWR _05174_ sky130_fd_sc_hd__mux2_1
X_10118_ cpuregs\[0\]\[15\] cpuregs\[1\]\[15\] _03824_ VGND VGND VPWR VPWR _04339_
+ sky130_fd_sc_hd__mux2_1
X_15975_ clknet_leaf_147_clk _00625_ VGND VGND VPWR VPWR count_instr\[44\] sky130_fd_sc_hd__dfxtp_1
X_11098_ net1342 _03504_ _05124_ VGND VGND VPWR VPWR _05134_ sky130_fd_sc_hd__mux2_1
X_10049_ cpuregs\[0\]\[13\] cpuregs\[1\]\[13\] _03824_ VGND VGND VPWR VPWR _04272_
+ sky130_fd_sc_hd__mux2_1
X_14926_ _01839_ VGND VGND VPWR VPWR _01326_ sky130_fd_sc_hd__clkbuf_1
XFILLER_0_26_99 VGND VGND VPWR VPWR sky130_fd_sc_hd__fill_1
X_14857_ _03504_ net1259 _01793_ VGND VGND VPWR VPWR _01803_ sky130_fd_sc_hd__mux2_1
X_13808_ cpuregs\[20\]\[31\] cpuregs\[21\]\[31\] _06456_ VGND VGND VPWR VPWR _07276_
+ sky130_fd_sc_hd__mux2_1
XFILLER_0_58_533 VGND VGND VPWR VPWR sky130_fd_sc_hd__fill_1
X_14788_ net807 _05179_ _01756_ VGND VGND VPWR VPWR _01766_ sky130_fd_sc_hd__mux2_1
X_13739_ _06970_ _07208_ VGND VGND VPWR VPWR _07209_ sky130_fd_sc_hd__and2_1
X_16527_ clknet_leaf_14_clk _01104_ VGND VGND VPWR VPWR mem_rdata_q\[11\] sky130_fd_sc_hd__dfxtp_1
XFILLER_0_46_728 VGND VGND VPWR VPWR sky130_fd_sc_hd__fill_1
XFILLER_0_18_419 VGND VGND VPWR VPWR sky130_fd_sc_hd__fill_1
X_16458_ clknet_leaf_135_clk _01040_ VGND VGND VPWR VPWR cpuregs\[18\]\[11\] sky130_fd_sc_hd__dfxtp_1
XFILLER_0_45_249 VGND VGND VPWR VPWR sky130_fd_sc_hd__fill_2
XFILLER_0_5_313 VGND VGND VPWR VPWR sky130_fd_sc_hd__fill_2
X_15409_ clknet_leaf_71_clk _00064_ VGND VGND VPWR VPWR cpuregs\[11\]\[27\] sky130_fd_sc_hd__dfxtp_1
XFILLER_0_54_783 VGND VGND VPWR VPWR sky130_fd_sc_hd__fill_2
XFILLER_0_5_346 VGND VGND VPWR VPWR sky130_fd_sc_hd__fill_2
X_16389_ clknet_leaf_144_clk _00971_ VGND VGND VPWR VPWR net142 sky130_fd_sc_hd__dfxtp_1
XFILLER_0_111_321 VGND VGND VPWR VPWR sky130_fd_sc_hd__decap_3
X_09901_ cpuregs\[2\]\[9\] cpuregs\[3\]\[9\] _03768_ VGND VGND VPWR VPWR _04128_ sky130_fd_sc_hd__mux2_1
XFILLER_0_6_54 VPWR VGND VPWR VGND sky130_ef_sc_hd__decap_12
XTAP_341 VGND VPWR sky130_fd_sc_hd__tapvpwrvgnd_1
XTAP_330 VGND VPWR sky130_fd_sc_hd__tapvpwrvgnd_1
X_09832_ _04045_ _04060_ _03674_ VGND VGND VPWR VPWR _04061_ sky130_fd_sc_hd__a21o_1
X_09763_ _03957_ _03958_ _03993_ _03717_ VGND VGND VPWR VPWR _03994_ sky130_fd_sc_hd__a22o_1
XTAP_385 VGND VPWR sky130_fd_sc_hd__tapvpwrvgnd_1
XTAP_374 VGND VPWR sky130_fd_sc_hd__tapvpwrvgnd_1
XTAP_363 VGND VPWR sky130_fd_sc_hd__tapvpwrvgnd_1
XTAP_352 VGND VPWR sky130_fd_sc_hd__tapvpwrvgnd_1
X_08714_ _03068_ _03074_ VGND VGND VPWR VPWR _03075_ sky130_fd_sc_hd__xnor2_1
XTAP_396 VGND VPWR sky130_fd_sc_hd__tapvpwrvgnd_1
XTAP_2208 VGND VPWR sky130_fd_sc_hd__tapvpwrvgnd_1
X_09694_ _03724_ _03925_ VGND VGND VPWR VPWR _03926_ sky130_fd_sc_hd__nand2_1
Xrebuffer21 _06135_ VGND VGND VPWR VPWR net379 sky130_fd_sc_hd__clkbuf_1
Xrebuffer10 net369 VGND VGND VPWR VPWR net368 sky130_fd_sc_hd__clkbuf_1
XTAP_2219 VGND VPWR sky130_fd_sc_hd__tapvpwrvgnd_1
X_08645_ _02426_ net209 _02942_ _02841_ VGND VGND VPWR VPWR _03011_ sky130_fd_sc_hd__a31o_1
XFILLER_0_83_94 VGND VGND VPWR VPWR sky130_fd_sc_hd__fill_1
X_08576_ _02352_ _02946_ VGND VGND VPWR VPWR _02948_ sky130_fd_sc_hd__or2_1
XTAP_1529 VGND VPWR sky130_fd_sc_hd__tapvpwrvgnd_1
XTAP_1518 VGND VPWR sky130_fd_sc_hd__tapvpwrvgnd_1
XTAP_1507 VGND VPWR sky130_fd_sc_hd__tapvpwrvgnd_1
XPHY_14 VGND VGND VPWR VPWR sky130_fd_sc_hd__decap_3
XPHY_25 VGND VGND VPWR VPWR sky130_fd_sc_hd__decap_3
XPHY_36 VGND VGND VPWR VPWR sky130_fd_sc_hd__decap_3
XPHY_47 VGND VGND VPWR VPWR sky130_fd_sc_hd__decap_3
XPHY_58 VGND VGND VPWR VPWR sky130_fd_sc_hd__decap_3
XPHY_69 VGND VGND VPWR VPWR sky130_fd_sc_hd__decap_3
XFILLER_0_91_311 VGND VGND VPWR VPWR sky130_fd_sc_hd__fill_2
XFILLER_0_9_652 VGND VGND VPWR VPWR sky130_fd_sc_hd__fill_1
XFILLER_0_9_641 VGND VGND VPWR VPWR sky130_fd_sc_hd__fill_2
XFILLER_0_17_430 VGND VGND VPWR VPWR sky130_fd_sc_hd__fill_2
XFILLER_0_8_195 VGND VGND VPWR VPWR sky130_fd_sc_hd__fill_1
XFILLER_0_17_474 VGND VGND VPWR VPWR sky130_fd_sc_hd__decap_3
X_09128_ _03377_ _03406_ VGND VGND VPWR VPWR _03407_ sky130_fd_sc_hd__or2_1
XFILLER_0_130_641 VGND VGND VPWR VPWR sky130_fd_sc_hd__decap_3
X_09059_ _03324_ VGND VGND VPWR VPWR _03340_ sky130_fd_sc_hd__buf_4
XFILLER_0_20_617 VGND VGND VPWR VPWR sky130_fd_sc_hd__fill_1
XFILLER_0_130_696 VGND VGND VPWR VPWR sky130_fd_sc_hd__decap_4
X_12070_ _03527_ reg_next_pc\[13\] _03222_ VGND VGND VPWR VPWR _05718_ sky130_fd_sc_hd__mux2_2
Xhold570 cpuregs\[24\]\[16\] VGND VGND VPWR VPWR net928 sky130_fd_sc_hd__dlygate4sd3_1
Xhold581 reg_next_pc\[7\] VGND VGND VPWR VPWR net939 sky130_fd_sc_hd__dlygate4sd3_1
X_11021_ _05093_ VGND VGND VPWR VPWR _00232_ sky130_fd_sc_hd__clkbuf_1
Xhold592 cpuregs\[1\]\[13\] VGND VGND VPWR VPWR net950 sky130_fd_sc_hd__dlygate4sd3_1
X_15760_ clknet_leaf_79_clk _00410_ VGND VGND VPWR VPWR cpuregs\[15\]\[22\] sky130_fd_sc_hd__dfxtp_1
Xhold1270 count_cycle\[7\] VGND VGND VPWR VPWR net1628 sky130_fd_sc_hd__dlygate4sd3_1
X_12972_ _03335_ VGND VGND VPWR VPWR _06466_ sky130_fd_sc_hd__buf_4
Xhold1281 reg_pc\[31\] VGND VGND VPWR VPWR net1639 sky130_fd_sc_hd__dlygate4sd3_1
X_15691_ clknet_leaf_96_clk _00341_ VGND VGND VPWR VPWR cpuregs\[27\]\[17\] sky130_fd_sc_hd__dfxtp_1
Xhold1292 reg_pc\[3\] VGND VGND VPWR VPWR net1650 sky130_fd_sc_hd__dlygate4sd3_1
X_14711_ _01725_ VGND VGND VPWR VPWR _01225_ sky130_fd_sc_hd__clkbuf_1
X_11923_ net909 _05609_ _05526_ VGND VGND VPWR VPWR _05613_ sky130_fd_sc_hd__o21ai_1
XFILLER_0_86_138 VGND VGND VPWR VPWR sky130_fd_sc_hd__fill_2
XFILLER_0_86_127 VGND VGND VPWR VPWR sky130_fd_sc_hd__decap_3
X_11854_ count_instr\[15\] _05560_ VGND VGND VPWR VPWR _05563_ sky130_fd_sc_hd__or2_1
X_14642_ net1419 _05169_ _01684_ VGND VGND VPWR VPWR _01689_ sky130_fd_sc_hd__mux2_1
X_10805_ net829 _03544_ _04957_ VGND VGND VPWR VPWR _04963_ sky130_fd_sc_hd__mux2_1
X_11785_ _05043_ net1011 _05505_ VGND VGND VPWR VPWR _05514_ sky130_fd_sc_hd__mux2_1
XFILLER_0_67_374 VGND VGND VPWR VPWR sky130_fd_sc_hd__fill_2
XFILLER_0_55_503 VGND VGND VPWR VPWR sky130_fd_sc_hd__fill_1
X_14573_ _01652_ VGND VGND VPWR VPWR _01160_ sky130_fd_sc_hd__clkbuf_1
XFILLER_0_27_216 VGND VGND VPWR VPWR sky130_fd_sc_hd__fill_1
XFILLER_0_137_262 VPWR VGND VPWR VGND sky130_ef_sc_hd__decap_12
X_13524_ _06866_ _06995_ _07000_ _06873_ VGND VGND VPWR VPWR _07001_ sky130_fd_sc_hd__o211a_1
X_10736_ net1155 _03552_ _04918_ VGND VGND VPWR VPWR _04925_ sky130_fd_sc_hd__mux2_1
X_16312_ clknet_leaf_139_clk _00897_ VGND VGND VPWR VPWR decoded_rd\[0\] sky130_fd_sc_hd__dfxtp_1
X_16243_ clknet_leaf_41_clk alu_out\[16\] VGND VGND VPWR VPWR alu_out_q\[16\] sky130_fd_sc_hd__dfxtp_1
X_10667_ _04832_ _04871_ _04870_ _04869_ VGND VGND VPWR VPWR _04873_ sky130_fd_sc_hd__o211ai_2
X_13455_ _06699_ _06933_ _06667_ VGND VGND VPWR VPWR _06934_ sky130_fd_sc_hd__a21o_1
XFILLER_0_70_528 VGND VGND VPWR VPWR sky130_fd_sc_hd__decap_4
X_12406_ _05981_ _05745_ VGND VGND VPWR VPWR _06013_ sky130_fd_sc_hd__and2_1
X_16174_ clknet_leaf_145_clk _00792_ VGND VGND VPWR VPWR net47 sky130_fd_sc_hd__dfxtp_1
X_10598_ cpuregs\[4\]\[28\] cpuregs\[5\]\[28\] cpuregs\[6\]\[28\] cpuregs\[7\]\[28\]
+ _03875_ _03726_ VGND VGND VPWR VPWR _04806_ sky130_fd_sc_hd__mux4_1
X_13386_ cpuregs\[12\]\[18\] cpuregs\[13\]\[18\] cpuregs\[14\]\[18\] cpuregs\[15\]\[18\]
+ _06696_ _06728_ VGND VGND VPWR VPWR _06867_ sky130_fd_sc_hd__mux4_1
XFILLER_0_50_230 VGND VGND VPWR VPWR sky130_fd_sc_hd__fill_2
X_15125_ net595 _03490_ _01937_ VGND VGND VPWR VPWR _01945_ sky130_fd_sc_hd__mux2_1
X_12337_ _05939_ _05949_ _05945_ _05926_ _05937_ VGND VGND VPWR VPWR _05950_ sky130_fd_sc_hd__o221a_1
Xoutput119 net252 VGND VGND VPWR VPWR mem_la_wdata[2] sky130_fd_sc_hd__clkbuf_4
Xoutput108 net108 VGND VGND VPWR VPWR mem_la_wdata[1] sky130_fd_sc_hd__clkbuf_4
XFILLER_0_121_685 VGND VGND VPWR VPWR sky130_fd_sc_hd__decap_3
X_12268_ _05763_ net1337 _05883_ _05886_ _05768_ VGND VGND VPWR VPWR _00686_ sky130_fd_sc_hd__o221a_1
XFILLER_0_10_149 VGND VGND VPWR VPWR sky130_fd_sc_hd__decap_4
X_15056_ _01908_ VGND VGND VPWR VPWR _01387_ sky130_fd_sc_hd__clkbuf_1
X_11219_ _03596_ VGND VGND VPWR VPWR _05209_ sky130_fd_sc_hd__buf_4
X_14007_ _02201_ _07382_ _07417_ _07419_ VGND VGND VPWR VPWR _00883_ sky130_fd_sc_hd__a22o_1
Xoutput90 net90 VGND VGND VPWR VPWR mem_la_addr[4] sky130_fd_sc_hd__clkbuf_4
X_12199_ _05806_ _05810_ _05822_ _02153_ VGND VGND VPWR VPWR _05823_ sky130_fd_sc_hd__a31o_1
XFILLER_0_37_76 VGND VGND VPWR VPWR sky130_fd_sc_hd__decap_6
X_15958_ clknet_leaf_154_clk _00608_ VGND VGND VPWR VPWR count_instr\[27\] sky130_fd_sc_hd__dfxtp_1
X_14909_ _03451_ net1084 _01829_ VGND VGND VPWR VPWR _01831_ sky130_fd_sc_hd__mux2_1
X_08430_ net226 VGND VGND VPWR VPWR _02811_ sky130_fd_sc_hd__inv_2
X_15889_ clknet_leaf_62_clk _00539_ VGND VGND VPWR VPWR cpuregs\[20\]\[23\] sky130_fd_sc_hd__dfxtp_1
XFILLER_0_74_801 VGND VGND VPWR VPWR sky130_fd_sc_hd__decap_3
X_08361_ _02653_ net227 VGND VGND VPWR VPWR _02742_ sky130_fd_sc_hd__nand2_1
XFILLER_0_92_119 VGND VGND VPWR VPWR sky130_fd_sc_hd__decap_8
XFILLER_0_58_363 VGND VGND VPWR VPWR sky130_fd_sc_hd__fill_1
XFILLER_0_129_785 VGND VGND VPWR VPWR sky130_fd_sc_hd__decap_4
X_08292_ net201 _02671_ VGND VGND VPWR VPWR _02673_ sky130_fd_sc_hd__nand2_1
XFILLER_0_73_355 VGND VGND VPWR VPWR sky130_fd_sc_hd__fill_1
XFILLER_0_5_132 VGND VGND VPWR VPWR sky130_fd_sc_hd__fill_1
XFILLER_0_14_400 VGND VGND VPWR VPWR sky130_fd_sc_hd__fill_2
XFILLER_0_6_699 VGND VGND VPWR VPWR sky130_fd_sc_hd__fill_1
XFILLER_0_5_198 VGND VGND VPWR VPWR sky130_fd_sc_hd__fill_1
X_09815_ cpuregs\[2\]\[7\] cpuregs\[3\]\[7\] _03665_ VGND VGND VPWR VPWR _04044_ sky130_fd_sc_hd__mux2_1
X_09746_ _03976_ VGND VGND VPWR VPWR _03977_ sky130_fd_sc_hd__clkbuf_8
XTAP_2016 VGND VPWR sky130_fd_sc_hd__tapvpwrvgnd_1
XTAP_2005 VGND VPWR sky130_fd_sc_hd__tapvpwrvgnd_1
X_09677_ _03855_ _03909_ _03715_ VGND VGND VPWR VPWR _03910_ sky130_fd_sc_hd__o21ba_1
XTAP_2049 VGND VPWR sky130_fd_sc_hd__tapvpwrvgnd_1
XTAP_2038 VGND VPWR sky130_fd_sc_hd__tapvpwrvgnd_1
XTAP_2027 VGND VPWR sky130_fd_sc_hd__tapvpwrvgnd_1
X_08628_ _02975_ _02985_ VGND VGND VPWR VPWR _02996_ sky130_fd_sc_hd__nand2_1
XTAP_1304 VGND VPWR sky130_fd_sc_hd__tapvpwrvgnd_1
XTAP_1348 VGND VPWR sky130_fd_sc_hd__tapvpwrvgnd_1
XTAP_1337 VGND VPWR sky130_fd_sc_hd__tapvpwrvgnd_1
XTAP_1326 VGND VPWR sky130_fd_sc_hd__tapvpwrvgnd_1
XTAP_1315 VGND VPWR sky130_fd_sc_hd__tapvpwrvgnd_1
X_08559_ _02910_ _02931_ _02926_ VGND VGND VPWR VPWR _02932_ sky130_fd_sc_hd__a21oi_1
XTAP_1359 VGND VPWR sky130_fd_sc_hd__tapvpwrvgnd_1
XFILLER_0_37_525 VGND VGND VPWR VPWR sky130_fd_sc_hd__fill_1
X_11570_ _05400_ VGND VGND VPWR VPWR _00474_ sky130_fd_sc_hd__clkbuf_1
X_10521_ cpuregs\[12\]\[26\] cpuregs\[13\]\[26\] _03976_ VGND VGND VPWR VPWR _04731_
+ sky130_fd_sc_hd__mux2_1
XFILLER_0_107_413 VGND VGND VPWR VPWR sky130_fd_sc_hd__fill_1
X_13240_ _06416_ _06712_ _06725_ _06470_ decoded_imm\[13\] VGND VGND VPWR VPWR _06726_
+ sky130_fd_sc_hd__a32o_1
X_10452_ cpuregs\[20\]\[24\] cpuregs\[21\]\[24\] cpuregs\[22\]\[24\] cpuregs\[23\]\[24\]
+ _03751_ _03929_ VGND VGND VPWR VPWR _04664_ sky130_fd_sc_hd__mux4_1
XFILLER_0_122_449 VGND VGND VPWR VPWR sky130_fd_sc_hd__fill_2
X_10383_ cpuregs\[0\]\[22\] cpuregs\[1\]\[22\] _03902_ VGND VGND VPWR VPWR _04597_
+ sky130_fd_sc_hd__mux2_1
XFILLER_0_103_641 VGND VGND VPWR VPWR sky130_fd_sc_hd__decap_3
X_13171_ _06459_ _06656_ _06658_ _06563_ VGND VGND VPWR VPWR _06659_ sky130_fd_sc_hd__a211o_1
X_12122_ _03624_ reg_next_pc\[28\] _03224_ VGND VGND VPWR VPWR _05755_ sky130_fd_sc_hd__mux2_2
XFILLER_0_102_195 VGND VGND VPWR VPWR sky130_fd_sc_hd__fill_1
X_16930_ clknet_leaf_88_clk _01494_ VGND VGND VPWR VPWR cpuregs\[0\]\[17\] sky130_fd_sc_hd__dfxtp_1
X_12053_ _02108_ _05706_ VGND VGND VPWR VPWR _05707_ sky130_fd_sc_hd__or2_1
X_11004_ _05045_ net1504 _05074_ VGND VGND VPWR VPWR _05084_ sky130_fd_sc_hd__mux2_1
X_16861_ clknet_leaf_137_clk _01425_ VGND VGND VPWR VPWR cpuregs\[22\]\[12\] sky130_fd_sc_hd__dfxtp_1
X_15812_ clknet_leaf_137_clk _00462_ VGND VGND VPWR VPWR cpuregs\[16\]\[10\] sky130_fd_sc_hd__dfxtp_1
X_16792_ clknet_leaf_112_clk _01356_ VGND VGND VPWR VPWR cpuregs\[6\]\[7\] sky130_fd_sc_hd__dfxtp_1
XFILLER_0_99_263 VGND VGND VPWR VPWR sky130_fd_sc_hd__fill_1
X_12955_ cpuregs\[20\]\[5\] cpuregs\[21\]\[5\] _06448_ VGND VGND VPWR VPWR _06449_
+ sky130_fd_sc_hd__mux2_1
X_15743_ clknet_leaf_131_clk _00393_ VGND VGND VPWR VPWR cpuregs\[15\]\[5\] sky130_fd_sc_hd__dfxtp_1
X_11906_ _05599_ _05576_ _05600_ VGND VGND VPWR VPWR _05601_ sky130_fd_sc_hd__and3b_1
X_15674_ clknet_leaf_125_clk _00324_ VGND VGND VPWR VPWR cpuregs\[27\]\[0\] sky130_fd_sc_hd__dfxtp_1
X_12886_ cpuregs\[8\]\[1\] cpuregs\[9\]\[1\] cpuregs\[10\]\[1\] cpuregs\[11\]\[1\]
+ _06383_ _03330_ VGND VGND VPWR VPWR _06384_ sky130_fd_sc_hd__mux4_1
X_14625_ _01679_ VGND VGND VPWR VPWR _01185_ sky130_fd_sc_hd__clkbuf_1
XTAP_1860 VGND VPWR sky130_fd_sc_hd__tapvpwrvgnd_1
X_11837_ _05539_ _05550_ VGND VGND VPWR VPWR _05551_ sky130_fd_sc_hd__nor2_1
XFILLER_0_23_23 VGND VGND VPWR VPWR sky130_fd_sc_hd__fill_1
XFILLER_0_23_45 VGND VGND VPWR VPWR sky130_fd_sc_hd__decap_3
X_14556_ net1460 _05219_ _01634_ VGND VGND VPWR VPWR _01643_ sky130_fd_sc_hd__mux2_1
XTAP_1893 VGND VPWR sky130_fd_sc_hd__tapvpwrvgnd_1
XTAP_1882 VGND VPWR sky130_fd_sc_hd__tapvpwrvgnd_1
XTAP_1871 VGND VPWR sky130_fd_sc_hd__tapvpwrvgnd_1
X_11768_ _05482_ VGND VGND VPWR VPWR _05505_ sky130_fd_sc_hd__buf_4
XFILLER_0_126_733 VGND VGND VPWR VPWR sky130_fd_sc_hd__decap_3
X_13507_ _06783_ _06982_ _06984_ _06789_ VGND VGND VPWR VPWR _06985_ sky130_fd_sc_hd__a211o_1
X_10719_ net1013 _03498_ _04907_ VGND VGND VPWR VPWR _04916_ sky130_fd_sc_hd__mux2_1
X_14487_ _01606_ VGND VGND VPWR VPWR _01088_ sky130_fd_sc_hd__clkbuf_1
XFILLER_0_125_254 VGND VGND VPWR VPWR sky130_fd_sc_hd__fill_1
X_11699_ _05468_ VGND VGND VPWR VPWR _00535_ sky130_fd_sc_hd__clkbuf_1
XFILLER_0_113_427 VGND VGND VPWR VPWR sky130_fd_sc_hd__decap_3
X_13438_ cpuregs\[20\]\[19\] cpuregs\[21\]\[19\] _06784_ VGND VGND VPWR VPWR _06918_
+ sky130_fd_sc_hd__mux2_1
Xrebuffer1 _06156_ VGND VGND VPWR VPWR net359 sky130_fd_sc_hd__clkbuf_1
X_16226_ clknet_leaf_3_clk _00843_ VGND VGND VPWR VPWR latched_is_lb sky130_fd_sc_hd__dfxtp_1
X_16157_ clknet_leaf_65_clk _00775_ VGND VGND VPWR VPWR net60 sky130_fd_sc_hd__dfxtp_1
X_13369_ _06849_ _06850_ VGND VGND VPWR VPWR _06851_ sky130_fd_sc_hd__or2_1
XFILLER_0_23_274 VGND VGND VPWR VPWR sky130_fd_sc_hd__decap_6
X_15108_ _01935_ VGND VGND VPWR VPWR _01412_ sky130_fd_sc_hd__clkbuf_1
X_16088_ clknet_leaf_3_clk _00738_ VGND VGND VPWR VPWR count_cycle\[31\] sky130_fd_sc_hd__dfxtp_1
XFILLER_0_139_44 VPWR VGND VPWR VGND sky130_ef_sc_hd__decap_12
X_07930_ _02331_ _02334_ VGND VGND VPWR VPWR _02335_ sky130_fd_sc_hd__xor2_1
X_15039_ _03646_ net1616 _01864_ VGND VGND VPWR VPWR _01899_ sky130_fd_sc_hd__mux2_1
X_07861_ instr_rdinstr VGND VGND VPWR VPWR _02270_ sky130_fd_sc_hd__clkbuf_4
X_09600_ _03668_ VGND VGND VPWR VPWR _03834_ sky130_fd_sc_hd__buf_4
X_07792_ count_instr\[0\] _02201_ _02202_ count_cycle\[0\] _02205_ VGND VGND VPWR
+ VPWR _02206_ sky130_fd_sc_hd__a221o_1
X_09531_ _03668_ VGND VGND VPWR VPWR _03766_ sky130_fd_sc_hd__clkbuf_8
XFILLER_0_64_41 VGND VGND VPWR VPWR sky130_fd_sc_hd__fill_1
XFILLER_0_64_85 VGND VGND VPWR VPWR sky130_fd_sc_hd__decap_4
X_09462_ _03663_ _03697_ VGND VGND VPWR VPWR _03698_ sky130_fd_sc_hd__nor2_1
X_09393_ reg_pc\[29\] _03626_ _03460_ VGND VGND VPWR VPWR _03632_ sky130_fd_sc_hd__o21ai_1
X_08413_ net200 _02781_ _02670_ _02787_ _02793_ VGND VGND VPWR VPWR _02794_ sky130_fd_sc_hd__o221a_1
X_08344_ net188 net220 VGND VGND VPWR VPWR _02725_ sky130_fd_sc_hd__nand2_1
XFILLER_0_117_777 VGND VGND VPWR VPWR sky130_fd_sc_hd__fill_1
X_08275_ net25 _02448_ _02429_ VGND VGND VPWR VPWR _02657_ sky130_fd_sc_hd__a21oi_1
XFILLER_0_34_539 VGND VGND VPWR VPWR sky130_fd_sc_hd__fill_1
XFILLER_0_116_265 VPWR VGND VPWR VGND sky130_ef_sc_hd__decap_12
XFILLER_0_116_298 VGND VGND VPWR VPWR sky130_fd_sc_hd__decap_4
XFILLER_0_131_279 VGND VGND VPWR VPWR sky130_fd_sc_hd__fill_1
XFILLER_0_30_734 VGND VGND VPWR VPWR sky130_fd_sc_hd__fill_1
XFILLER_0_100_699 VGND VGND VPWR VPWR sky130_fd_sc_hd__fill_1
X_09729_ cpuregs\[8\]\[5\] cpuregs\[9\]\[5\] cpuregs\[10\]\[5\] cpuregs\[11\]\[5\]
+ _03875_ _03726_ VGND VGND VPWR VPWR _03960_ sky130_fd_sc_hd__mux4_1
X_12740_ _03984_ _06273_ VGND VGND VPWR VPWR _06274_ sky130_fd_sc_hd__and2_1
XTAP_1123 VGND VPWR sky130_fd_sc_hd__tapvpwrvgnd_1
XTAP_1112 VGND VPWR sky130_fd_sc_hd__tapvpwrvgnd_1
XTAP_1101 VGND VPWR sky130_fd_sc_hd__tapvpwrvgnd_1
XTAP_1156 VGND VPWR sky130_fd_sc_hd__tapvpwrvgnd_1
XTAP_1145 VGND VPWR sky130_fd_sc_hd__tapvpwrvgnd_1
XTAP_1134 VGND VPWR sky130_fd_sc_hd__tapvpwrvgnd_1
X_12671_ count_cycle\[47\] count_cycle\[50\] _06207_ _06217_ VGND VGND VPWR VPWR _06219_
+ sky130_fd_sc_hd__and4_1
X_14410_ _05033_ net1266 _01562_ VGND VGND VPWR VPWR _01566_ sky130_fd_sc_hd__mux2_1
X_11622_ _05016_ net1423 _05422_ VGND VGND VPWR VPWR _05428_ sky130_fd_sc_hd__mux2_1
XTAP_1189 VGND VPWR sky130_fd_sc_hd__tapvpwrvgnd_1
XTAP_1178 VGND VPWR sky130_fd_sc_hd__tapvpwrvgnd_1
XTAP_1167 VGND VPWR sky130_fd_sc_hd__tapvpwrvgnd_1
X_15390_ clknet_leaf_114_clk _00045_ VGND VGND VPWR VPWR cpuregs\[11\]\[8\] sky130_fd_sc_hd__dfxtp_1
X_14341_ decoded_imm\[8\] _07459_ net1093 VGND VGND VPWR VPWR _01021_ sky130_fd_sc_hd__o21a_1
XFILLER_0_108_755 VGND VGND VPWR VPWR sky130_fd_sc_hd__fill_1
X_11553_ _05391_ VGND VGND VPWR VPWR _00466_ sky130_fd_sc_hd__clkbuf_1
X_10504_ _03662_ _04710_ _04714_ _03684_ VGND VGND VPWR VPWR _04715_ sky130_fd_sc_hd__o211a_1
X_11484_ _05354_ VGND VGND VPWR VPWR _00434_ sky130_fd_sc_hd__clkbuf_1
XFILLER_0_52_358 VGND VGND VPWR VPWR sky130_fd_sc_hd__decap_6
X_14272_ _04902_ _07560_ _07561_ net388 VGND VGND VPWR VPWR _00994_ sky130_fd_sc_hd__a22o_1
X_10435_ cpuregs\[12\]\[24\] cpuregs\[13\]\[24\] cpuregs\[14\]\[24\] cpuregs\[15\]\[24\]
+ _03977_ _03719_ VGND VGND VPWR VPWR _04647_ sky130_fd_sc_hd__mux4_1
XFILLER_0_100_27 VGND VGND VPWR VPWR sky130_fd_sc_hd__fill_1
X_16011_ clknet_leaf_30_clk _00661_ VGND VGND VPWR VPWR reg_pc\[17\] sky130_fd_sc_hd__dfxtp_2
X_13223_ cpuregs\[0\]\[13\] cpuregs\[1\]\[13\] cpuregs\[2\]\[13\] cpuregs\[3\]\[13\]
+ _06364_ _06708_ VGND VGND VPWR VPWR _06709_ sky130_fd_sc_hd__mux4_1
X_13154_ cpuregs\[6\]\[11\] cpuregs\[7\]\[11\] _06511_ VGND VGND VPWR VPWR _06642_
+ sky130_fd_sc_hd__mux2_1
X_10366_ _04578_ _04579_ VGND VGND VPWR VPWR _04580_ sky130_fd_sc_hd__nand2_1
X_12105_ _05519_ _05743_ VGND VGND VPWR VPWR _05744_ sky130_fd_sc_hd__nand2_1
XTAP_907 VGND VPWR sky130_fd_sc_hd__tapvpwrvgnd_1
X_10297_ decoded_imm\[20\] net183 VGND VGND VPWR VPWR _04513_ sky130_fd_sc_hd__or2_1
X_13085_ _03322_ VGND VGND VPWR VPWR _06575_ sky130_fd_sc_hd__buf_4
XTAP_918 VGND VPWR sky130_fd_sc_hd__tapvpwrvgnd_1
XTAP_929 VGND VPWR sky130_fd_sc_hd__tapvpwrvgnd_1
X_12036_ _05688_ _05693_ _05694_ _02142_ VGND VGND VPWR VPWR _00646_ sky130_fd_sc_hd__o211a_1
X_16913_ clknet_leaf_119_clk _01477_ VGND VGND VPWR VPWR cpuregs\[0\]\[0\] sky130_fd_sc_hd__dfxtp_1
X_16844_ clknet_leaf_73_clk _01408_ VGND VGND VPWR VPWR cpuregs\[7\]\[27\] sky130_fd_sc_hd__dfxtp_1
XFILLER_0_109_69 VGND VGND VPWR VPWR sky130_fd_sc_hd__decap_6
XFILLER_0_88_701 VGND VGND VPWR VPWR sky130_fd_sc_hd__fill_2
X_16775_ clknet_leaf_76_clk _01339_ VGND VGND VPWR VPWR cpuregs\[5\]\[22\] sky130_fd_sc_hd__dfxtp_1
X_13987_ _07404_ VGND VGND VPWR VPWR _00878_ sky130_fd_sc_hd__clkbuf_1
X_15726_ clknet_leaf_57_clk _00376_ VGND VGND VPWR VPWR cpuregs\[21\]\[20\] sky130_fd_sc_hd__dfxtp_1
X_12938_ cpuregs\[4\]\[5\] cpuregs\[5\]\[5\] _06383_ VGND VGND VPWR VPWR _06432_ sky130_fd_sc_hd__mux2_1
XFILLER_0_87_277 VGND VGND VPWR VPWR sky130_fd_sc_hd__decap_3
X_15657_ clknet_leaf_90_clk _00307_ VGND VGND VPWR VPWR cpuregs\[14\]\[15\] sky130_fd_sc_hd__dfxtp_1
XFILLER_0_47_119 VGND VGND VPWR VPWR sky130_fd_sc_hd__decap_4
X_14608_ _05026_ net1524 _01670_ VGND VGND VPWR VPWR _01671_ sky130_fd_sc_hd__mux2_1
XFILLER_0_56_642 VGND VGND VPWR VPWR sky130_fd_sc_hd__fill_2
X_12869_ _03311_ _06367_ VGND VGND VPWR VPWR _06368_ sky130_fd_sc_hd__or2_1
XTAP_1690 VGND VPWR sky130_fd_sc_hd__tapvpwrvgnd_1
X_15588_ clknet_leaf_134_clk _00238_ VGND VGND VPWR VPWR cpuregs\[28\]\[10\] sky130_fd_sc_hd__dfxtp_1
X_14539_ _01611_ VGND VGND VPWR VPWR _01634_ sky130_fd_sc_hd__buf_4
XFILLER_0_71_612 VGND VGND VPWR VPWR sky130_fd_sc_hd__decap_4
XFILLER_0_16_517 VGND VGND VPWR VPWR sky130_fd_sc_hd__decap_4
X_08060_ _02237_ VGND VGND VPWR VPWR _02456_ sky130_fd_sc_hd__clkbuf_4
X_16209_ clknet_leaf_52_clk _00826_ VGND VGND VPWR VPWR net215 sky130_fd_sc_hd__dfxtp_4
Xpicorv32_311 VGND VGND VPWR VPWR picorv32_311/HI pcpi_insn[22] sky130_fd_sc_hd__conb_1
Xpicorv32_300 VGND VGND VPWR VPWR picorv32_300/HI pcpi_insn[11] sky130_fd_sc_hd__conb_1
Xpicorv32_344 VGND VGND VPWR VPWR picorv32_344/HI trace_data[22] sky130_fd_sc_hd__conb_1
XFILLER_0_113_279 VGND VGND VPWR VPWR sky130_fd_sc_hd__fill_1
Xpicorv32_333 VGND VGND VPWR VPWR picorv32_333/HI trace_data[11] sky130_fd_sc_hd__conb_1
XFILLER_0_24_583 VGND VGND VPWR VPWR sky130_fd_sc_hd__decap_4
Xpicorv32_322 VGND VGND VPWR VPWR picorv32_322/HI trace_data[0] sky130_fd_sc_hd__conb_1
Xpicorv32_355 VGND VGND VPWR VPWR picorv32_355/HI trace_data[33] sky130_fd_sc_hd__conb_1
X_08962_ _02509_ _03265_ _03246_ VGND VGND VPWR VPWR _03266_ sky130_fd_sc_hd__mux2_1
X_08893_ net221 _02448_ _03207_ VGND VGND VPWR VPWR net115 sky130_fd_sc_hd__a21o_4
X_07913_ reg_pc\[7\] decoded_imm\[7\] VGND VGND VPWR VPWR _02319_ sky130_fd_sc_hd__nor2_1
X_07844_ reg_pc\[3\] decoded_imm\[3\] VGND VGND VPWR VPWR _02254_ sky130_fd_sc_hd__and2_1
XFILLER_0_38_3 VPWR VGND VPWR VGND sky130_ef_sc_hd__decap_12
X_07775_ mem_do_prefetch _02150_ cpu_state\[5\] VGND VGND VPWR VPWR _02191_ sky130_fd_sc_hd__o21a_1
XFILLER_0_79_745 VGND VGND VPWR VPWR sky130_fd_sc_hd__decap_8
X_09514_ _00012_ VGND VGND VPWR VPWR _03749_ sky130_fd_sc_hd__clkbuf_8
XFILLER_0_39_609 VGND VGND VPWR VPWR sky130_fd_sc_hd__fill_1
XPHY_206 VGND VGND VPWR VPWR sky130_fd_sc_hd__decap_3
X_09445_ cpuregs\[28\]\[0\] cpuregs\[29\]\[0\] cpuregs\[30\]\[0\] cpuregs\[31\]\[0\]
+ _03680_ _03670_ VGND VGND VPWR VPWR _03681_ sky130_fd_sc_hd__mux4_1
XPHY_239 VGND VGND VPWR VPWR sky130_fd_sc_hd__decap_3
XPHY_228 VGND VGND VPWR VPWR sky130_fd_sc_hd__decap_3
XPHY_217 VGND VGND VPWR VPWR sky130_fd_sc_hd__decap_3
XFILLER_0_93_225 VGND VGND VPWR VPWR sky130_fd_sc_hd__fill_2
XFILLER_0_19_322 VGND VGND VPWR VPWR sky130_fd_sc_hd__decap_4
X_09376_ _03617_ VGND VGND VPWR VPWR _00063_ sky130_fd_sc_hd__clkbuf_1
XFILLER_0_81_409 VGND VGND VPWR VPWR sky130_fd_sc_hd__fill_1
XFILLER_0_46_141 VGND VGND VPWR VPWR sky130_fd_sc_hd__fill_2
X_08327_ net184 net216 VGND VGND VPWR VPWR _02708_ sky130_fd_sc_hd__or2_1
XFILLER_0_61_100 VGND VGND VPWR VPWR sky130_fd_sc_hd__fill_1
XFILLER_0_19_377 VGND VGND VPWR VPWR sky130_fd_sc_hd__fill_2
XFILLER_0_19_388 VGND VGND VPWR VPWR sky130_fd_sc_hd__decap_4
XFILLER_0_34_303 VGND VGND VPWR VPWR sky130_fd_sc_hd__decap_4
X_08258_ _02639_ _02640_ VGND VGND VPWR VPWR _02641_ sky130_fd_sc_hd__nand2_1
XFILLER_0_62_656 VGND VGND VPWR VPWR sky130_fd_sc_hd__fill_2
XFILLER_0_61_133 VGND VGND VPWR VPWR sky130_fd_sc_hd__decap_6
XFILLER_0_7_783 VGND VGND VPWR VPWR sky130_fd_sc_hd__fill_1
X_08189_ _02562_ _02565_ _02575_ _02170_ VGND VGND VPWR VPWR _02577_ sky130_fd_sc_hd__a31o_1
XFILLER_0_104_268 VGND VGND VPWR VPWR sky130_fd_sc_hd__fill_1
X_10220_ _04438_ VGND VGND VPWR VPWR _00086_ sky130_fd_sc_hd__clkbuf_1
XFILLER_0_100_430 VGND VGND VPWR VPWR sky130_fd_sc_hd__decap_4
X_10151_ decoded_imm\[16\] net178 VGND VGND VPWR VPWR _04371_ sky130_fd_sc_hd__or2_1
XFILLER_0_30_597 VGND VGND VPWR VPWR sky130_fd_sc_hd__fill_2
X_10082_ cpuregs\[14\]\[14\] cpuregs\[15\]\[14\] _03898_ VGND VGND VPWR VPWR _04304_
+ sky130_fd_sc_hd__mux2_1
X_13910_ _07354_ VGND VGND VPWR VPWR _01105_ sky130_fd_sc_hd__buf_1
X_14890_ _01820_ VGND VGND VPWR VPWR _01309_ sky130_fd_sc_hd__clkbuf_1
X_13841_ _02185_ _07303_ VGND VGND VPWR VPWR _07304_ sky130_fd_sc_hd__and2_1
XFILLER_0_97_531 VGND VGND VPWR VPWR sky130_fd_sc_hd__fill_1
X_13772_ cpuregs\[0\]\[30\] cpuregs\[1\]\[30\] cpuregs\[2\]\[30\] cpuregs\[3\]\[30\]
+ _06344_ _06345_ VGND VGND VPWR VPWR _07241_ sky130_fd_sc_hd__mux4_1
X_10984_ _05073_ VGND VGND VPWR VPWR _00215_ sky130_fd_sc_hd__clkbuf_1
XFILLER_0_69_222 VGND VGND VPWR VPWR sky130_fd_sc_hd__fill_2
X_16560_ clknet_leaf_134_clk _01137_ VGND VGND VPWR VPWR cpuregs\[24\]\[12\] sky130_fd_sc_hd__dfxtp_1
XFILLER_0_139_110 VGND VGND VPWR VPWR sky130_fd_sc_hd__fill_2
X_15511_ clknet_leaf_60_clk _00161_ VGND VGND VPWR VPWR cpuregs\[30\]\[29\] sky130_fd_sc_hd__dfxtp_1
XFILLER_0_97_564 VGND VGND VPWR VPWR sky130_fd_sc_hd__fill_1
X_12723_ cpuregs\[8\]\[31\] cpuregs\[9\]\[31\] cpuregs\[10\]\[31\] cpuregs\[11\]\[31\]
+ _03980_ _03811_ VGND VGND VPWR VPWR _06257_ sky130_fd_sc_hd__mux4_1
XFILLER_0_127_305 VGND VGND VPWR VPWR sky130_fd_sc_hd__fill_1
XFILLER_0_85_748 VGND VGND VPWR VPWR sky130_fd_sc_hd__decap_8
X_16491_ clknet_leaf_136_clk _01073_ VGND VGND VPWR VPWR cpuregs\[19\]\[12\] sky130_fd_sc_hd__dfxtp_1
X_15442_ clknet_leaf_44_clk _00092_ VGND VGND VPWR VPWR net186 sky130_fd_sc_hd__dfxtp_4
X_12654_ _06206_ VGND VGND VPWR VPWR _00752_ sky130_fd_sc_hd__clkbuf_1
X_15373_ _03641_ net941 _02040_ VGND VGND VPWR VPWR _02074_ sky130_fd_sc_hd__mux2_1
X_12585_ _06156_ _06128_ _06157_ VGND VGND VPWR VPWR _06158_ sky130_fd_sc_hd__and3b_1
X_11605_ _04999_ net730 _05411_ VGND VGND VPWR VPWR _05419_ sky130_fd_sc_hd__mux2_1
X_14324_ net1412 _07587_ _07590_ _07594_ VGND VGND VPWR VPWR _01013_ sky130_fd_sc_hd__o22a_1
X_11536_ _05382_ VGND VGND VPWR VPWR _00458_ sky130_fd_sc_hd__clkbuf_1
XFILLER_0_111_48 VGND VGND VPWR VPWR sky130_fd_sc_hd__decap_4
X_14255_ net702 net121 _07518_ VGND VGND VPWR VPWR _07553_ sky130_fd_sc_hd__mux2_1
X_13206_ _06441_ _06680_ _06685_ _06692_ _06468_ VGND VGND VPWR VPWR _06693_ sky130_fd_sc_hd__a311o_1
X_11467_ _05345_ VGND VGND VPWR VPWR _00426_ sky130_fd_sc_hd__clkbuf_1
XFILLER_0_33_391 VGND VGND VPWR VPWR sky130_fd_sc_hd__fill_1
X_10418_ cpuregs\[22\]\[23\] cpuregs\[23\]\[23\] _03750_ VGND VGND VPWR VPWR _04631_
+ sky130_fd_sc_hd__mux2_1
X_14186_ _02114_ _07509_ _06290_ VGND VGND VPWR VPWR _07516_ sky130_fd_sc_hd__a21oi_1
X_11398_ net837 _05173_ _05302_ VGND VGND VPWR VPWR _05309_ sky130_fd_sc_hd__mux2_1
XFILLER_0_21_564 VGND VGND VPWR VPWR sky130_fd_sc_hd__fill_2
X_10349_ _04119_ _04563_ _04121_ VGND VGND VPWR VPWR _04564_ sky130_fd_sc_hd__a21o_1
X_13137_ _06455_ _06621_ _06625_ _06466_ VGND VGND VPWR VPWR _06626_ sky130_fd_sc_hd__o211a_1
XFILLER_0_21_575 VGND VGND VPWR VPWR sky130_fd_sc_hd__decap_4
XTAP_704 VGND VPWR sky130_fd_sc_hd__tapvpwrvgnd_1
XTAP_715 VGND VPWR sky130_fd_sc_hd__tapvpwrvgnd_1
X_13068_ cpuregs\[24\]\[8\] cpuregs\[25\]\[8\] cpuregs\[26\]\[8\] cpuregs\[27\]\[8\]
+ _06525_ _06558_ VGND VGND VPWR VPWR _06559_ sky130_fd_sc_hd__mux4_1
XFILLER_0_29_66 VPWR VGND VPWR VGND sky130_ef_sc_hd__decap_12
XTAP_726 VGND VPWR sky130_fd_sc_hd__tapvpwrvgnd_1
XTAP_737 VGND VPWR sky130_fd_sc_hd__tapvpwrvgnd_1
XTAP_748 VGND VPWR sky130_fd_sc_hd__tapvpwrvgnd_1
XTAP_759 VGND VPWR sky130_fd_sc_hd__tapvpwrvgnd_1
X_12019_ _05680_ _05661_ _05681_ VGND VGND VPWR VPWR _05682_ sky130_fd_sc_hd__and3b_1
XFILLER_0_136_45 VPWR VGND VPWR VGND sky130_ef_sc_hd__decap_12
X_16827_ clknet_leaf_111_clk _01391_ VGND VGND VPWR VPWR cpuregs\[7\]\[10\] sky130_fd_sc_hd__dfxtp_1
X_16758_ clknet_leaf_122_clk _01322_ VGND VGND VPWR VPWR cpuregs\[5\]\[5\] sky130_fd_sc_hd__dfxtp_1
XFILLER_0_48_417 VGND VGND VPWR VPWR sky130_fd_sc_hd__decap_3
X_15709_ clknet_leaf_127_clk _00359_ VGND VGND VPWR VPWR cpuregs\[21\]\[3\] sky130_fd_sc_hd__dfxtp_1
XFILLER_0_75_225 VGND VGND VPWR VPWR sky130_fd_sc_hd__decap_4
XFILLER_0_0_67 VGND VGND VPWR VPWR sky130_fd_sc_hd__fill_1
X_16689_ clknet_leaf_121_clk _01256_ VGND VGND VPWR VPWR cpuregs\[3\]\[3\] sky130_fd_sc_hd__dfxtp_1
X_09230_ _03490_ VGND VGND VPWR VPWR _03491_ sky130_fd_sc_hd__buf_2
XFILLER_0_91_729 VGND VGND VPWR VPWR sky130_fd_sc_hd__fill_1
XFILLER_0_61_75 VGND VGND VPWR VPWR sky130_fd_sc_hd__fill_1
XFILLER_0_28_141 VGND VGND VPWR VPWR sky130_fd_sc_hd__decap_4
X_09161_ _03295_ VGND VGND VPWR VPWR _03430_ sky130_fd_sc_hd__buf_4
X_08112_ _02501_ _02503_ _02498_ VGND VGND VPWR VPWR _02505_ sky130_fd_sc_hd__a21o_1
XFILLER_0_16_358 VGND VGND VPWR VPWR sky130_fd_sc_hd__decap_6
X_09092_ cpuregs\[8\]\[3\] cpuregs\[9\]\[3\] cpuregs\[10\]\[3\] cpuregs\[11\]\[3\]
+ _03323_ _03325_ VGND VGND VPWR VPWR _03372_ sky130_fd_sc_hd__mux4_1
X_08043_ reg_pc\[16\] decoded_imm\[16\] VGND VGND VPWR VPWR _02440_ sky130_fd_sc_hd__nand2_1
XFILLER_0_31_306 VGND VGND VPWR VPWR sky130_fd_sc_hd__fill_1
XFILLER_0_43_166 VGND VGND VPWR VPWR sky130_fd_sc_hd__fill_2
Xhold922 cpuregs\[18\]\[14\] VGND VGND VPWR VPWR net1280 sky130_fd_sc_hd__dlygate4sd3_1
XFILLER_0_71_497 VGND VGND VPWR VPWR sky130_fd_sc_hd__decap_6
Xhold900 cpuregs\[17\]\[10\] VGND VGND VPWR VPWR net1258 sky130_fd_sc_hd__dlygate4sd3_1
Xhold911 cpuregs\[23\]\[2\] VGND VGND VPWR VPWR net1269 sky130_fd_sc_hd__dlygate4sd3_1
XFILLER_0_12_531 VGND VGND VPWR VPWR sky130_fd_sc_hd__fill_1
XFILLER_0_43_199 VGND VGND VPWR VPWR sky130_fd_sc_hd__decap_3
Xhold944 cpuregs\[1\]\[23\] VGND VGND VPWR VPWR net1302 sky130_fd_sc_hd__dlygate4sd3_1
XFILLER_0_101_238 VGND VGND VPWR VPWR sky130_fd_sc_hd__fill_1
XFILLER_0_101_216 VGND VGND VPWR VPWR sky130_fd_sc_hd__fill_1
Xhold955 cpuregs\[25\]\[16\] VGND VGND VPWR VPWR net1313 sky130_fd_sc_hd__dlygate4sd3_1
XFILLER_0_12_553 VGND VGND VPWR VPWR sky130_fd_sc_hd__decap_6
Xhold933 cpuregs\[13\]\[5\] VGND VGND VPWR VPWR net1291 sky130_fd_sc_hd__dlygate4sd3_1
Xhold988 cpuregs\[2\]\[23\] VGND VGND VPWR VPWR net1346 sky130_fd_sc_hd__dlygate4sd3_1
X_09994_ _03732_ _04214_ _04218_ _03873_ VGND VGND VPWR VPWR _04219_ sky130_fd_sc_hd__o211a_1
Xhold977 cpuregs\[25\]\[6\] VGND VGND VPWR VPWR net1335 sky130_fd_sc_hd__dlygate4sd3_1
XFILLER_0_12_597 VGND VGND VPWR VPWR sky130_fd_sc_hd__decap_4
Xhold966 cpuregs\[1\]\[7\] VGND VGND VPWR VPWR net1324 sky130_fd_sc_hd__dlygate4sd3_1
Xhold999 cpuregs\[12\]\[22\] VGND VGND VPWR VPWR net1357 sky130_fd_sc_hd__dlygate4sd3_1
X_08945_ _03254_ VGND VGND VPWR VPWR net70 sky130_fd_sc_hd__clkbuf_4
XFILLER_0_99_818 VGND VGND VPWR VPWR sky130_fd_sc_hd__fill_2
X_08876_ _03213_ VGND VGND VPWR VPWR net104 sky130_fd_sc_hd__buf_4
X_07827_ count_instr\[33\] _02233_ _02235_ _02238_ VGND VGND VPWR VPWR _02239_ sky130_fd_sc_hd__a211o_1
X_07758_ _02170_ _02151_ _02176_ VGND VGND VPWR VPWR _02177_ sky130_fd_sc_hd__o21ai_1
XFILLER_0_94_512 VGND VGND VPWR VPWR sky130_fd_sc_hd__decap_4
XFILLER_0_66_225 VGND VGND VPWR VPWR sky130_fd_sc_hd__fill_2
X_07689_ cpu_state\[2\] VGND VGND VPWR VPWR _02116_ sky130_fd_sc_hd__inv_2
XFILLER_0_136_124 VGND VGND VPWR VPWR sky130_fd_sc_hd__fill_2
X_09428_ _00012_ VGND VGND VPWR VPWR _03664_ sky130_fd_sc_hd__clkbuf_8
XFILLER_0_136_135 VGND VGND VPWR VPWR sky130_fd_sc_hd__decap_4
X_09359_ _03602_ VGND VGND VPWR VPWR _03603_ sky130_fd_sc_hd__buf_2
X_12370_ _05791_ _05979_ VGND VGND VPWR VPWR _05980_ sky130_fd_sc_hd__nor2_1
XFILLER_0_90_784 VGND VGND VPWR VPWR sky130_fd_sc_hd__fill_1
X_11321_ _05268_ VGND VGND VPWR VPWR _00357_ sky130_fd_sc_hd__clkbuf_1
XFILLER_0_35_689 VGND VGND VPWR VPWR sky130_fd_sc_hd__fill_2
XFILLER_0_105_566 VGND VGND VPWR VPWR sky130_fd_sc_hd__fill_1
XFILLER_0_62_497 VGND VGND VPWR VPWR sky130_fd_sc_hd__fill_2
X_14040_ _07436_ VGND VGND VPWR VPWR _00893_ sky130_fd_sc_hd__clkbuf_1
X_11252_ _05231_ VGND VGND VPWR VPWR _00325_ sky130_fd_sc_hd__clkbuf_1
X_10203_ cpuregs\[16\]\[17\] cpuregs\[17\]\[17\] cpuregs\[18\]\[17\] cpuregs\[19\]\[17\]
+ _03902_ _03718_ VGND VGND VPWR VPWR _04422_ sky130_fd_sc_hd__mux4_1
X_11183_ net1142 _05184_ _05182_ VGND VGND VPWR VPWR _05185_ sky130_fd_sc_hd__mux2_1
X_10134_ _03738_ _04350_ _04354_ _03806_ VGND VGND VPWR VPWR _04355_ sky130_fd_sc_hd__o211a_1
X_15991_ clknet_leaf_1_clk _00641_ VGND VGND VPWR VPWR count_instr\[60\] sky130_fd_sc_hd__dfxtp_1
X_14942_ _03558_ net1264 _01840_ VGND VGND VPWR VPWR _01848_ sky130_fd_sc_hd__mux2_1
X_10065_ _03738_ _04283_ _04287_ _03806_ VGND VGND VPWR VPWR _04288_ sky130_fd_sc_hd__o211a_1
X_14873_ _01811_ VGND VGND VPWR VPWR _01301_ sky130_fd_sc_hd__clkbuf_1
X_16612_ clknet_leaf_78_clk _01179_ VGND VGND VPWR VPWR cpuregs\[9\]\[22\] sky130_fd_sc_hd__dfxtp_1
X_13824_ _07290_ _02836_ cpu_state\[3\] VGND VGND VPWR VPWR _07291_ sky130_fd_sc_hd__o21a_1
X_13755_ _06387_ _07224_ VGND VGND VPWR VPWR _07225_ sky130_fd_sc_hd__and2_1
X_16543_ clknet_leaf_10_clk _01120_ VGND VGND VPWR VPWR mem_rdata_q\[27\] sky130_fd_sc_hd__dfxtp_2
X_10967_ _05008_ net1378 _05063_ VGND VGND VPWR VPWR _05065_ sky130_fd_sc_hd__mux2_1
X_16474_ clknet_leaf_45_clk _01056_ VGND VGND VPWR VPWR cpuregs\[18\]\[27\] sky130_fd_sc_hd__dfxtp_1
X_13686_ cpuregs\[16\]\[27\] cpuregs\[17\]\[27\] cpuregs\[18\]\[27\] cpuregs\[19\]\[27\]
+ _06945_ _06979_ VGND VGND VPWR VPWR _07158_ sky130_fd_sc_hd__mux4_1
XFILLER_0_128_636 VGND VGND VPWR VPWR sky130_fd_sc_hd__decap_8
X_10898_ _05021_ VGND VGND VPWR VPWR _00181_ sky130_fd_sc_hd__clkbuf_1
X_12706_ _06244_ VGND VGND VPWR VPWR _00766_ sky130_fd_sc_hd__clkbuf_1
XFILLER_0_72_206 VGND VGND VPWR VPWR sky130_fd_sc_hd__fill_2
XFILLER_0_66_781 VGND VGND VPWR VPWR sky130_fd_sc_hd__fill_1
X_15425_ clknet_leaf_17_clk _00075_ VGND VGND VPWR VPWR net199 sky130_fd_sc_hd__dfxtp_4
X_12637_ _06193_ _06179_ _06194_ VGND VGND VPWR VPWR _06195_ sky130_fd_sc_hd__and3b_1
XFILLER_0_26_645 VPWR VGND VPWR VGND sky130_ef_sc_hd__decap_12
X_15356_ _02065_ VGND VGND VPWR VPWR _01530_ sky130_fd_sc_hd__clkbuf_1
XFILLER_0_53_464 VGND VGND VPWR VPWR sky130_fd_sc_hd__fill_1
X_12568_ count_cycle\[20\] _06142_ VGND VGND VPWR VPWR _06146_ sky130_fd_sc_hd__or2_1
X_15287_ net448 VGND VGND VPWR VPWR _02029_ sky130_fd_sc_hd__clkbuf_1
X_12499_ _06094_ _06097_ _05811_ VGND VGND VPWR VPWR _06098_ sky130_fd_sc_hd__mux2_1
X_14307_ mem_rdata_q\[22\] _07576_ VGND VGND VPWR VPWR _07584_ sky130_fd_sc_hd__and2_1
X_11519_ _05372_ VGND VGND VPWR VPWR _00451_ sky130_fd_sc_hd__clkbuf_1
Xhold207 _02145_ VGND VGND VPWR VPWR net565 sky130_fd_sc_hd__dlygate4sd3_1
XFILLER_0_40_103 VGND VGND VPWR VPWR sky130_fd_sc_hd__decap_8
Xhold229 cpuregs\[14\]\[23\] VGND VGND VPWR VPWR net587 sky130_fd_sc_hd__dlygate4sd3_1
Xhold218 decoded_imm\[22\] VGND VGND VPWR VPWR net576 sky130_fd_sc_hd__dlygate4sd3_1
XFILLER_0_0_211 VGND VGND VPWR VPWR sky130_fd_sc_hd__fill_2
X_14238_ _07544_ VGND VGND VPWR VPWR _00977_ sky130_fd_sc_hd__clkbuf_1
X_14169_ _05049_ net1555 _07470_ VGND VGND VPWR VPWR _07505_ sky130_fd_sc_hd__mux2_1
XFILLER_0_0_233 VGND VGND VPWR VPWR sky130_fd_sc_hd__fill_2
XFILLER_0_1_756 VPWR VGND VPWR VGND sky130_ef_sc_hd__decap_12
XFILLER_0_21_361 VGND VGND VPWR VPWR sky130_fd_sc_hd__fill_1
XFILLER_0_0_277 VGND VGND VPWR VPWR sky130_fd_sc_hd__decap_3
XTAP_501 VGND VPWR sky130_fd_sc_hd__tapvpwrvgnd_1
XTAP_512 VGND VPWR sky130_fd_sc_hd__tapvpwrvgnd_1
XTAP_523 VGND VPWR sky130_fd_sc_hd__tapvpwrvgnd_1
XTAP_534 VGND VPWR sky130_fd_sc_hd__tapvpwrvgnd_1
XTAP_545 VGND VPWR sky130_fd_sc_hd__tapvpwrvgnd_1
XTAP_556 VGND VPWR sky130_fd_sc_hd__tapvpwrvgnd_1
XTAP_567 VGND VPWR sky130_fd_sc_hd__tapvpwrvgnd_1
X_08730_ net185 _03087_ VGND VGND VPWR VPWR _03089_ sky130_fd_sc_hd__or2_1
XFILLER_0_56_42 VGND VGND VPWR VPWR sky130_fd_sc_hd__fill_2
XTAP_589 VGND VPWR sky130_fd_sc_hd__tapvpwrvgnd_1
XTAP_578 VGND VPWR sky130_fd_sc_hd__tapvpwrvgnd_1
X_08661_ _02445_ _03025_ VGND VGND VPWR VPWR _03026_ sky130_fd_sc_hd__xnor2_1
X_08592_ _02680_ _02895_ _02961_ VGND VGND VPWR VPWR _02962_ sky130_fd_sc_hd__a21o_1
XFILLER_0_49_726 VGND VGND VPWR VPWR sky130_fd_sc_hd__fill_2
XFILLER_0_118_124 VPWR VGND VPWR VGND sky130_ef_sc_hd__decap_12
XFILLER_0_76_589 VGND VGND VPWR VPWR sky130_fd_sc_hd__decap_4
XFILLER_0_63_206 VGND VGND VPWR VPWR sky130_fd_sc_hd__decap_4
X_09213_ reg_out\[5\] alu_out_q\[5\] latched_stalu VGND VGND VPWR VPWR _03476_ sky130_fd_sc_hd__mux2_1
XFILLER_0_133_105 VGND VGND VPWR VPWR sky130_fd_sc_hd__decap_6
XFILLER_0_118_179 VPWR VGND VPWR VGND sky130_ef_sc_hd__decap_12
X_09144_ _03421_ VGND VGND VPWR VPWR _01113_ sky130_fd_sc_hd__buf_1
XFILLER_0_16_111 VGND VGND VPWR VPWR sky130_fd_sc_hd__fill_2
XFILLER_0_72_784 VGND VGND VPWR VPWR sky130_fd_sc_hd__decap_6
X_09075_ _03311_ _03351_ _03355_ _03308_ VGND VGND VPWR VPWR _03356_ sky130_fd_sc_hd__o211a_1
XFILLER_0_130_823 VGND VGND VPWR VPWR sky130_fd_sc_hd__decap_3
Xhold730 cpuregs\[11\]\[18\] VGND VGND VPWR VPWR net1088 sky130_fd_sc_hd__dlygate4sd3_1
X_08026_ _02409_ _02410_ _02411_ VGND VGND VPWR VPWR _02424_ sky130_fd_sc_hd__a21bo_1
Xhold752 cpuregs\[1\]\[22\] VGND VGND VPWR VPWR net1110 sky130_fd_sc_hd__dlygate4sd3_1
Xhold741 cpuregs\[10\]\[24\] VGND VGND VPWR VPWR net1099 sky130_fd_sc_hd__dlygate4sd3_1
Xhold763 cpuregs\[5\]\[3\] VGND VGND VPWR VPWR net1121 sky130_fd_sc_hd__dlygate4sd3_1
Xhold774 cpuregs\[31\]\[21\] VGND VGND VPWR VPWR net1132 sky130_fd_sc_hd__dlygate4sd3_1
Xhold796 cpuregs\[20\]\[5\] VGND VGND VPWR VPWR net1154 sky130_fd_sc_hd__dlygate4sd3_1
Xhold785 mem_rdata_q\[0\] VGND VGND VPWR VPWR net1143 sky130_fd_sc_hd__dlygate4sd3_1
X_09977_ cpuregs\[2\]\[11\] cpuregs\[3\]\[11\] _04194_ VGND VGND VPWR VPWR _04202_
+ sky130_fd_sc_hd__mux2_1
X_08928_ _03242_ VGND VGND VPWR VPWR net95 sky130_fd_sc_hd__clkbuf_4
XFILLER_0_99_626 VGND VGND VPWR VPWR sky130_fd_sc_hd__decap_4
XFILLER_0_98_136 VGND VGND VPWR VPWR sky130_fd_sc_hd__decap_4
X_08859_ _02143_ _02751_ _02671_ _02187_ VGND VGND VPWR VPWR _03205_ sky130_fd_sc_hd__a22o_1
X_11870_ _05574_ VGND VGND VPWR VPWR _00600_ sky130_fd_sc_hd__clkbuf_1
X_10821_ _04971_ VGND VGND VPWR VPWR _00154_ sky130_fd_sc_hd__clkbuf_1
XFILLER_0_39_214 VGND VGND VPWR VPWR sky130_fd_sc_hd__fill_1
X_10752_ _04933_ VGND VGND VPWR VPWR _00123_ sky130_fd_sc_hd__clkbuf_1
X_13540_ cpuregs\[24\]\[22\] cpuregs\[25\]\[22\] cpuregs\[26\]\[22\] cpuregs\[27\]\[22\]
+ _06856_ _06889_ VGND VGND VPWR VPWR _07017_ sky130_fd_sc_hd__mux4_1
XFILLER_0_109_113 VGND VGND VPWR VPWR sky130_fd_sc_hd__fill_1
XFILLER_0_109_102 VGND VGND VPWR VPWR sky130_fd_sc_hd__decap_4
XFILLER_0_39_269 VGND VGND VPWR VPWR sky130_fd_sc_hd__fill_2
XFILLER_0_109_135 VGND VGND VPWR VPWR sky130_fd_sc_hd__fill_2
X_13471_ _06682_ _06949_ VGND VGND VPWR VPWR _06950_ sky130_fd_sc_hd__and2_1
X_12422_ _06026_ _06027_ VGND VGND VPWR VPWR _06028_ sky130_fd_sc_hd__xor2_1
X_10683_ _03744_ _04884_ _04888_ _03885_ VGND VGND VPWR VPWR _04889_ sky130_fd_sc_hd__o211a_1
X_15210_ _03544_ net1359 _01984_ VGND VGND VPWR VPWR _01990_ sky130_fd_sc_hd__mux2_1
XFILLER_0_48_792 VGND VGND VPWR VPWR sky130_fd_sc_hd__fill_2
XFILLER_0_35_420 VPWR VGND VPWR VGND sky130_ef_sc_hd__decap_12
XFILLER_0_23_615 VGND VGND VPWR VPWR sky130_fd_sc_hd__fill_1
X_16190_ clknet_leaf_139_clk _00807_ VGND VGND VPWR VPWR net108 sky130_fd_sc_hd__dfxtp_2
X_12353_ _05731_ _05956_ VGND VGND VPWR VPWR _05965_ sky130_fd_sc_hd__nand2_1
XFILLER_0_90_592 VGND VGND VPWR VPWR sky130_fd_sc_hd__fill_2
X_15141_ _01953_ VGND VGND VPWR VPWR _01427_ sky130_fd_sc_hd__clkbuf_1
XFILLER_0_22_114 VGND VGND VPWR VPWR sky130_fd_sc_hd__fill_2
XFILLER_0_133_683 VGND VGND VPWR VPWR sky130_fd_sc_hd__fill_2
X_11304_ _05258_ VGND VGND VPWR VPWR _00350_ sky130_fd_sc_hd__clkbuf_1
X_12284_ _05879_ _05889_ VGND VGND VPWR VPWR _05901_ sky130_fd_sc_hd__and2_1
X_15072_ net816 _05190_ _01912_ VGND VGND VPWR VPWR _01917_ sky130_fd_sc_hd__mux2_1
XFILLER_0_132_193 VGND VGND VPWR VPWR sky130_fd_sc_hd__decap_3
X_11235_ net1169 _05219_ _05203_ VGND VGND VPWR VPWR _05220_ sky130_fd_sc_hd__mux2_1
X_14023_ decoded_imm_j\[7\] _01120_ _03430_ VGND VGND VPWR VPWR _07428_ sky130_fd_sc_hd__mux2_1
XFILLER_0_50_489 VGND VGND VPWR VPWR sky130_fd_sc_hd__fill_1
XFILLER_0_10_309 VGND VGND VPWR VPWR sky130_fd_sc_hd__decap_3
XFILLER_0_30_180 VGND VGND VPWR VPWR sky130_fd_sc_hd__decap_3
X_11166_ _03483_ VGND VGND VPWR VPWR _05173_ sky130_fd_sc_hd__clkbuf_4
X_10117_ cpuregs\[2\]\[15\] cpuregs\[3\]\[15\] _03768_ VGND VGND VPWR VPWR _04338_
+ sky130_fd_sc_hd__mux2_1
X_15974_ clknet_leaf_145_clk _00624_ VGND VGND VPWR VPWR count_instr\[43\] sky130_fd_sc_hd__dfxtp_1
X_11097_ _05133_ VGND VGND VPWR VPWR _00268_ sky130_fd_sc_hd__clkbuf_1
X_10048_ cpuregs\[2\]\[13\] cpuregs\[3\]\[13\] _03768_ VGND VGND VPWR VPWR _04271_
+ sky130_fd_sc_hd__mux2_1
X_14925_ _03504_ net1586 _01829_ VGND VGND VPWR VPWR _01839_ sky130_fd_sc_hd__mux2_1
Xhold90 cpuregs\[0\]\[21\] VGND VGND VPWR VPWR net448 sky130_fd_sc_hd__dlygate4sd3_1
XFILLER_0_89_125 VGND VGND VPWR VPWR sky130_fd_sc_hd__decap_3
XFILLER_0_26_45 VGND VGND VPWR VPWR sky130_fd_sc_hd__decap_3
XFILLER_0_89_169 VGND VGND VPWR VPWR sky130_fd_sc_hd__decap_6
X_14856_ _01802_ VGND VGND VPWR VPWR _01293_ sky130_fd_sc_hd__clkbuf_1
X_13807_ _06382_ _07274_ VGND VGND VPWR VPWR _07275_ sky130_fd_sc_hd__or2_1
X_14787_ _01765_ VGND VGND VPWR VPWR _01261_ sky130_fd_sc_hd__clkbuf_1
XFILLER_0_133_57 VPWR VGND VPWR VGND sky130_ef_sc_hd__decap_12
X_13738_ cpuregs\[4\]\[29\] cpuregs\[5\]\[29\] _06906_ VGND VGND VPWR VPWR _07208_
+ sky130_fd_sc_hd__mux2_1
X_16526_ clknet_leaf_14_clk _01103_ VGND VGND VPWR VPWR mem_rdata_q\[10\] sky130_fd_sc_hd__dfxtp_1
X_11999_ count_instr\[55\] count_instr\[54\] _05664_ VGND VGND VPWR VPWR _05668_ sky130_fd_sc_hd__and3_1
XFILLER_0_128_477 VGND VGND VPWR VPWR sky130_fd_sc_hd__decap_8
X_13669_ _06415_ _07128_ _07141_ _02181_ decoded_imm\[26\] VGND VGND VPWR VPWR _07142_
+ sky130_fd_sc_hd__a32o_1
X_16457_ clknet_leaf_17_clk _01039_ VGND VGND VPWR VPWR cpuregs\[18\]\[10\] sky130_fd_sc_hd__dfxtp_1
X_15408_ clknet_leaf_80_clk _00063_ VGND VGND VPWR VPWR cpuregs\[11\]\[26\] sky130_fd_sc_hd__dfxtp_1
XFILLER_0_60_209 VPWR VGND VPWR VGND sky130_ef_sc_hd__decap_12
XFILLER_0_53_250 VGND VGND VPWR VPWR sky130_fd_sc_hd__decap_3
X_16388_ clknet_leaf_154_clk _00970_ VGND VGND VPWR VPWR net141 sky130_fd_sc_hd__dfxtp_1
X_15339_ _02056_ VGND VGND VPWR VPWR _01522_ sky130_fd_sc_hd__clkbuf_1
XFILLER_0_26_486 VGND VGND VPWR VPWR sky130_fd_sc_hd__fill_1
X_09900_ _03668_ VGND VGND VPWR VPWR _04127_ sky130_fd_sc_hd__clkbuf_8
XFILLER_0_13_169 VGND VGND VPWR VPWR sky130_fd_sc_hd__fill_1
XFILLER_0_67_41 VGND VGND VPWR VPWR sky130_fd_sc_hd__fill_2
XFILLER_0_67_30 VGND VGND VPWR VPWR sky130_fd_sc_hd__decap_6
XFILLER_0_6_66 VGND VGND VPWR VPWR sky130_fd_sc_hd__fill_2
XFILLER_0_1_564 VGND VGND VPWR VPWR sky130_fd_sc_hd__fill_1
XTAP_342 VGND VPWR sky130_fd_sc_hd__tapvpwrvgnd_1
XTAP_331 VGND VPWR sky130_fd_sc_hd__tapvpwrvgnd_1
XTAP_320 VGND VPWR sky130_fd_sc_hd__tapvpwrvgnd_1
X_09831_ cpuregs\[28\]\[7\] cpuregs\[29\]\[7\] _03749_ VGND VGND VPWR VPWR _04060_
+ sky130_fd_sc_hd__mux2_1
X_09762_ _03959_ _03973_ _03991_ _03992_ reg_pc\[5\] VGND VGND VPWR VPWR _03993_ sky130_fd_sc_hd__a32o_1
XTAP_375 VGND VPWR sky130_fd_sc_hd__tapvpwrvgnd_1
XTAP_364 VGND VPWR sky130_fd_sc_hd__tapvpwrvgnd_1
XTAP_353 VGND VPWR sky130_fd_sc_hd__tapvpwrvgnd_1
X_08713_ _03021_ _03069_ _03073_ VGND VGND VPWR VPWR _03074_ sky130_fd_sc_hd__a21oi_2
XTAP_397 VGND VPWR sky130_fd_sc_hd__tapvpwrvgnd_1
XTAP_386 VGND VPWR sky130_fd_sc_hd__tapvpwrvgnd_1
X_09693_ cpuregs\[20\]\[4\] cpuregs\[21\]\[4\] _03667_ VGND VGND VPWR VPWR _03925_
+ sky130_fd_sc_hd__mux2_1
Xrebuffer11 net370 VGND VGND VPWR VPWR net369 sky130_fd_sc_hd__clkbuf_1
XTAP_2209 VGND VPWR sky130_fd_sc_hd__tapvpwrvgnd_1
X_08644_ _02849_ _03007_ _03010_ VGND VGND VPWR VPWR alu_out\[14\] sky130_fd_sc_hd__a21o_1
XFILLER_0_83_73 VGND VGND VPWR VPWR sky130_fd_sc_hd__decap_6
XFILLER_0_68_309 VGND VGND VPWR VPWR sky130_fd_sc_hd__decap_6
Xrebuffer22 _05557_ VGND VGND VPWR VPWR net380 sky130_fd_sc_hd__clkbuf_1
X_08575_ _02352_ _02946_ VGND VGND VPWR VPWR _02947_ sky130_fd_sc_hd__nand2_1
XTAP_1519 VGND VPWR sky130_fd_sc_hd__tapvpwrvgnd_1
XTAP_1508 VGND VPWR sky130_fd_sc_hd__tapvpwrvgnd_1
XPHY_15 VGND VGND VPWR VPWR sky130_fd_sc_hd__decap_3
XPHY_26 VGND VGND VPWR VPWR sky130_fd_sc_hd__decap_3
XPHY_37 VGND VGND VPWR VPWR sky130_fd_sc_hd__decap_3
XPHY_48 VGND VGND VPWR VPWR sky130_fd_sc_hd__decap_3
XPHY_59 VGND VGND VPWR VPWR sky130_fd_sc_hd__decap_3
XFILLER_0_119_455 VGND VGND VPWR VPWR sky130_fd_sc_hd__decap_4
XFILLER_0_92_813 VGND VGND VPWR VPWR sky130_fd_sc_hd__fill_1
XFILLER_0_49_578 VGND VGND VPWR VPWR sky130_fd_sc_hd__fill_2
XFILLER_0_37_729 VGND VGND VPWR VPWR sky130_fd_sc_hd__fill_2
XFILLER_0_103_801 VGND VGND VPWR VPWR sky130_fd_sc_hd__fill_1
X_09127_ cpuregs\[24\]\[4\] cpuregs\[25\]\[4\] cpuregs\[26\]\[4\] cpuregs\[27\]\[4\]
+ _03336_ _03337_ VGND VGND VPWR VPWR _03406_ sky130_fd_sc_hd__mux4_1
XFILLER_0_17_497 VGND VGND VPWR VPWR sky130_fd_sc_hd__fill_1
XFILLER_0_130_620 VGND VGND VPWR VPWR sky130_fd_sc_hd__decap_4
X_09058_ _03318_ _03338_ VGND VGND VPWR VPWR _03339_ sky130_fd_sc_hd__or2_1
X_08009_ reg_pc\[12\] decoded_imm\[12\] _02398_ VGND VGND VPWR VPWR _02408_ sky130_fd_sc_hd__nand3_1
XFILLER_0_13_670 VGND VGND VPWR VPWR sky130_fd_sc_hd__fill_2
Xhold571 cpuregs\[18\]\[24\] VGND VGND VPWR VPWR net929 sky130_fd_sc_hd__dlygate4sd3_1
Xhold560 cpuregs\[4\]\[12\] VGND VGND VPWR VPWR net918 sky130_fd_sc_hd__dlygate4sd3_1
XFILLER_0_12_191 VGND VGND VPWR VPWR sky130_fd_sc_hd__fill_1
Xhold582 cpuregs\[8\]\[23\] VGND VGND VPWR VPWR net940 sky130_fd_sc_hd__dlygate4sd3_1
Xhold593 reg_next_pc\[20\] VGND VGND VPWR VPWR net951 sky130_fd_sc_hd__dlygate4sd3_1
X_11020_ net1501 _03472_ _05088_ VGND VGND VPWR VPWR _05093_ sky130_fd_sc_hd__mux2_1
Xhold1260 _01014_ VGND VGND VPWR VPWR net1618 sky130_fd_sc_hd__dlygate4sd3_1
X_12971_ _06459_ _06460_ _06464_ _03328_ VGND VGND VPWR VPWR _06465_ sky130_fd_sc_hd__a211o_1
Xhold1293 cpuregs\[25\]\[23\] VGND VGND VPWR VPWR net1651 sky130_fd_sc_hd__dlygate4sd3_1
Xhold1282 reg_pc\[30\] VGND VGND VPWR VPWR net1640 sky130_fd_sc_hd__dlygate4sd3_1
XFILLER_0_87_607 VGND VGND VPWR VPWR sky130_fd_sc_hd__decap_3
X_15690_ clknet_leaf_18_clk _00340_ VGND VGND VPWR VPWR cpuregs\[27\]\[16\] sky130_fd_sc_hd__dfxtp_1
X_14710_ _04993_ net1532 _01720_ VGND VGND VPWR VPWR _01725_ sky130_fd_sc_hd__mux2_1
X_11922_ count_instr\[34\] _05609_ VGND VGND VPWR VPWR _05612_ sky130_fd_sc_hd__and2_1
Xhold1271 _02318_ VGND VGND VPWR VPWR net1629 sky130_fd_sc_hd__dlygate4sd3_1
X_11853_ count_instr\[15\] count_instr\[14\] _05557_ VGND VGND VPWR VPWR _05562_ sky130_fd_sc_hd__and3_1
X_14641_ _01688_ VGND VGND VPWR VPWR _01192_ sky130_fd_sc_hd__clkbuf_1
XFILLER_0_95_640 VGND VGND VPWR VPWR sky130_fd_sc_hd__fill_1
XFILLER_0_79_180 VGND VGND VPWR VPWR sky130_fd_sc_hd__decap_8
X_10804_ _04962_ VGND VGND VPWR VPWR _00146_ sky130_fd_sc_hd__clkbuf_1
XFILLER_0_28_707 VGND VGND VPWR VPWR sky130_fd_sc_hd__decap_3
X_11784_ _05513_ VGND VGND VPWR VPWR _00575_ sky130_fd_sc_hd__clkbuf_1
X_16311_ clknet_leaf_33_clk _00896_ VGND VGND VPWR VPWR decoded_imm_j\[20\] sky130_fd_sc_hd__dfxtp_1
X_14572_ _04991_ net1090 _01648_ VGND VGND VPWR VPWR _01652_ sky130_fd_sc_hd__mux2_1
X_13523_ _06868_ _06996_ _06999_ VGND VGND VPWR VPWR _07000_ sky130_fd_sc_hd__a21o_1
X_10735_ _04924_ VGND VGND VPWR VPWR _00115_ sky130_fd_sc_hd__clkbuf_1
XFILLER_0_137_274 VGND VGND VPWR VPWR sky130_fd_sc_hd__decap_6
X_10666_ _04869_ _04870_ _04871_ _04832_ VGND VGND VPWR VPWR _04872_ sky130_fd_sc_hd__a211o_1
X_16242_ clknet_leaf_31_clk alu_out\[15\] VGND VGND VPWR VPWR alu_out_q\[15\] sky130_fd_sc_hd__dfxtp_1
X_13454_ cpuregs\[10\]\[20\] cpuregs\[11\]\[20\] _06766_ VGND VGND VPWR VPWR _06933_
+ sky130_fd_sc_hd__mux2_1
XFILLER_0_12_47 VGND VGND VPWR VPWR sky130_fd_sc_hd__decap_3
X_13385_ _06343_ VGND VGND VPWR VPWR _06866_ sky130_fd_sc_hd__buf_4
X_12405_ _05852_ net537 _05816_ _06012_ VGND VGND VPWR VPWR _00697_ sky130_fd_sc_hd__o211a_1
XFILLER_0_88_18 VGND VGND VPWR VPWR sky130_fd_sc_hd__fill_2
X_16173_ clknet_leaf_117_clk _00791_ VGND VGND VPWR VPWR net46 sky130_fd_sc_hd__dfxtp_1
X_10597_ _03738_ _04800_ _04804_ _03684_ VGND VGND VPWR VPWR _04805_ sky130_fd_sc_hd__o211a_1
XFILLER_0_106_661 VGND VGND VPWR VPWR sky130_fd_sc_hd__fill_2
XFILLER_0_88_29 VGND VGND VPWR VPWR sky130_fd_sc_hd__fill_2
XFILLER_0_2_306 VGND VGND VPWR VPWR sky130_fd_sc_hd__fill_2
X_15124_ _01944_ VGND VGND VPWR VPWR _01419_ sky130_fd_sc_hd__clkbuf_1
Xoutput109 net109 VGND VGND VPWR VPWR mem_la_wdata[20] sky130_fd_sc_hd__clkbuf_4
X_12336_ _05936_ VGND VGND VPWR VPWR _05949_ sky130_fd_sc_hd__inv_2
XFILLER_0_50_253 VGND VGND VPWR VPWR sky130_fd_sc_hd__fill_2
XFILLER_0_120_152 VGND VGND VPWR VPWR sky130_fd_sc_hd__decap_8
X_12267_ _05884_ _05885_ _05785_ _05715_ VGND VGND VPWR VPWR _05886_ sky130_fd_sc_hd__a2bb2o_1
X_15055_ net902 _05173_ _01901_ VGND VGND VPWR VPWR _01908_ sky130_fd_sc_hd__mux2_1
XFILLER_0_121_697 VGND VGND VPWR VPWR sky130_fd_sc_hd__decap_4
XFILLER_0_120_185 VGND VGND VPWR VPWR sky130_fd_sc_hd__decap_8
X_11218_ _05208_ VGND VGND VPWR VPWR _00314_ sky130_fd_sc_hd__clkbuf_1
X_12198_ _05819_ _05820_ VGND VGND VPWR VPWR _05822_ sky130_fd_sc_hd__nand2_1
X_14006_ mem_rdata_q\[20\] _07411_ mem_rdata_q\[21\] VGND VGND VPWR VPWR _07419_ sky130_fd_sc_hd__nor3b_1
Xoutput80 net80 VGND VGND VPWR VPWR mem_la_addr[24] sky130_fd_sc_hd__clkbuf_4
X_11149_ net758 _05159_ _05161_ VGND VGND VPWR VPWR _05162_ sky130_fd_sc_hd__mux2_1
Xoutput91 net91 VGND VGND VPWR VPWR mem_la_addr[5] sky130_fd_sc_hd__clkbuf_4
X_15957_ clknet_leaf_154_clk _00607_ VGND VGND VPWR VPWR count_instr\[26\] sky130_fd_sc_hd__dfxtp_1
XFILLER_0_37_99 VPWR VGND VPWR VGND sky130_ef_sc_hd__decap_12
X_15888_ clknet_leaf_48_clk _00538_ VGND VGND VPWR VPWR cpuregs\[20\]\[22\] sky130_fd_sc_hd__dfxtp_1
X_14908_ _01830_ VGND VGND VPWR VPWR _01317_ sky130_fd_sc_hd__clkbuf_1
X_14839_ _03440_ net1442 _01793_ VGND VGND VPWR VPWR _01794_ sky130_fd_sc_hd__mux2_1
X_08360_ net194 net226 VGND VGND VPWR VPWR _02741_ sky130_fd_sc_hd__nand2_1
XFILLER_0_18_217 VPWR VGND VPWR VGND sky130_ef_sc_hd__decap_12
X_16509_ clknet_leaf_53_clk _01091_ VGND VGND VPWR VPWR cpuregs\[19\]\[30\] sky130_fd_sc_hd__dfxtp_1
X_08291_ net201 _02671_ VGND VGND VPWR VPWR _02672_ sky130_fd_sc_hd__or2_1
XFILLER_0_41_242 VGND VGND VPWR VPWR sky130_fd_sc_hd__decap_4
XFILLER_0_78_51 VGND VGND VPWR VPWR sky130_fd_sc_hd__fill_1
XFILLER_0_111_152 VGND VGND VPWR VPWR sky130_fd_sc_hd__fill_1
X_09814_ cpuregs\[4\]\[7\] cpuregs\[5\]\[7\] cpuregs\[6\]\[7\] cpuregs\[7\]\[7\] _03881_
+ _03718_ VGND VGND VPWR VPWR _04043_ sky130_fd_sc_hd__mux4_1
X_09745_ _03880_ VGND VGND VPWR VPWR _03976_ sky130_fd_sc_hd__buf_4
XTAP_2006 VGND VPWR sky130_fd_sc_hd__tapvpwrvgnd_1
X_09676_ _02082_ _03860_ _03861_ _03862_ _03908_ VGND VGND VPWR VPWR _03909_ sky130_fd_sc_hd__a32o_1
XTAP_2039 VGND VPWR sky130_fd_sc_hd__tapvpwrvgnd_1
XTAP_2017 VGND VPWR sky130_fd_sc_hd__tapvpwrvgnd_1
XTAP_2028 VGND VPWR sky130_fd_sc_hd__tapvpwrvgnd_1
X_08627_ _02993_ _02994_ VGND VGND VPWR VPWR _02995_ sky130_fd_sc_hd__nor2_1
XTAP_1305 VGND VPWR sky130_fd_sc_hd__tapvpwrvgnd_1
XTAP_1338 VGND VPWR sky130_fd_sc_hd__tapvpwrvgnd_1
XTAP_1327 VGND VPWR sky130_fd_sc_hd__tapvpwrvgnd_1
XTAP_1316 VGND VPWR sky130_fd_sc_hd__tapvpwrvgnd_1
XFILLER_0_68_139 VGND VGND VPWR VPWR sky130_fd_sc_hd__fill_1
X_08558_ _02325_ _02924_ VGND VGND VPWR VPWR _02931_ sky130_fd_sc_hd__nand2_1
XTAP_1349 VGND VPWR sky130_fd_sc_hd__tapvpwrvgnd_1
XFILLER_0_76_194 VGND VGND VPWR VPWR sky130_fd_sc_hd__fill_2
X_08489_ _02864_ _02865_ _02867_ VGND VGND VPWR VPWR _02868_ sky130_fd_sc_hd__o21a_1
XFILLER_0_134_200 VGND VGND VPWR VPWR sky130_fd_sc_hd__fill_1
X_10520_ cpuregs\[14\]\[26\] cpuregs\[15\]\[26\] _03756_ VGND VGND VPWR VPWR _04730_
+ sky130_fd_sc_hd__mux2_1
XFILLER_0_91_153 VGND VGND VPWR VPWR sky130_fd_sc_hd__decap_3
XFILLER_0_24_209 VGND VGND VPWR VPWR sky130_fd_sc_hd__fill_1
X_10451_ cpuregs\[24\]\[24\] cpuregs\[25\]\[24\] cpuregs\[26\]\[24\] cpuregs\[27\]\[24\]
+ _03751_ _03929_ VGND VGND VPWR VPWR _04663_ sky130_fd_sc_hd__mux4_1
XFILLER_0_32_220 VGND VGND VPWR VPWR sky130_fd_sc_hd__decap_8
XFILLER_0_33_765 VGND VGND VPWR VPWR sky130_fd_sc_hd__fill_2
X_10382_ cpuregs\[2\]\[22\] cpuregs\[3\]\[22\] _03977_ VGND VGND VPWR VPWR _04596_
+ sky130_fd_sc_hd__mux2_1
X_13170_ _06461_ _06657_ VGND VGND VPWR VPWR _06658_ sky130_fd_sc_hd__and2_1
XFILLER_0_32_253 VGND VGND VPWR VPWR sky130_fd_sc_hd__decap_3
XFILLER_0_33_776 VGND VGND VPWR VPWR sky130_fd_sc_hd__fill_2
X_12121_ _05735_ _05753_ _05754_ _05730_ VGND VGND VPWR VPWR _00671_ sky130_fd_sc_hd__o211a_1
XFILLER_0_102_130 VGND VGND VPWR VPWR sky130_fd_sc_hd__fill_1
XFILLER_0_20_448 VGND VGND VPWR VPWR sky130_fd_sc_hd__fill_1
X_12052_ _03489_ reg_next_pc\[7\] _03221_ VGND VGND VPWR VPWR _05706_ sky130_fd_sc_hd__mux2_2
Xhold390 cpuregs\[3\]\[12\] VGND VGND VPWR VPWR net748 sky130_fd_sc_hd__dlygate4sd3_1
X_11003_ _05083_ VGND VGND VPWR VPWR _00224_ sky130_fd_sc_hd__clkbuf_1
X_16860_ clknet_leaf_135_clk _01424_ VGND VGND VPWR VPWR cpuregs\[22\]\[11\] sky130_fd_sc_hd__dfxtp_1
X_16791_ clknet_leaf_118_clk _01355_ VGND VGND VPWR VPWR cpuregs\[6\]\[6\] sky130_fd_sc_hd__dfxtp_1
X_15811_ clknet_leaf_138_clk _00461_ VGND VGND VPWR VPWR cpuregs\[16\]\[9\] sky130_fd_sc_hd__dfxtp_1
XFILLER_0_99_242 VGND VGND VPWR VPWR sky130_fd_sc_hd__decap_6
X_15742_ clknet_leaf_124_clk _00392_ VGND VGND VPWR VPWR cpuregs\[15\]\[4\] sky130_fd_sc_hd__dfxtp_1
X_12954_ _06349_ VGND VGND VPWR VPWR _06448_ sky130_fd_sc_hd__buf_4
Xhold1090 cpuregs\[21\]\[29\] VGND VGND VPWR VPWR net1448 sky130_fd_sc_hd__dlygate4sd3_1
XFILLER_0_59_117 VGND VGND VPWR VPWR sky130_fd_sc_hd__fill_1
X_11905_ count_instr\[29\] _05597_ VGND VGND VPWR VPWR _05600_ sky130_fd_sc_hd__or2_1
XFILLER_0_114_15 VGND VGND VPWR VPWR sky130_fd_sc_hd__decap_6
X_15673_ clknet_leaf_94_clk _00323_ VGND VGND VPWR VPWR cpuregs\[14\]\[31\] sky130_fd_sc_hd__dfxtp_1
X_12885_ _03322_ VGND VGND VPWR VPWR _06383_ sky130_fd_sc_hd__clkbuf_8
X_14624_ _05043_ net1580 _01670_ VGND VGND VPWR VPWR _01679_ sky130_fd_sc_hd__mux2_1
XFILLER_0_114_37 VPWR VGND VPWR VGND sky130_ef_sc_hd__decap_12
XTAP_1861 VGND VPWR sky130_fd_sc_hd__tapvpwrvgnd_1
XTAP_1850 VGND VPWR sky130_fd_sc_hd__tapvpwrvgnd_1
X_11836_ count_instr\[10\] _05547_ VGND VGND VPWR VPWR _05550_ sky130_fd_sc_hd__and2_1
X_14555_ _01642_ VGND VGND VPWR VPWR _01152_ sky130_fd_sc_hd__clkbuf_1
XFILLER_0_126_701 VGND VGND VPWR VPWR sky130_fd_sc_hd__decap_8
XTAP_1894 VGND VPWR sky130_fd_sc_hd__tapvpwrvgnd_1
XTAP_1883 VGND VPWR sky130_fd_sc_hd__tapvpwrvgnd_1
XTAP_1872 VGND VPWR sky130_fd_sc_hd__tapvpwrvgnd_1
X_11767_ _05504_ VGND VGND VPWR VPWR _00567_ sky130_fd_sc_hd__clkbuf_1
XFILLER_0_23_57 VGND VGND VPWR VPWR sky130_fd_sc_hd__fill_1
X_13506_ _06682_ _06983_ VGND VGND VPWR VPWR _06984_ sky130_fd_sc_hd__and2_1
XFILLER_0_83_654 VGND VGND VPWR VPWR sky130_fd_sc_hd__fill_1
XFILLER_0_71_805 VGND VGND VPWR VPWR sky130_fd_sc_hd__decap_3
X_10718_ _04915_ VGND VGND VPWR VPWR _00107_ sky130_fd_sc_hd__clkbuf_1
X_14486_ net739 _05217_ _01598_ VGND VGND VPWR VPWR _01606_ sky130_fd_sc_hd__mux2_1
X_11698_ net1124 _05200_ _05458_ VGND VGND VPWR VPWR _05468_ sky130_fd_sc_hd__mux2_1
XFILLER_0_82_164 VGND VGND VPWR VPWR sky130_fd_sc_hd__decap_8
XFILLER_0_70_315 VGND VGND VPWR VPWR sky130_fd_sc_hd__fill_1
XFILLER_0_70_304 VGND VGND VPWR VPWR sky130_fd_sc_hd__decap_4
X_16225_ clknet_leaf_3_clk _00842_ VGND VGND VPWR VPWR latched_is_lh sky130_fd_sc_hd__dfxtp_1
X_10649_ _03695_ _04853_ _04855_ VGND VGND VPWR VPWR _04856_ sky130_fd_sc_hd__a21o_1
X_13437_ _06849_ _06916_ VGND VGND VPWR VPWR _06917_ sky130_fd_sc_hd__or2_1
XFILLER_0_82_197 VGND VGND VPWR VPWR sky130_fd_sc_hd__decap_3
XFILLER_0_3_626 VGND VGND VPWR VPWR sky130_fd_sc_hd__fill_1
XFILLER_0_3_615 VGND VGND VPWR VPWR sky130_fd_sc_hd__fill_1
Xrebuffer2 _06186_ VGND VGND VPWR VPWR net360 sky130_fd_sc_hd__buf_1
XFILLER_0_140_225 VGND VGND VPWR VPWR sky130_fd_sc_hd__decap_8
X_16156_ clknet_leaf_29_clk _00774_ VGND VGND VPWR VPWR net59 sky130_fd_sc_hd__dfxtp_1
X_13368_ cpuregs\[16\]\[17\] cpuregs\[17\]\[17\] cpuregs\[18\]\[17\] cpuregs\[19\]\[17\]
+ _06614_ _06648_ VGND VGND VPWR VPWR _06850_ sky130_fd_sc_hd__mux4_1
XFILLER_0_140_258 VGND VGND VPWR VPWR sky130_fd_sc_hd__fill_1
X_12319_ _05763_ net1625 _05929_ _05933_ _05768_ VGND VGND VPWR VPWR _00690_ sky130_fd_sc_hd__o221a_1
X_15107_ net1369 _05225_ _01900_ VGND VGND VPWR VPWR _01935_ sky130_fd_sc_hd__mux2_1
X_16087_ clknet_leaf_1_clk _00737_ VGND VGND VPWR VPWR count_cycle\[30\] sky130_fd_sc_hd__dfxtp_1
X_13299_ _06348_ VGND VGND VPWR VPWR _06783_ sky130_fd_sc_hd__clkbuf_4
X_15038_ _01898_ VGND VGND VPWR VPWR _01379_ sky130_fd_sc_hd__clkbuf_1
XFILLER_0_54_9 VGND VGND VPWR VPWR sky130_fd_sc_hd__fill_1
XFILLER_0_48_32 VGND VGND VPWR VPWR sky130_fd_sc_hd__fill_1
X_07860_ _02203_ VGND VGND VPWR VPWR _02269_ sky130_fd_sc_hd__clkbuf_4
X_07791_ count_instr\[32\] _02203_ count_cycle\[32\] _02204_ VGND VGND VPWR VPWR _02205_
+ sky130_fd_sc_hd__a22o_1
X_09530_ cpuregs\[6\]\[1\] cpuregs\[7\]\[1\] _03751_ VGND VGND VPWR VPWR _03765_ sky130_fd_sc_hd__mux2_1
XFILLER_0_64_97 VGND VGND VPWR VPWR sky130_fd_sc_hd__fill_1
X_09461_ cpuregs\[0\]\[0\] cpuregs\[1\]\[0\] cpuregs\[2\]\[0\] cpuregs\[3\]\[0\] _03680_
+ _03696_ VGND VGND VPWR VPWR _03697_ sky130_fd_sc_hd__mux4_1
XFILLER_0_3_89 VGND VGND VPWR VPWR sky130_fd_sc_hd__fill_1
X_09392_ reg_pc\[29\] _03626_ VGND VGND VPWR VPWR _03631_ sky130_fd_sc_hd__and2_1
XFILLER_0_93_407 VGND VGND VPWR VPWR sky130_fd_sc_hd__fill_1
XFILLER_0_80_41 VGND VGND VPWR VPWR sky130_fd_sc_hd__decap_6
X_08412_ _02662_ _02663_ _02788_ _02792_ VGND VGND VPWR VPWR _02793_ sky130_fd_sc_hd__a22o_1
XFILLER_0_65_109 VGND VGND VPWR VPWR sky130_fd_sc_hd__decap_3
X_08343_ net187 net219 VGND VGND VPWR VPWR _02724_ sky130_fd_sc_hd__nand2_1
XFILLER_0_74_643 VGND VGND VPWR VPWR sky130_fd_sc_hd__fill_1
XFILLER_0_58_194 VGND VGND VPWR VPWR sky130_fd_sc_hd__fill_2
XFILLER_0_117_745 VGND VGND VPWR VPWR sky130_fd_sc_hd__fill_1
XFILLER_0_104_81 VGND VGND VPWR VPWR sky130_fd_sc_hd__decap_3
XFILLER_0_80_85 VGND VGND VPWR VPWR sky130_fd_sc_hd__decap_3
XFILLER_0_73_131 VGND VGND VPWR VPWR sky130_fd_sc_hd__decap_3
XFILLER_0_46_345 VGND VGND VPWR VPWR sky130_fd_sc_hd__fill_1
XFILLER_0_19_559 VGND VGND VPWR VPWR sky130_fd_sc_hd__fill_1
X_08274_ count_cycle\[31\] _02202_ _02654_ _02655_ VGND VGND VPWR VPWR _02656_ sky130_fd_sc_hd__a211o_2
XFILLER_0_61_315 VGND VGND VPWR VPWR sky130_fd_sc_hd__fill_1
XFILLER_0_132_726 VGND VGND VPWR VPWR sky130_fd_sc_hd__fill_1
XFILLER_0_116_277 VGND VGND VPWR VPWR sky130_fd_sc_hd__decap_6
XFILLER_0_6_486 VGND VGND VPWR VPWR sky130_fd_sc_hd__fill_2
XFILLER_0_131_225 VGND VGND VPWR VPWR sky130_fd_sc_hd__decap_6
XFILLER_0_112_483 VGND VGND VPWR VPWR sky130_fd_sc_hd__fill_2
X_07989_ _02336_ _02389_ _02338_ VGND VGND VPWR VPWR _02390_ sky130_fd_sc_hd__a21o_1
X_09728_ _03656_ VGND VGND VPWR VPWR _03959_ sky130_fd_sc_hd__clkbuf_4
XTAP_1113 VGND VPWR sky130_fd_sc_hd__tapvpwrvgnd_1
XTAP_1102 VGND VPWR sky130_fd_sc_hd__tapvpwrvgnd_1
X_09659_ _03878_ _03889_ _03891_ VGND VGND VPWR VPWR _03892_ sky130_fd_sc_hd__a21o_1
XFILLER_0_96_256 VGND VGND VPWR VPWR sky130_fd_sc_hd__fill_1
XTAP_1146 VGND VPWR sky130_fd_sc_hd__tapvpwrvgnd_1
XTAP_1135 VGND VPWR sky130_fd_sc_hd__tapvpwrvgnd_1
XTAP_1124 VGND VPWR sky130_fd_sc_hd__tapvpwrvgnd_1
X_12670_ _06216_ _06214_ _06218_ _02164_ VGND VGND VPWR VPWR _00756_ sky130_fd_sc_hd__a211oi_1
XFILLER_0_38_813 VGND VGND VPWR VPWR sky130_fd_sc_hd__fill_1
XFILLER_0_77_481 VGND VGND VPWR VPWR sky130_fd_sc_hd__fill_1
X_11621_ _05427_ VGND VGND VPWR VPWR _00498_ sky130_fd_sc_hd__clkbuf_1
XTAP_1179 VGND VPWR sky130_fd_sc_hd__tapvpwrvgnd_1
XTAP_1157 VGND VPWR sky130_fd_sc_hd__tapvpwrvgnd_1
XTAP_1168 VGND VPWR sky130_fd_sc_hd__tapvpwrvgnd_1
XFILLER_0_49_183 VGND VGND VPWR VPWR sky130_fd_sc_hd__fill_1
XFILLER_0_92_451 VGND VGND VPWR VPWR sky130_fd_sc_hd__fill_2
X_14340_ _07320_ net1092 _07588_ mem_rdata_q\[28\] _07357_ VGND VGND VPWR VPWR _07603_
+ sky130_fd_sc_hd__a221o_1
XFILLER_0_107_222 VGND VGND VPWR VPWR sky130_fd_sc_hd__fill_2
XFILLER_0_80_613 VGND VGND VPWR VPWR sky130_fd_sc_hd__fill_1
X_11552_ _05014_ net1542 _05386_ VGND VGND VPWR VPWR _05391_ sky130_fd_sc_hd__mux2_1
XFILLER_0_64_186 VGND VGND VPWR VPWR sky130_fd_sc_hd__fill_1
X_10503_ _03929_ _04711_ _04713_ VGND VGND VPWR VPWR _04714_ sky130_fd_sc_hd__a21o_1
X_11483_ net1510 _05190_ _05349_ VGND VGND VPWR VPWR _05354_ sky130_fd_sc_hd__mux2_1
XFILLER_0_64_197 VGND VGND VPWR VPWR sky130_fd_sc_hd__fill_1
X_14271_ _04901_ _07560_ _07561_ net395 VGND VGND VPWR VPWR _00993_ sky130_fd_sc_hd__a22o_1
X_10434_ _04646_ VGND VGND VPWR VPWR _00092_ sky130_fd_sc_hd__clkbuf_1
XFILLER_0_122_247 VGND VGND VPWR VPWR sky130_fd_sc_hd__fill_2
XFILLER_0_122_225 VGND VGND VPWR VPWR sky130_fd_sc_hd__fill_2
X_16010_ clknet_leaf_30_clk _00660_ VGND VGND VPWR VPWR reg_pc\[16\] sky130_fd_sc_hd__dfxtp_2
X_13222_ _00008_ VGND VGND VPWR VPWR _06708_ sky130_fd_sc_hd__buf_4
X_10365_ decoded_imm\[22\] net185 VGND VGND VPWR VPWR _04579_ sky130_fd_sc_hd__or2_1
X_13153_ _06639_ _06640_ VGND VGND VPWR VPWR _06641_ sky130_fd_sc_hd__and2_1
XFILLER_0_20_212 VGND VGND VPWR VPWR sky130_fd_sc_hd__decap_6
XFILLER_0_20_223 VGND VGND VPWR VPWR sky130_fd_sc_hd__decap_3
XFILLER_0_33_595 VGND VGND VPWR VPWR sky130_fd_sc_hd__decap_3
X_12104_ reg_next_pc\[22\] _03223_ _05742_ VGND VGND VPWR VPWR _05743_ sky130_fd_sc_hd__a21oi_2
XFILLER_0_103_472 VGND VGND VPWR VPWR sky130_fd_sc_hd__fill_1
XTAP_908 VGND VPWR sky130_fd_sc_hd__tapvpwrvgnd_1
X_10296_ decoded_imm\[20\] _02509_ VGND VGND VPWR VPWR _04512_ sky130_fd_sc_hd__nand2_2
X_13084_ _06535_ _06569_ _06573_ _06542_ VGND VGND VPWR VPWR _06574_ sky130_fd_sc_hd__o211a_1
XTAP_919 VGND VPWR sky130_fd_sc_hd__tapvpwrvgnd_1
X_16912_ clknet_leaf_103_clk _01476_ VGND VGND VPWR VPWR cpuregs\[8\]\[31\] sky130_fd_sc_hd__dfxtp_1
X_12035_ _05690_ reg_pc\[2\] VGND VGND VPWR VPWR _05694_ sky130_fd_sc_hd__or2_1
X_16843_ clknet_leaf_74_clk _01407_ VGND VGND VPWR VPWR cpuregs\[7\]\[26\] sky130_fd_sc_hd__dfxtp_1
X_16774_ clknet_leaf_76_clk _01338_ VGND VGND VPWR VPWR cpuregs\[5\]\[21\] sky130_fd_sc_hd__dfxtp_1
X_13986_ _07377_ _07403_ VGND VGND VPWR VPWR _07404_ sky130_fd_sc_hd__and2_1
X_15725_ clknet_leaf_56_clk _00375_ VGND VGND VPWR VPWR cpuregs\[21\]\[19\] sky130_fd_sc_hd__dfxtp_1
XFILLER_0_34_23 VGND VGND VPWR VPWR sky130_fd_sc_hd__decap_4
X_12937_ _03345_ VGND VGND VPWR VPWR _06431_ sky130_fd_sc_hd__buf_4
XFILLER_0_125_69 VGND VGND VPWR VPWR sky130_fd_sc_hd__decap_3
X_15656_ clknet_leaf_104_clk _00306_ VGND VGND VPWR VPWR cpuregs\[14\]\[14\] sky130_fd_sc_hd__dfxtp_1
X_12868_ cpuregs\[4\]\[0\] cpuregs\[5\]\[0\] cpuregs\[6\]\[0\] cpuregs\[7\]\[0\] _06344_
+ _03314_ VGND VGND VPWR VPWR _06367_ sky130_fd_sc_hd__mux4_1
X_14607_ _01647_ VGND VGND VPWR VPWR _01670_ sky130_fd_sc_hd__buf_4
X_11819_ _05536_ _05530_ _05537_ VGND VGND VPWR VPWR _05538_ sky130_fd_sc_hd__and3b_1
XTAP_1691 VGND VPWR sky130_fd_sc_hd__tapvpwrvgnd_1
XTAP_1680 VGND VPWR sky130_fd_sc_hd__tapvpwrvgnd_1
X_12799_ _06314_ VGND VGND VPWR VPWR _00789_ sky130_fd_sc_hd__clkbuf_1
X_15587_ clknet_leaf_134_clk _00237_ VGND VGND VPWR VPWR cpuregs\[28\]\[9\] sky130_fd_sc_hd__dfxtp_1
X_14538_ _01633_ VGND VGND VPWR VPWR _01144_ sky130_fd_sc_hd__clkbuf_1
XFILLER_0_55_186 VGND VGND VPWR VPWR sky130_fd_sc_hd__decap_3
XFILLER_0_50_44 VGND VGND VPWR VPWR sky130_fd_sc_hd__fill_1
X_14469_ net912 _05200_ _01587_ VGND VGND VPWR VPWR _01597_ sky130_fd_sc_hd__mux2_1
XFILLER_0_70_134 VGND VGND VPWR VPWR sky130_fd_sc_hd__decap_6
XFILLER_0_50_99 VGND VGND VPWR VPWR sky130_fd_sc_hd__fill_2
XFILLER_0_113_225 VGND VGND VPWR VPWR sky130_fd_sc_hd__decap_8
XFILLER_0_113_214 VGND VGND VPWR VPWR sky130_fd_sc_hd__decap_3
X_16208_ clknet_leaf_54_clk _00825_ VGND VGND VPWR VPWR net213 sky130_fd_sc_hd__dfxtp_4
Xpicorv32_301 VGND VGND VPWR VPWR picorv32_301/HI pcpi_insn[12] sky130_fd_sc_hd__conb_1
Xpicorv32_312 VGND VGND VPWR VPWR picorv32_312/HI pcpi_insn[23] sky130_fd_sc_hd__conb_1
Xpicorv32_334 VGND VGND VPWR VPWR picorv32_334/HI trace_data[12] sky130_fd_sc_hd__conb_1
X_16139_ clknet_leaf_30_clk _07626_ VGND VGND VPWR VPWR reg_out\[17\] sky130_fd_sc_hd__dfxtp_1
XFILLER_0_59_31 VGND VGND VPWR VPWR sky130_fd_sc_hd__fill_1
Xpicorv32_345 VGND VGND VPWR VPWR picorv32_345/HI trace_data[23] sky130_fd_sc_hd__conb_1
Xpicorv32_323 VGND VGND VPWR VPWR picorv32_323/HI trace_data[1] sky130_fd_sc_hd__conb_1
Xpicorv32_356 VGND VGND VPWR VPWR picorv32_356/HI trace_data[34] sky130_fd_sc_hd__conb_1
X_08961_ reg_out\[20\] reg_next_pc\[20\] _03248_ VGND VGND VPWR VPWR _03265_ sky130_fd_sc_hd__mux2_1
X_08892_ net220 _03204_ _03206_ VGND VGND VPWR VPWR net114 sky130_fd_sc_hd__a21o_2
X_07912_ net1628 _02232_ _02317_ VGND VGND VPWR VPWR _02318_ sky130_fd_sc_hd__a21oi_1
X_07843_ _02253_ VGND VGND VPWR VPWR _07640_ sky130_fd_sc_hd__clkbuf_1
XFILLER_0_75_85 VGND VGND VPWR VPWR sky130_fd_sc_hd__fill_1
XFILLER_0_78_201 VGND VGND VPWR VPWR sky130_fd_sc_hd__decap_8
X_07774_ _02172_ _02189_ _02171_ cpu_state\[2\] VGND VGND VPWR VPWR _02190_ sky130_fd_sc_hd__and4b_1
X_09513_ _03734_ _03746_ _03747_ VGND VGND VPWR VPWR _03748_ sky130_fd_sc_hd__o21ai_2
XPHY_207 VGND VGND VPWR VPWR sky130_fd_sc_hd__decap_3
XFILLER_0_91_84 VGND VGND VPWR VPWR sky130_fd_sc_hd__fill_1
X_09444_ _03666_ VGND VGND VPWR VPWR _03680_ sky130_fd_sc_hd__buf_4
XFILLER_0_38_109 VGND VGND VPWR VPWR sky130_fd_sc_hd__decap_3
XPHY_229 VGND VGND VPWR VPWR sky130_fd_sc_hd__decap_3
XPHY_218 VGND VGND VPWR VPWR sky130_fd_sc_hd__decap_3
XFILLER_0_78_289 VGND VGND VPWR VPWR sky130_fd_sc_hd__decap_3
X_09375_ net957 _03616_ _03578_ VGND VGND VPWR VPWR _03617_ sky130_fd_sc_hd__mux2_1
X_08326_ net184 net216 VGND VGND VPWR VPWR _02707_ sky130_fd_sc_hd__nand2_1
XFILLER_0_117_531 VGND VGND VPWR VPWR sky130_fd_sc_hd__fill_1
X_08257_ reg_pc\[30\] decoded_imm\[30\] VGND VGND VPWR VPWR _02640_ sky130_fd_sc_hd__or2_1
XFILLER_0_46_197 VGND VGND VPWR VPWR sky130_fd_sc_hd__decap_4
X_08188_ _02562_ _02565_ _02575_ VGND VGND VPWR VPWR _02576_ sky130_fd_sc_hd__a21oi_1
XFILLER_0_30_510 VGND VGND VPWR VPWR sky130_fd_sc_hd__fill_1
X_10150_ _04077_ _04362_ _04363_ _04369_ VGND VGND VPWR VPWR _04370_ sky130_fd_sc_hd__o31ai_2
XFILLER_0_30_576 VGND VGND VPWR VPWR sky130_fd_sc_hd__fill_1
X_10081_ cpuregs\[8\]\[14\] cpuregs\[9\]\[14\] cpuregs\[10\]\[14\] cpuregs\[11\]\[14\]
+ _03876_ _03895_ VGND VGND VPWR VPWR _04303_ sky130_fd_sc_hd__mux4_1
XFILLER_0_69_201 VPWR VGND VPWR VGND sky130_ef_sc_hd__decap_12
X_13840_ instr_lb _07299_ _07300_ latched_is_lb VGND VGND VPWR VPWR _07303_ sky130_fd_sc_hd__a22o_1
X_13771_ _06457_ _07239_ VGND VGND VPWR VPWR _07240_ sky130_fd_sc_hd__and2_1
X_10983_ _05024_ net1175 _05063_ VGND VGND VPWR VPWR _05073_ sky130_fd_sc_hd__mux2_1
Xclkbuf_leaf_148_clk clknet_4_2_0_clk VGND VGND VPWR VPWR clknet_leaf_148_clk sky130_fd_sc_hd__clkbuf_16
X_15510_ clknet_leaf_66_clk _00160_ VGND VGND VPWR VPWR cpuregs\[30\]\[28\] sky130_fd_sc_hd__dfxtp_1
X_12722_ _02605_ _02646_ _03847_ VGND VGND VPWR VPWR _06256_ sky130_fd_sc_hd__mux2_1
XFILLER_0_69_267 VGND VGND VPWR VPWR sky130_fd_sc_hd__decap_3
X_16490_ clknet_leaf_135_clk _01072_ VGND VGND VPWR VPWR cpuregs\[19\]\[11\] sky130_fd_sc_hd__dfxtp_1
X_15441_ clknet_leaf_49_clk _00091_ VGND VGND VPWR VPWR net185 sky130_fd_sc_hd__dfxtp_4
XFILLER_0_78_790 VGND VGND VPWR VPWR sky130_fd_sc_hd__decap_3
X_12653_ _06204_ _06205_ _05523_ VGND VGND VPWR VPWR _06206_ sky130_fd_sc_hd__and3b_1
X_15372_ _02073_ VGND VGND VPWR VPWR _01538_ sky130_fd_sc_hd__clkbuf_1
X_11604_ _05418_ VGND VGND VPWR VPWR _00490_ sky130_fd_sc_hd__clkbuf_1
X_12584_ count_cycle\[23\] count_cycle\[24\] net362 count_cycle\[25\] VGND VGND VPWR
+ VPWR _06157_ sky130_fd_sc_hd__a31o_1
X_14323_ _06025_ decoded_imm_j\[16\] _07570_ mem_rdata_q\[16\] _07388_ VGND VGND VPWR
+ VPWR _07594_ sky130_fd_sc_hd__a221o_1
X_11535_ _04997_ net1492 _05375_ VGND VGND VPWR VPWR _05382_ sky130_fd_sc_hd__mux2_1
XFILLER_0_25_326 VGND VGND VPWR VPWR sky130_fd_sc_hd__fill_1
X_14254_ _07552_ VGND VGND VPWR VPWR _00985_ sky130_fd_sc_hd__clkbuf_1
XFILLER_0_80_454 VGND VGND VPWR VPWR sky130_fd_sc_hd__fill_1
XFILLER_0_20_36 VGND VGND VPWR VPWR sky130_fd_sc_hd__fill_1
XFILLER_0_20_47 VGND VGND VPWR VPWR sky130_fd_sc_hd__decap_6
XFILLER_0_40_307 VGND VGND VPWR VPWR sky130_fd_sc_hd__fill_1
XFILLER_0_111_729 VGND VGND VPWR VPWR sky130_fd_sc_hd__decap_4
X_13205_ _06455_ _06686_ _06691_ _06466_ VGND VGND VPWR VPWR _06692_ sky130_fd_sc_hd__o211a_1
X_11466_ net1466 _05173_ _05338_ VGND VGND VPWR VPWR _05345_ sky130_fd_sc_hd__mux2_1
X_10417_ cpuregs\[16\]\[23\] cpuregs\[17\]\[23\] cpuregs\[18\]\[23\] cpuregs\[19\]\[23\]
+ _03819_ _03799_ VGND VGND VPWR VPWR _04630_ sky130_fd_sc_hd__mux4_1
X_14185_ _07515_ VGND VGND VPWR VPWR _00953_ sky130_fd_sc_hd__clkbuf_1
X_11397_ _05308_ VGND VGND VPWR VPWR _00393_ sky130_fd_sc_hd__clkbuf_1
X_10348_ cpuregs\[20\]\[21\] cpuregs\[21\]\[21\] _03767_ VGND VGND VPWR VPWR _04563_
+ sky130_fd_sc_hd__mux2_1
X_13136_ _06459_ _06622_ _06624_ _06563_ VGND VGND VPWR VPWR _06625_ sky130_fd_sc_hd__a211o_1
XTAP_705 VGND VPWR sky130_fd_sc_hd__tapvpwrvgnd_1
XTAP_716 VGND VPWR sky130_fd_sc_hd__tapvpwrvgnd_1
X_10279_ _03723_ _04495_ _03675_ VGND VGND VPWR VPWR _04496_ sky130_fd_sc_hd__a21o_1
X_13067_ _03330_ VGND VGND VPWR VPWR _06558_ sky130_fd_sc_hd__buf_4
XFILLER_0_29_78 VGND VGND VPWR VPWR sky130_fd_sc_hd__fill_2
XTAP_727 VGND VPWR sky130_fd_sc_hd__tapvpwrvgnd_1
XTAP_738 VGND VPWR sky130_fd_sc_hd__tapvpwrvgnd_1
XTAP_749 VGND VPWR sky130_fd_sc_hd__tapvpwrvgnd_1
X_12018_ count_instr\[60\] _05677_ count_instr\[61\] VGND VGND VPWR VPWR _05681_ sky130_fd_sc_hd__a21o_1
XFILLER_0_136_57 VPWR VGND VPWR VGND sky130_ef_sc_hd__decap_12
X_16826_ clknet_leaf_110_clk _01390_ VGND VGND VPWR VPWR cpuregs\[7\]\[9\] sky130_fd_sc_hd__dfxtp_1
XFILLER_0_45_88 VGND VGND VPWR VPWR sky130_fd_sc_hd__decap_6
X_16757_ clknet_leaf_124_clk _01321_ VGND VGND VPWR VPWR cpuregs\[5\]\[4\] sky130_fd_sc_hd__dfxtp_1
X_13969_ _07392_ VGND VGND VPWR VPWR _00872_ sky130_fd_sc_hd__clkbuf_1
Xclkbuf_leaf_139_clk clknet_4_3_0_clk VGND VGND VPWR VPWR clknet_leaf_139_clk sky130_fd_sc_hd__clkbuf_16
X_15708_ clknet_leaf_132_clk _00358_ VGND VGND VPWR VPWR cpuregs\[21\]\[2\] sky130_fd_sc_hd__dfxtp_1
XFILLER_0_0_35 VGND VGND VPWR VPWR sky130_fd_sc_hd__fill_1
XFILLER_0_29_610 VGND VGND VPWR VPWR sky130_fd_sc_hd__decap_6
X_16688_ clknet_leaf_131_clk _01255_ VGND VGND VPWR VPWR cpuregs\[3\]\[2\] sky130_fd_sc_hd__dfxtp_1
X_15639_ clknet_leaf_60_clk _00289_ VGND VGND VPWR VPWR cpuregs\[31\]\[29\] sky130_fd_sc_hd__dfxtp_1
XFILLER_0_90_207 VPWR VGND VPWR VGND sky130_ef_sc_hd__decap_12
XFILLER_0_71_410 VGND VGND VPWR VPWR sky130_fd_sc_hd__fill_2
X_09160_ _03429_ VGND VGND VPWR VPWR _01117_ sky130_fd_sc_hd__buf_1
XFILLER_0_8_559 VGND VGND VPWR VPWR sky130_fd_sc_hd__fill_2
X_08111_ _02498_ _02501_ _02503_ VGND VGND VPWR VPWR _02504_ sky130_fd_sc_hd__nand3_1
XFILLER_0_71_432 VGND VGND VPWR VPWR sky130_fd_sc_hd__decap_6
X_09091_ _03318_ _03370_ VGND VGND VPWR VPWR _03371_ sky130_fd_sc_hd__or2_1
X_08042_ reg_pc\[16\] decoded_imm\[16\] VGND VGND VPWR VPWR _02439_ sky130_fd_sc_hd__or2_1
XFILLER_0_9_55 VGND VGND VPWR VPWR sky130_fd_sc_hd__fill_1
XFILLER_0_102_718 VGND VGND VPWR VPWR sky130_fd_sc_hd__decap_4
Xhold912 cpuregs\[11\]\[6\] VGND VGND VPWR VPWR net1270 sky130_fd_sc_hd__dlygate4sd3_1
Xhold901 cpuregs\[4\]\[9\] VGND VGND VPWR VPWR net1259 sky130_fd_sc_hd__dlygate4sd3_1
XFILLER_0_43_189 VGND VGND VPWR VPWR sky130_fd_sc_hd__fill_1
Xhold934 cpuregs\[1\]\[28\] VGND VGND VPWR VPWR net1292 sky130_fd_sc_hd__dlygate4sd3_1
Xhold945 cpuregs\[6\]\[4\] VGND VGND VPWR VPWR net1303 sky130_fd_sc_hd__dlygate4sd3_1
Xhold923 cpuregs\[19\]\[5\] VGND VGND VPWR VPWR net1281 sky130_fd_sc_hd__dlygate4sd3_1
Xhold956 cpuregs\[18\]\[25\] VGND VGND VPWR VPWR net1314 sky130_fd_sc_hd__dlygate4sd3_1
Xhold978 cpuregs\[5\]\[27\] VGND VGND VPWR VPWR net1336 sky130_fd_sc_hd__dlygate4sd3_1
Xhold967 cpuregs\[1\]\[19\] VGND VGND VPWR VPWR net1325 sky130_fd_sc_hd__dlygate4sd3_1
X_09993_ _03696_ _04215_ _04217_ VGND VGND VPWR VPWR _04218_ sky130_fd_sc_hd__a21o_1
Xhold989 cpuregs\[16\]\[1\] VGND VGND VPWR VPWR net1347 sky130_fd_sc_hd__dlygate4sd3_1
X_08944_ _02416_ _03253_ _03246_ VGND VGND VPWR VPWR _03254_ sky130_fd_sc_hd__mux2_1
X_08875_ _02751_ _02716_ _02447_ VGND VGND VPWR VPWR _03213_ sky130_fd_sc_hd__mux2_1
X_07826_ count_instr\[1\] _02236_ count_cycle\[33\] _02237_ VGND VGND VPWR VPWR _02238_
+ sky130_fd_sc_hd__a22o_1
X_07757_ _02171_ _02175_ _02116_ VGND VGND VPWR VPWR _02176_ sky130_fd_sc_hd__a21o_1
XFILLER_0_67_738 VGND VGND VPWR VPWR sky130_fd_sc_hd__decap_4
X_07688_ _02115_ VGND VGND VPWR VPWR net129 sky130_fd_sc_hd__inv_2
XFILLER_0_136_103 VGND VGND VPWR VPWR sky130_fd_sc_hd__fill_1
X_09427_ _03662_ VGND VGND VPWR VPWR _03663_ sky130_fd_sc_hd__buf_4
X_09358_ _03546_ _03599_ _03600_ _03601_ VGND VGND VPWR VPWR _03602_ sky130_fd_sc_hd__a22o_2
XFILLER_0_75_793 VGND VGND VPWR VPWR sky130_fd_sc_hd__fill_1
XFILLER_0_124_309 VGND VGND VPWR VPWR sky130_fd_sc_hd__fill_1
XFILLER_0_117_350 VGND VGND VPWR VPWR sky130_fd_sc_hd__fill_1
XFILLER_0_105_501 VGND VGND VPWR VPWR sky130_fd_sc_hd__decap_3
X_08309_ _02403_ net207 VGND VGND VPWR VPWR _02690_ sky130_fd_sc_hd__nand2_1
XFILLER_0_74_270 VPWR VGND VPWR VGND sky130_ef_sc_hd__decap_12
X_09289_ reg_pc\[15\] _03534_ _03459_ VGND VGND VPWR VPWR _03542_ sky130_fd_sc_hd__o21a_1
XFILLER_0_7_592 VGND VGND VPWR VPWR sky130_fd_sc_hd__fill_1
X_11320_ _04987_ net1560 _05266_ VGND VGND VPWR VPWR _05268_ sky130_fd_sc_hd__mux2_1
X_11251_ net1078 _05163_ _05229_ VGND VGND VPWR VPWR _05231_ sky130_fd_sc_hd__mux2_1
X_10202_ _00016_ _04414_ _04420_ VGND VGND VPWR VPWR _04421_ sky130_fd_sc_hd__or3_2
X_11182_ _03518_ VGND VGND VPWR VPWR _05184_ sky130_fd_sc_hd__buf_2
XFILLER_0_100_261 VPWR VGND VPWR VGND sky130_ef_sc_hd__decap_12
X_10133_ _03834_ _04351_ _04353_ VGND VGND VPWR VPWR _04354_ sky130_fd_sc_hd__a21o_1
X_15990_ clknet_leaf_1_clk _00640_ VGND VGND VPWR VPWR count_instr\[59\] sky130_fd_sc_hd__dfxtp_1
X_14941_ _01847_ VGND VGND VPWR VPWR _01333_ sky130_fd_sc_hd__clkbuf_1
X_10064_ _03834_ _04284_ _04286_ VGND VGND VPWR VPWR _04287_ sky130_fd_sc_hd__a21o_1
X_14872_ _03552_ net1100 _01804_ VGND VGND VPWR VPWR _01811_ sky130_fd_sc_hd__mux2_1
X_16611_ clknet_leaf_77_clk _01178_ VGND VGND VPWR VPWR cpuregs\[9\]\[21\] sky130_fd_sc_hd__dfxtp_1
X_13823_ is_beq_bne_blt_bge_bltu_bgeu VGND VGND VPWR VPWR _07290_ sky130_fd_sc_hd__inv_2
X_16542_ clknet_leaf_7_clk _01119_ VGND VGND VPWR VPWR mem_rdata_q\[26\] sky130_fd_sc_hd__dfxtp_2
X_13754_ cpuregs\[30\]\[29\] cpuregs\[31\]\[29\] _06510_ VGND VGND VPWR VPWR _07224_
+ sky130_fd_sc_hd__mux2_1
X_10966_ _05064_ VGND VGND VPWR VPWR _00206_ sky130_fd_sc_hd__clkbuf_1
X_16473_ clknet_leaf_44_clk _01055_ VGND VGND VPWR VPWR cpuregs\[18\]\[26\] sky130_fd_sc_hd__dfxtp_1
X_13685_ _06962_ _07149_ _07156_ VGND VGND VPWR VPWR _07157_ sky130_fd_sc_hd__or3_2
X_10897_ _05020_ net1252 _05006_ VGND VGND VPWR VPWR _05021_ sky130_fd_sc_hd__mux2_1
X_12705_ _06242_ _05523_ _06243_ VGND VGND VPWR VPWR _06244_ sky130_fd_sc_hd__and3b_1
XFILLER_0_122_37 VGND VGND VPWR VPWR sky130_fd_sc_hd__fill_1
XFILLER_0_122_26 VGND VGND VPWR VPWR sky130_fd_sc_hd__fill_2
X_15424_ clknet_leaf_17_clk _00074_ VGND VGND VPWR VPWR net198 sky130_fd_sc_hd__dfxtp_2
X_12636_ count_cycle\[38\] count_cycle\[39\] net360 count_cycle\[40\] VGND VGND VPWR
+ VPWR _06194_ sky130_fd_sc_hd__a31o_1
XFILLER_0_127_169 VPWR VGND VPWR VGND sky130_ef_sc_hd__decap_12
X_15355_ _03584_ net995 _02063_ VGND VGND VPWR VPWR _02065_ sky130_fd_sc_hd__mux2_1
XFILLER_0_65_281 VGND VGND VPWR VPWR sky130_fd_sc_hd__fill_2
XFILLER_0_26_657 VPWR VGND VPWR VGND sky130_ef_sc_hd__decap_12
XFILLER_0_81_785 VGND VGND VPWR VPWR sky130_fd_sc_hd__fill_2
XFILLER_0_80_251 VGND VGND VPWR VPWR sky130_fd_sc_hd__fill_1
X_14306_ _07569_ _07573_ _07583_ _07575_ net1329 VGND VGND VPWR VPWR _01006_ sky130_fd_sc_hd__o32a_1
X_12567_ count_cycle\[20\] _06142_ VGND VGND VPWR VPWR _06145_ sky130_fd_sc_hd__and2_1
XFILLER_0_25_167 VGND VGND VPWR VPWR sky130_fd_sc_hd__fill_1
X_12498_ _06095_ _06096_ VGND VGND VPWR VPWR _06097_ sky130_fd_sc_hd__xnor2_1
X_15286_ _02028_ VGND VGND VPWR VPWR _01497_ sky130_fd_sc_hd__clkbuf_1
XFILLER_0_80_295 VPWR VGND VPWR VGND sky130_ef_sc_hd__decap_12
XFILLER_0_80_273 VGND VGND VPWR VPWR sky130_fd_sc_hd__fill_1
X_11518_ net679 _05225_ _05337_ VGND VGND VPWR VPWR _05372_ sky130_fd_sc_hd__mux2_1
Xhold208 mem_rdata_q\[7\] VGND VGND VPWR VPWR net566 sky130_fd_sc_hd__buf_1
X_11449_ _05335_ VGND VGND VPWR VPWR _00418_ sky130_fd_sc_hd__clkbuf_1
Xhold219 cpuregs\[20\]\[17\] VGND VGND VPWR VPWR net577 sky130_fd_sc_hd__dlygate4sd3_1
X_14237_ net482 net111 _07541_ VGND VGND VPWR VPWR _07544_ sky130_fd_sc_hd__mux2_1
X_14168_ _07504_ VGND VGND VPWR VPWR _00947_ sky130_fd_sc_hd__clkbuf_1
XFILLER_0_1_768 VPWR VGND VPWR VGND sky130_ef_sc_hd__decap_12
X_13119_ cpuregs\[6\]\[10\] cpuregs\[7\]\[10\] _06511_ VGND VGND VPWR VPWR _06608_
+ sky130_fd_sc_hd__mux2_1
XTAP_502 VGND VPWR sky130_fd_sc_hd__tapvpwrvgnd_1
XTAP_513 VGND VPWR sky130_fd_sc_hd__tapvpwrvgnd_1
XTAP_524 VGND VPWR sky130_fd_sc_hd__tapvpwrvgnd_1
XTAP_535 VGND VPWR sky130_fd_sc_hd__tapvpwrvgnd_1
XTAP_546 VGND VPWR sky130_fd_sc_hd__tapvpwrvgnd_1
XTAP_557 VGND VPWR sky130_fd_sc_hd__tapvpwrvgnd_1
X_14099_ is_alu_reg_reg _07459_ _07465_ _07467_ VGND VGND VPWR VPWR _00915_ sky130_fd_sc_hd__a31o_1
XFILLER_0_56_54 VGND VGND VPWR VPWR sky130_fd_sc_hd__decap_4
XTAP_568 VGND VPWR sky130_fd_sc_hd__tapvpwrvgnd_1
XTAP_579 VGND VPWR sky130_fd_sc_hd__tapvpwrvgnd_1
X_08660_ _02122_ _03023_ _03024_ VGND VGND VPWR VPWR _03025_ sky130_fd_sc_hd__o21a_1
X_16809_ clknet_leaf_92_clk _01373_ VGND VGND VPWR VPWR cpuregs\[6\]\[24\] sky130_fd_sc_hd__dfxtp_1
X_08591_ _02378_ net205 _02942_ _02841_ VGND VGND VPWR VPWR _02961_ sky130_fd_sc_hd__a31o_1
XFILLER_0_76_513 VGND VGND VPWR VPWR sky130_fd_sc_hd__fill_2
XFILLER_0_119_615 VGND VGND VPWR VPWR sky130_fd_sc_hd__fill_1
XFILLER_0_48_248 VGND VGND VPWR VPWR sky130_fd_sc_hd__fill_1
X_09212_ reg_pc\[5\] _03468_ _03460_ VGND VGND VPWR VPWR _03475_ sky130_fd_sc_hd__o21ai_1
X_09143_ mem_rdata_q\[20\] net13 _03292_ VGND VGND VPWR VPWR _03421_ sky130_fd_sc_hd__mux2_1
XFILLER_0_56_292 VGND VGND VPWR VPWR sky130_fd_sc_hd__fill_1
XFILLER_0_13_830 VGND VGND VPWR VPWR sky130_fd_sc_hd__fill_2
X_09074_ _03345_ _03352_ _03354_ VGND VGND VPWR VPWR _03355_ sky130_fd_sc_hd__a21o_1
XFILLER_0_130_813 VGND VGND VPWR VPWR sky130_fd_sc_hd__decap_6
X_08025_ reg_pc\[15\] decoded_imm\[15\] VGND VGND VPWR VPWR _02423_ sky130_fd_sc_hd__xnor2_1
Xhold720 cpuregs\[27\]\[1\] VGND VGND VPWR VPWR net1078 sky130_fd_sc_hd__dlygate4sd3_1
Xhold764 cpuregs\[8\]\[24\] VGND VGND VPWR VPWR net1122 sky130_fd_sc_hd__dlygate4sd3_1
Xhold742 cpuregs\[4\]\[16\] VGND VGND VPWR VPWR net1100 sky130_fd_sc_hd__dlygate4sd3_1
Xhold731 cpuregs\[11\]\[31\] VGND VGND VPWR VPWR net1089 sky130_fd_sc_hd__dlygate4sd3_1
Xhold753 cpuregs\[14\]\[1\] VGND VGND VPWR VPWR net1111 sky130_fd_sc_hd__dlygate4sd3_1
XFILLER_0_12_362 VGND VGND VPWR VPWR sky130_fd_sc_hd__fill_2
Xhold775 cpuregs\[17\]\[22\] VGND VGND VPWR VPWR net1133 sky130_fd_sc_hd__dlygate4sd3_1
Xhold797 cpuregs\[12\]\[16\] VGND VGND VPWR VPWR net1155 sky130_fd_sc_hd__dlygate4sd3_1
Xhold786 cpuregs\[9\]\[6\] VGND VGND VPWR VPWR net1144 sky130_fd_sc_hd__dlygate4sd3_1
XFILLER_0_110_592 VGND VGND VPWR VPWR sky130_fd_sc_hd__fill_2
X_09976_ cpuregs\[4\]\[11\] cpuregs\[5\]\[11\] cpuregs\[6\]\[11\] cpuregs\[7\]\[11\]
+ _04192_ _04200_ VGND VGND VPWR VPWR _04201_ sky130_fd_sc_hd__mux4_1
X_08927_ _02352_ _03241_ _03227_ VGND VGND VPWR VPWR _03242_ sky130_fd_sc_hd__mux2_1
X_08858_ _02466_ VGND VGND VPWR VPWR _03204_ sky130_fd_sc_hd__clkbuf_4
X_07809_ _02221_ VGND VGND VPWR VPWR _02222_ sky130_fd_sc_hd__clkbuf_4
X_08789_ _02813_ _02814_ _03127_ _02122_ VGND VGND VPWR VPWR _03144_ sky130_fd_sc_hd__a31oi_1
X_10820_ net799 _03591_ _04968_ VGND VGND VPWR VPWR _04971_ sky130_fd_sc_hd__mux2_1
X_10751_ net607 _03597_ _04929_ VGND VGND VPWR VPWR _04933_ sky130_fd_sc_hd__mux2_1
X_13470_ cpuregs\[22\]\[20\] cpuregs\[23\]\[20\] _06786_ VGND VGND VPWR VPWR _06949_
+ sky130_fd_sc_hd__mux2_1
XFILLER_0_94_365 VPWR VGND VPWR VGND sky130_ef_sc_hd__decap_12
X_12421_ _06015_ _06018_ _06013_ VGND VGND VPWR VPWR _06027_ sky130_fd_sc_hd__a21o_1
XFILLER_0_109_169 VPWR VGND VPWR VGND sky130_ef_sc_hd__decap_12
X_10682_ _03897_ _04885_ _04887_ VGND VGND VPWR VPWR _04888_ sky130_fd_sc_hd__a21o_1
XFILLER_0_35_432 VGND VGND VPWR VPWR sky130_fd_sc_hd__fill_2
XFILLER_0_62_251 VGND VGND VPWR VPWR sky130_fd_sc_hd__fill_1
XFILLER_0_35_443 VGND VGND VPWR VPWR sky130_fd_sc_hd__fill_2
XFILLER_0_117_191 VGND VGND VPWR VPWR sky130_fd_sc_hd__decap_4
X_12352_ _05962_ _05963_ VGND VGND VPWR VPWR _05964_ sky130_fd_sc_hd__xnor2_1
X_15140_ net785 _03537_ _01948_ VGND VGND VPWR VPWR _01953_ sky130_fd_sc_hd__mux2_1
XFILLER_0_133_673 VGND VGND VPWR VPWR sky130_fd_sc_hd__fill_1
X_11303_ net589 _05215_ _05251_ VGND VGND VPWR VPWR _05258_ sky130_fd_sc_hd__mux2_1
X_12283_ _05898_ _05899_ VGND VGND VPWR VPWR _05900_ sky130_fd_sc_hd__and2b_1
X_15071_ _01916_ VGND VGND VPWR VPWR _01394_ sky130_fd_sc_hd__clkbuf_1
X_11234_ _03628_ VGND VGND VPWR VPWR _05219_ sky130_fd_sc_hd__clkbuf_4
X_14022_ _07427_ VGND VGND VPWR VPWR _01120_ sky130_fd_sc_hd__buf_1
X_11165_ _05172_ VGND VGND VPWR VPWR _00297_ sky130_fd_sc_hd__clkbuf_1
X_10116_ cpuregs\[4\]\[15\] cpuregs\[5\]\[15\] cpuregs\[6\]\[15\] cpuregs\[7\]\[15\]
+ _03864_ _03820_ VGND VGND VPWR VPWR _04337_ sky130_fd_sc_hd__mux4_1
X_15973_ clknet_leaf_145_clk _00623_ VGND VGND VPWR VPWR count_instr\[42\] sky130_fd_sc_hd__dfxtp_1
X_11096_ net1276 _03498_ _05124_ VGND VGND VPWR VPWR _05133_ sky130_fd_sc_hd__mux2_1
X_10047_ cpuregs\[4\]\[13\] cpuregs\[5\]\[13\] cpuregs\[6\]\[13\] cpuregs\[7\]\[13\]
+ _03864_ _03820_ VGND VGND VPWR VPWR _04270_ sky130_fd_sc_hd__mux4_1
X_14924_ _01838_ VGND VGND VPWR VPWR _01325_ sky130_fd_sc_hd__clkbuf_1
Xhold80 reg_next_pc\[27\] VGND VGND VPWR VPWR net438 sky130_fd_sc_hd__dlygate4sd3_1
Xhold91 count_instr\[8\] VGND VGND VPWR VPWR net449 sky130_fd_sc_hd__dlygate4sd3_1
X_14855_ _03498_ net747 _01793_ VGND VGND VPWR VPWR _01802_ sky130_fd_sc_hd__mux2_1
XFILLER_0_98_671 VGND VGND VPWR VPWR sky130_fd_sc_hd__decap_3
XFILLER_0_86_822 VGND VGND VPWR VPWR sky130_fd_sc_hd__fill_2
X_13806_ cpuregs\[16\]\[31\] cpuregs\[17\]\[31\] cpuregs\[18\]\[31\] cpuregs\[19\]\[31\]
+ _06418_ _06419_ VGND VGND VPWR VPWR _07274_ sky130_fd_sc_hd__mux4_1
X_11998_ net1310 _05664_ _05667_ VGND VGND VPWR VPWR _00635_ sky130_fd_sc_hd__o21a_1
X_14786_ net1405 _05177_ _01756_ VGND VGND VPWR VPWR _01765_ sky130_fd_sc_hd__mux2_1
XFILLER_0_133_25 VPWR VGND VPWR VGND sky130_ef_sc_hd__decap_12
X_13737_ _06430_ _07202_ _07206_ _03335_ VGND VGND VPWR VPWR _07207_ sky130_fd_sc_hd__o211a_1
X_16525_ clknet_leaf_14_clk _01102_ VGND VGND VPWR VPWR mem_rdata_q\[9\] sky130_fd_sc_hd__dfxtp_1
X_10949_ _05055_ VGND VGND VPWR VPWR _00198_ sky130_fd_sc_hd__clkbuf_1
XFILLER_0_133_69 VGND VGND VPWR VPWR sky130_fd_sc_hd__decap_8
Xclkbuf_leaf_70_clk clknet_4_13_0_clk VGND VGND VPWR VPWR clknet_leaf_70_clk sky130_fd_sc_hd__clkbuf_16
XFILLER_0_85_365 VGND VGND VPWR VPWR sky130_fd_sc_hd__decap_4
XFILLER_0_73_527 VGND VGND VPWR VPWR sky130_fd_sc_hd__fill_1
X_16456_ clknet_leaf_138_clk _01038_ VGND VGND VPWR VPWR cpuregs\[18\]\[9\] sky130_fd_sc_hd__dfxtp_1
X_15407_ clknet_leaf_71_clk _00062_ VGND VGND VPWR VPWR cpuregs\[11\]\[25\] sky130_fd_sc_hd__dfxtp_1
X_13668_ _06377_ _07130_ _07134_ _07140_ _06341_ VGND VGND VPWR VPWR _07141_ sky130_fd_sc_hd__a311o_1
X_16387_ clknet_leaf_42_clk _00969_ VGND VGND VPWR VPWR net140 sky130_fd_sc_hd__dfxtp_2
X_13599_ cpuregs\[22\]\[24\] cpuregs\[23\]\[24\] _06786_ VGND VGND VPWR VPWR _07074_
+ sky130_fd_sc_hd__mux2_1
X_12619_ count_cycle\[35\] _06178_ _05539_ VGND VGND VPWR VPWR _06182_ sky130_fd_sc_hd__a21oi_1
X_15338_ _03532_ net1428 _02052_ VGND VGND VPWR VPWR _02056_ sky130_fd_sc_hd__mux2_1
XFILLER_0_13_104 VGND VGND VPWR VPWR sky130_fd_sc_hd__decap_8
X_15269_ net519 VGND VGND VPWR VPWR _02020_ sky130_fd_sc_hd__clkbuf_1
XFILLER_0_13_137 VGND VGND VPWR VPWR sky130_fd_sc_hd__decap_6
XFILLER_0_1_543 VGND VGND VPWR VPWR sky130_fd_sc_hd__fill_1
XFILLER_0_10_811 VGND VGND VPWR VPWR sky130_fd_sc_hd__fill_1
XTAP_332 VGND VPWR sky130_fd_sc_hd__tapvpwrvgnd_1
XTAP_321 VGND VPWR sky130_fd_sc_hd__tapvpwrvgnd_1
XTAP_310 VGND VPWR sky130_fd_sc_hd__tapvpwrvgnd_1
X_09830_ cpuregs\[30\]\[7\] cpuregs\[31\]\[7\] _04058_ VGND VGND VPWR VPWR _04059_
+ sky130_fd_sc_hd__mux2_1
X_09761_ _03774_ VGND VGND VPWR VPWR _03992_ sky130_fd_sc_hd__clkbuf_4
XTAP_376 VGND VPWR sky130_fd_sc_hd__tapvpwrvgnd_1
XTAP_365 VGND VPWR sky130_fd_sc_hd__tapvpwrvgnd_1
XTAP_354 VGND VPWR sky130_fd_sc_hd__tapvpwrvgnd_1
XTAP_343 VGND VPWR sky130_fd_sc_hd__tapvpwrvgnd_1
X_08712_ _03046_ _03047_ _03057_ _03071_ _03072_ VGND VGND VPWR VPWR _03073_ sky130_fd_sc_hd__a32o_1
XTAP_387 VGND VPWR sky130_fd_sc_hd__tapvpwrvgnd_1
XTAP_398 VGND VPWR sky130_fd_sc_hd__tapvpwrvgnd_1
Xrebuffer12 net371 VGND VGND VPWR VPWR net370 sky130_fd_sc_hd__clkbuf_1
X_09692_ _03744_ _03919_ _03923_ _03685_ VGND VGND VPWR VPWR _03924_ sky130_fd_sc_hd__o211a_1
X_08643_ _02416_ _02688_ _03008_ _03009_ VGND VGND VPWR VPWR _03010_ sky130_fd_sc_hd__o22a_1
XFILLER_0_13_3 VGND VGND VPWR VPWR sky130_fd_sc_hd__decap_4
Xrebuffer23 _06119_ VGND VGND VPWR VPWR net381 sky130_fd_sc_hd__clkbuf_1
X_08574_ net248 _02945_ VGND VGND VPWR VPWR _02946_ sky130_fd_sc_hd__xnor2_1
XFILLER_0_88_170 VGND VGND VPWR VPWR sky130_fd_sc_hd__fill_2
XTAP_1509 VGND VPWR sky130_fd_sc_hd__tapvpwrvgnd_1
XFILLER_0_49_502 VGND VGND VPWR VPWR sky130_fd_sc_hd__fill_2
XPHY_16 VGND VGND VPWR VPWR sky130_fd_sc_hd__decap_3
XPHY_27 VGND VGND VPWR VPWR sky130_fd_sc_hd__decap_3
XPHY_38 VGND VGND VPWR VPWR sky130_fd_sc_hd__decap_3
XPHY_49 VGND VGND VPWR VPWR sky130_fd_sc_hd__decap_3
Xclkbuf_leaf_61_clk clknet_4_13_0_clk VGND VGND VPWR VPWR clknet_leaf_61_clk sky130_fd_sc_hd__clkbuf_16
XFILLER_0_123_80 VGND VGND VPWR VPWR sky130_fd_sc_hd__fill_1
XFILLER_0_29_281 VPWR VGND VPWR VGND sky130_ef_sc_hd__decap_12
XFILLER_0_91_368 VGND VGND VPWR VPWR sky130_fd_sc_hd__fill_2
XFILLER_0_8_197 VGND VGND VPWR VPWR sky130_fd_sc_hd__decap_3
X_09126_ _03309_ _03397_ _03399_ _03402_ _03404_ VGND VGND VPWR VPWR _03405_ sky130_fd_sc_hd__a32o_1
XFILLER_0_32_402 VGND VGND VPWR VPWR sky130_fd_sc_hd__fill_2
XFILLER_0_130_610 VGND VGND VPWR VPWR sky130_fd_sc_hd__fill_1
X_09057_ cpuregs\[24\]\[2\] cpuregs\[25\]\[2\] cpuregs\[26\]\[2\] cpuregs\[27\]\[2\]
+ _03336_ _03337_ VGND VGND VPWR VPWR _03338_ sky130_fd_sc_hd__mux4_1
X_08008_ _02397_ _02407_ VGND VGND VPWR VPWR _07622_ sky130_fd_sc_hd__nor2_1
Xhold561 cpuregs\[6\]\[21\] VGND VGND VPWR VPWR net919 sky130_fd_sc_hd__dlygate4sd3_1
Xhold550 cpuregs\[13\]\[19\] VGND VGND VPWR VPWR net908 sky130_fd_sc_hd__dlygate4sd3_1
Xhold572 cpuregs\[28\]\[3\] VGND VGND VPWR VPWR net930 sky130_fd_sc_hd__dlygate4sd3_1
Xhold594 cpuregs\[15\]\[24\] VGND VGND VPWR VPWR net952 sky130_fd_sc_hd__dlygate4sd3_1
Xhold583 cpuregs\[10\]\[30\] VGND VGND VPWR VPWR net941 sky130_fd_sc_hd__dlygate4sd3_1
X_09959_ _04184_ _02366_ _04150_ VGND VGND VPWR VPWR _04185_ sky130_fd_sc_hd__mux2_1
XFILLER_0_99_424 VGND VGND VPWR VPWR sky130_fd_sc_hd__fill_1
Xhold1250 cpuregs\[21\]\[19\] VGND VGND VPWR VPWR net1608 sky130_fd_sc_hd__dlygate4sd3_1
Xhold1261 decoded_imm\[19\] VGND VGND VPWR VPWR net1619 sky130_fd_sc_hd__dlygate4sd3_1
X_12970_ _06461_ _06463_ VGND VGND VPWR VPWR _06464_ sky130_fd_sc_hd__and2_1
Xhold1283 decoded_imm\[14\] VGND VGND VPWR VPWR net1641 sky130_fd_sc_hd__dlygate4sd3_1
Xhold1272 mem_rdata_q\[24\] VGND VGND VPWR VPWR net1630 sky130_fd_sc_hd__dlygate4sd3_1
Xhold1294 cpuregs\[15\]\[1\] VGND VGND VPWR VPWR net1652 sky130_fd_sc_hd__dlygate4sd3_1
X_11921_ _05611_ VGND VGND VPWR VPWR _00614_ sky130_fd_sc_hd__clkbuf_1
X_11852_ net505 net380 _05561_ VGND VGND VPWR VPWR _00595_ sky130_fd_sc_hd__o21a_1
X_14640_ net695 _05167_ _01684_ VGND VGND VPWR VPWR _01688_ sky130_fd_sc_hd__mux2_1
X_10803_ net711 _03538_ _04957_ VGND VGND VPWR VPWR _04962_ sky130_fd_sc_hd__mux2_1
X_14571_ _01651_ VGND VGND VPWR VPWR _01159_ sky130_fd_sc_hd__clkbuf_1
X_11783_ _05041_ net1579 _05505_ VGND VGND VPWR VPWR _05513_ sky130_fd_sc_hd__mux2_1
X_13522_ _06699_ _06997_ _06998_ VGND VGND VPWR VPWR _06999_ sky130_fd_sc_hd__a21o_1
Xclkbuf_leaf_52_clk clknet_4_6_0_clk VGND VGND VPWR VPWR clknet_leaf_52_clk sky130_fd_sc_hd__clkbuf_16
X_16310_ clknet_leaf_27_clk _00895_ VGND VGND VPWR VPWR decoded_imm_j\[19\] sky130_fd_sc_hd__dfxtp_2
XFILLER_0_55_505 VGND VGND VPWR VPWR sky130_fd_sc_hd__decap_8
XFILLER_0_27_207 VGND VGND VPWR VPWR sky130_fd_sc_hd__fill_1
XFILLER_0_103_17 VGND VGND VPWR VPWR sky130_fd_sc_hd__fill_1
XFILLER_0_94_184 VGND VGND VPWR VPWR sky130_fd_sc_hd__decap_3
X_10734_ net586 _03544_ _04918_ VGND VGND VPWR VPWR _04924_ sky130_fd_sc_hd__mux2_1
X_10665_ decoded_imm\[29\] _02632_ _04830_ VGND VGND VPWR VPWR _04871_ sky130_fd_sc_hd__o21a_1
X_13453_ cpuregs\[8\]\[20\] cpuregs\[9\]\[20\] _06764_ VGND VGND VPWR VPWR _06932_
+ sky130_fd_sc_hd__mux2_1
X_16241_ clknet_leaf_21_clk alu_out\[14\] VGND VGND VPWR VPWR alu_out_q\[14\] sky130_fd_sc_hd__dfxtp_1
X_12404_ _05790_ _05744_ _06011_ _05802_ VGND VGND VPWR VPWR _06012_ sky130_fd_sc_hd__a22o_1
X_13384_ _06865_ VGND VGND VPWR VPWR _00823_ sky130_fd_sc_hd__clkbuf_1
X_16172_ clknet_leaf_154_clk _00790_ VGND VGND VPWR VPWR net45 sky130_fd_sc_hd__dfxtp_1
X_10596_ _03834_ _04801_ _04803_ VGND VGND VPWR VPWR _04804_ sky130_fd_sc_hd__a21o_1
X_12335_ _05861_ _05871_ _05905_ _05946_ VGND VGND VPWR VPWR _05948_ sky130_fd_sc_hd__or4_1
XFILLER_0_50_210 VGND VGND VPWR VPWR sky130_fd_sc_hd__decap_8
X_15123_ net1244 _03483_ _01937_ VGND VGND VPWR VPWR _01944_ sky130_fd_sc_hd__mux2_1
XFILLER_0_121_632 VGND VGND VPWR VPWR sky130_fd_sc_hd__decap_4
XFILLER_0_105_183 VGND VGND VPWR VPWR sky130_fd_sc_hd__decap_3
XFILLER_0_50_276 VGND VGND VPWR VPWR sky130_fd_sc_hd__fill_1
X_12266_ _05714_ _05868_ _02154_ VGND VGND VPWR VPWR _05885_ sky130_fd_sc_hd__a21o_1
X_15054_ _01907_ VGND VGND VPWR VPWR _01386_ sky130_fd_sc_hd__clkbuf_1
XFILLER_0_120_197 VGND VGND VPWR VPWR sky130_fd_sc_hd__fill_1
X_11217_ net627 _05207_ _05203_ VGND VGND VPWR VPWR _05208_ sky130_fd_sc_hd__mux2_1
X_12197_ _05806_ _05810_ VGND VGND VPWR VPWR _05821_ sky130_fd_sc_hd__nand2_1
Xoutput70 net70 VGND VGND VPWR VPWR mem_la_addr[14] sky130_fd_sc_hd__clkbuf_4
X_14005_ _02456_ _07382_ _07412_ _07418_ VGND VGND VPWR VPWR _00882_ sky130_fd_sc_hd__a22o_1
Xoutput92 net92 VGND VGND VPWR VPWR mem_la_addr[6] sky130_fd_sc_hd__clkbuf_4
Xoutput81 net81 VGND VGND VPWR VPWR mem_la_addr[25] sky130_fd_sc_hd__clkbuf_4
X_11148_ _05160_ VGND VGND VPWR VPWR _05161_ sky130_fd_sc_hd__buf_4
X_15956_ clknet_leaf_153_clk _00606_ VGND VGND VPWR VPWR count_instr\[25\] sky130_fd_sc_hd__dfxtp_1
X_11079_ _05123_ VGND VGND VPWR VPWR _05124_ sky130_fd_sc_hd__buf_4
X_15887_ clknet_leaf_62_clk _00537_ VGND VGND VPWR VPWR cpuregs\[20\]\[21\] sky130_fd_sc_hd__dfxtp_1
X_14907_ _03440_ net1549 _01829_ VGND VGND VPWR VPWR _01830_ sky130_fd_sc_hd__mux2_1
X_14838_ _01792_ VGND VGND VPWR VPWR _01793_ sky130_fd_sc_hd__clkbuf_8
Xclkbuf_leaf_43_clk clknet_4_7_0_clk VGND VGND VPWR VPWR clknet_leaf_43_clk sky130_fd_sc_hd__clkbuf_16
XFILLER_0_74_825 VGND VGND VPWR VPWR sky130_fd_sc_hd__fill_1
XFILLER_0_46_505 VGND VGND VPWR VPWR sky130_fd_sc_hd__decap_3
X_14769_ _01755_ VGND VGND VPWR VPWR _01756_ sky130_fd_sc_hd__buf_4
X_16508_ clknet_leaf_44_clk _01090_ VGND VGND VPWR VPWR cpuregs\[19\]\[29\] sky130_fd_sc_hd__dfxtp_1
XFILLER_0_85_173 VGND VGND VPWR VPWR sky130_fd_sc_hd__fill_1
X_08290_ net233 VGND VGND VPWR VPWR _02671_ sky130_fd_sc_hd__buf_4
XFILLER_0_73_324 VGND VGND VPWR VPWR sky130_fd_sc_hd__decap_6
XFILLER_0_46_549 VGND VGND VPWR VPWR sky130_fd_sc_hd__fill_1
XFILLER_0_18_229 VGND VGND VPWR VPWR sky130_fd_sc_hd__fill_2
X_16439_ clknet_leaf_10_clk _01021_ VGND VGND VPWR VPWR decoded_imm\[8\] sky130_fd_sc_hd__dfxtp_2
XFILLER_0_100_805 VGND VGND VPWR VPWR sky130_fd_sc_hd__fill_1
XFILLER_0_112_698 VGND VGND VPWR VPWR sky130_fd_sc_hd__fill_2
XFILLER_0_111_175 VGND VGND VPWR VPWR sky130_fd_sc_hd__decap_3
XFILLER_0_10_685 VGND VGND VPWR VPWR sky130_fd_sc_hd__fill_2
XFILLER_0_10_696 VGND VGND VPWR VPWR sky130_fd_sc_hd__decap_4
X_09813_ _04020_ _04037_ _04041_ _00015_ VGND VGND VPWR VPWR _04042_ sky130_fd_sc_hd__o211a_1
XFILLER_0_94_40 VGND VGND VPWR VPWR sky130_fd_sc_hd__decap_8
X_09744_ _03662_ _03974_ VGND VGND VPWR VPWR _03975_ sky130_fd_sc_hd__or2_1
XTAP_2007 VGND VPWR sky130_fd_sc_hd__tapvpwrvgnd_1
X_09675_ _03657_ _03887_ _03907_ _03776_ reg_pc\[3\] VGND VGND VPWR VPWR _03908_ sky130_fd_sc_hd__a32o_1
XTAP_2018 VGND VPWR sky130_fd_sc_hd__tapvpwrvgnd_1
XTAP_2029 VGND VPWR sky130_fd_sc_hd__tapvpwrvgnd_1
X_08626_ _02803_ _02992_ VGND VGND VPWR VPWR _02994_ sky130_fd_sc_hd__and2_1
XTAP_1339 VGND VPWR sky130_fd_sc_hd__tapvpwrvgnd_1
XTAP_1328 VGND VPWR sky130_fd_sc_hd__tapvpwrvgnd_1
XTAP_1317 VGND VPWR sky130_fd_sc_hd__tapvpwrvgnd_1
XTAP_1306 VGND VPWR sky130_fd_sc_hd__tapvpwrvgnd_1
XFILLER_0_49_310 VGND VGND VPWR VPWR sky130_fd_sc_hd__decap_4
Xclkbuf_leaf_34_clk clknet_4_5_0_clk VGND VGND VPWR VPWR clknet_leaf_34_clk sky130_fd_sc_hd__clkbuf_16
X_08557_ _02673_ _02895_ _02929_ VGND VGND VPWR VPWR _02930_ sky130_fd_sc_hd__a21o_1
XFILLER_0_37_505 VGND VGND VPWR VPWR sky130_fd_sc_hd__fill_2
X_08488_ net240 VGND VGND VPWR VPWR _02867_ sky130_fd_sc_hd__buf_4
XFILLER_0_64_335 VGND VGND VPWR VPWR sky130_fd_sc_hd__fill_2
XFILLER_0_107_426 VGND VGND VPWR VPWR sky130_fd_sc_hd__fill_2
XFILLER_0_64_368 VGND VGND VPWR VPWR sky130_fd_sc_hd__fill_1
XFILLER_0_52_508 VGND VGND VPWR VPWR sky130_fd_sc_hd__decap_6
X_10450_ cpuregs\[28\]\[24\] cpuregs\[29\]\[24\] cpuregs\[30\]\[24\] cpuregs\[31\]\[24\]
+ _03751_ _03929_ VGND VGND VPWR VPWR _04662_ sky130_fd_sc_hd__mux4_1
XFILLER_0_92_699 VGND VGND VPWR VPWR sky130_fd_sc_hd__fill_1
XFILLER_0_17_262 VGND VGND VPWR VPWR sky130_fd_sc_hd__decap_4
X_09109_ _03311_ _03384_ _03388_ _03308_ VGND VGND VPWR VPWR _03389_ sky130_fd_sc_hd__o211a_1
X_10381_ cpuregs\[4\]\[22\] cpuregs\[5\]\[22\] cpuregs\[6\]\[22\] cpuregs\[7\]\[22\]
+ _03894_ _04090_ VGND VGND VPWR VPWR _04595_ sky130_fd_sc_hd__mux4_1
X_12120_ _05737_ reg_pc\[27\] VGND VGND VPWR VPWR _05754_ sky130_fd_sc_hd__or2_1
XFILLER_0_20_438 VGND VGND VPWR VPWR sky130_fd_sc_hd__decap_3
X_12051_ _05688_ _05704_ _05705_ _02142_ VGND VGND VPWR VPWR _00650_ sky130_fd_sc_hd__o211a_1
Xhold380 cpuregs\[27\]\[2\] VGND VGND VPWR VPWR net738 sky130_fd_sc_hd__dlygate4sd3_1
X_11002_ _05043_ net1193 _05074_ VGND VGND VPWR VPWR _05083_ sky130_fd_sc_hd__mux2_1
XFILLER_0_102_197 VGND VGND VPWR VPWR sky130_fd_sc_hd__fill_2
Xhold391 cpuregs\[2\]\[10\] VGND VGND VPWR VPWR net749 sky130_fd_sc_hd__dlygate4sd3_1
X_15810_ clknet_leaf_143_clk _00460_ VGND VGND VPWR VPWR cpuregs\[16\]\[8\] sky130_fd_sc_hd__dfxtp_1
X_16790_ clknet_leaf_131_clk _01354_ VGND VGND VPWR VPWR cpuregs\[6\]\[5\] sky130_fd_sc_hd__dfxtp_1
X_15741_ clknet_leaf_122_clk _00391_ VGND VGND VPWR VPWR cpuregs\[15\]\[3\] sky130_fd_sc_hd__dfxtp_1
X_12953_ _06348_ VGND VGND VPWR VPWR _06447_ sky130_fd_sc_hd__buf_4
X_15672_ clknet_leaf_92_clk _00322_ VGND VGND VPWR VPWR cpuregs\[14\]\[30\] sky130_fd_sc_hd__dfxtp_1
Xhold1080 cpuregs\[8\]\[11\] VGND VGND VPWR VPWR net1438 sky130_fd_sc_hd__dlygate4sd3_1
X_11904_ count_instr\[29\] count_instr\[28\] _05594_ VGND VGND VPWR VPWR _05599_ sky130_fd_sc_hd__and3_1
Xhold1091 cpuregs\[5\]\[7\] VGND VGND VPWR VPWR net1449 sky130_fd_sc_hd__dlygate4sd3_1
X_14623_ _01678_ VGND VGND VPWR VPWR _01184_ sky130_fd_sc_hd__clkbuf_1
X_12884_ _03317_ VGND VGND VPWR VPWR _06382_ sky130_fd_sc_hd__buf_4
XFILLER_0_114_49 VGND VGND VPWR VPWR sky130_fd_sc_hd__fill_1
XTAP_1851 VGND VPWR sky130_fd_sc_hd__tapvpwrvgnd_1
XTAP_1840 VGND VPWR sky130_fd_sc_hd__tapvpwrvgnd_1
Xclkbuf_leaf_25_clk clknet_4_4_0_clk VGND VGND VPWR VPWR clknet_leaf_25_clk sky130_fd_sc_hd__clkbuf_16
XFILLER_0_68_674 VGND VGND VPWR VPWR sky130_fd_sc_hd__fill_1
XFILLER_0_68_663 VGND VGND VPWR VPWR sky130_fd_sc_hd__fill_2
XFILLER_0_67_151 VGND VGND VPWR VPWR sky130_fd_sc_hd__decap_3
X_11835_ _05549_ VGND VGND VPWR VPWR _00590_ sky130_fd_sc_hd__clkbuf_1
X_14554_ net883 _05217_ _01634_ VGND VGND VPWR VPWR _01642_ sky130_fd_sc_hd__mux2_1
XTAP_1884 VGND VPWR sky130_fd_sc_hd__tapvpwrvgnd_1
XTAP_1873 VGND VPWR sky130_fd_sc_hd__tapvpwrvgnd_1
XTAP_1862 VGND VPWR sky130_fd_sc_hd__tapvpwrvgnd_1
X_11766_ _05024_ net1491 _05494_ VGND VGND VPWR VPWR _05504_ sky130_fd_sc_hd__mux2_1
X_14485_ _01605_ VGND VGND VPWR VPWR _01087_ sky130_fd_sc_hd__clkbuf_1
X_13505_ cpuregs\[22\]\[21\] cpuregs\[23\]\[21\] _06786_ VGND VGND VPWR VPWR _06983_
+ sky130_fd_sc_hd__mux2_1
XTAP_1895 VGND VPWR sky130_fd_sc_hd__tapvpwrvgnd_1
XFILLER_0_99_29 VGND VGND VPWR VPWR sky130_fd_sc_hd__fill_2
X_10717_ net661 _03491_ _04907_ VGND VGND VPWR VPWR _04915_ sky130_fd_sc_hd__mux2_1
X_11697_ _05467_ VGND VGND VPWR VPWR _00534_ sky130_fd_sc_hd__clkbuf_1
X_13436_ cpuregs\[16\]\[19\] cpuregs\[17\]\[19\] cpuregs\[18\]\[19\] cpuregs\[19\]\[19\]
+ _06614_ _06648_ VGND VGND VPWR VPWR _06916_ sky130_fd_sc_hd__mux4_1
XFILLER_0_82_176 VGND VGND VPWR VPWR sky130_fd_sc_hd__decap_6
X_16224_ clknet_leaf_4_clk _00841_ VGND VGND VPWR VPWR decoder_pseudo_trigger sky130_fd_sc_hd__dfxtp_1
XFILLER_0_130_59 VGND VGND VPWR VPWR sky130_fd_sc_hd__fill_1
X_10648_ _04119_ _04854_ _04121_ VGND VGND VPWR VPWR _04855_ sky130_fd_sc_hd__a21o_1
Xrebuffer3 _06135_ VGND VGND VPWR VPWR net361 sky130_fd_sc_hd__clkbuf_1
XFILLER_0_24_755 VGND VGND VPWR VPWR sky130_fd_sc_hd__fill_1
XFILLER_0_140_237 VGND VGND VPWR VPWR sky130_fd_sc_hd__decap_4
X_10579_ _02653_ _03648_ _03845_ VGND VGND VPWR VPWR _04787_ sky130_fd_sc_hd__a21oi_1
X_13367_ _03318_ VGND VGND VPWR VPWR _06849_ sky130_fd_sc_hd__buf_2
X_16155_ clknet_leaf_144_clk _00773_ VGND VGND VPWR VPWR net58 sky130_fd_sc_hd__dfxtp_1
X_12318_ _05785_ _05724_ _05930_ _05932_ VGND VGND VPWR VPWR _05933_ sky130_fd_sc_hd__a22o_1
X_15106_ _01934_ VGND VGND VPWR VPWR _01411_ sky130_fd_sc_hd__clkbuf_1
X_13298_ _06518_ _06781_ VGND VGND VPWR VPWR _06782_ sky130_fd_sc_hd__or2_1
X_16086_ clknet_leaf_3_clk net539 VGND VGND VPWR VPWR count_cycle\[29\] sky130_fd_sc_hd__dfxtp_1
X_15037_ _03641_ net745 _01864_ VGND VGND VPWR VPWR _01898_ sky130_fd_sc_hd__mux2_1
X_12249_ decoded_imm_j\[10\] _05712_ VGND VGND VPWR VPWR _05869_ sky130_fd_sc_hd__or2_1
XFILLER_0_139_57 VPWR VGND VPWR VGND sky130_ef_sc_hd__decap_12
XFILLER_0_48_99 VGND VGND VPWR VPWR sky130_fd_sc_hd__decap_4
X_07790_ instr_rdcycleh VGND VGND VPWR VPWR _02204_ sky130_fd_sc_hd__clkbuf_4
XFILLER_0_3_79 VGND VGND VPWR VPWR sky130_fd_sc_hd__decap_3
X_15939_ clknet_leaf_145_clk _00589_ VGND VGND VPWR VPWR count_instr\[8\] sky130_fd_sc_hd__dfxtp_1
X_09460_ _03695_ VGND VGND VPWR VPWR _03696_ sky130_fd_sc_hd__buf_4
X_08411_ _02665_ _02666_ _02791_ VGND VGND VPWR VPWR _02792_ sky130_fd_sc_hd__a21o_1
X_09391_ _03630_ VGND VGND VPWR VPWR _00065_ sky130_fd_sc_hd__clkbuf_1
Xclkbuf_leaf_16_clk clknet_4_6_0_clk VGND VGND VPWR VPWR clknet_leaf_16_clk sky130_fd_sc_hd__clkbuf_16
X_08342_ net187 net219 VGND VGND VPWR VPWR _02723_ sky130_fd_sc_hd__or2_1
X_08273_ count_instr\[31\] instr_rdinstr count_cycle\[63\] _02237_ VGND VGND VPWR
+ VPWR _02655_ sky130_fd_sc_hd__a22o_1
XFILLER_0_74_699 VGND VGND VPWR VPWR sky130_fd_sc_hd__fill_1
XFILLER_0_6_421 VGND VGND VPWR VPWR sky130_fd_sc_hd__decap_4
XFILLER_0_131_204 VPWR VGND VPWR VGND sky130_ef_sc_hd__decap_12
XFILLER_0_104_407 VGND VGND VPWR VPWR sky130_fd_sc_hd__decap_3
XFILLER_0_125_790 VGND VGND VPWR VPWR sky130_fd_sc_hd__fill_2
XFILLER_0_140_793 VGND VGND VPWR VPWR sky130_fd_sc_hd__fill_1
XFILLER_0_112_473 VGND VGND VPWR VPWR sky130_fd_sc_hd__decap_3
XFILLER_0_100_657 VGND VGND VPWR VPWR sky130_fd_sc_hd__decap_6
X_07988_ _02224_ _02187_ net21 _02210_ net4 VGND VGND VPWR VPWR _02389_ sky130_fd_sc_hd__a32o_1
X_09727_ _03953_ _03956_ _02081_ VGND VGND VPWR VPWR _03958_ sky130_fd_sc_hd__o21a_1
XFILLER_0_69_427 VGND VGND VPWR VPWR sky130_fd_sc_hd__fill_2
XTAP_1114 VGND VPWR sky130_fd_sc_hd__tapvpwrvgnd_1
XTAP_1103 VGND VPWR sky130_fd_sc_hd__tapvpwrvgnd_1
X_09658_ _03868_ _03890_ _03870_ VGND VGND VPWR VPWR _03891_ sky130_fd_sc_hd__a21o_1
XFILLER_0_139_337 VGND VGND VPWR VPWR sky130_fd_sc_hd__fill_1
X_08609_ _02958_ _02968_ VGND VGND VPWR VPWR _02978_ sky130_fd_sc_hd__nand2_1
XFILLER_0_84_419 VGND VGND VPWR VPWR sky130_fd_sc_hd__fill_1
XTAP_1147 VGND VPWR sky130_fd_sc_hd__tapvpwrvgnd_1
XTAP_1136 VGND VPWR sky130_fd_sc_hd__tapvpwrvgnd_1
XTAP_1125 VGND VPWR sky130_fd_sc_hd__tapvpwrvgnd_1
X_09589_ _03722_ VGND VGND VPWR VPWR _03823_ sky130_fd_sc_hd__clkbuf_8
X_11620_ _05014_ net1079 _05422_ VGND VGND VPWR VPWR _05427_ sky130_fd_sc_hd__mux2_1
XFILLER_0_65_622 VGND VGND VPWR VPWR sky130_fd_sc_hd__fill_2
XTAP_1158 VGND VPWR sky130_fd_sc_hd__tapvpwrvgnd_1
XTAP_1169 VGND VPWR sky130_fd_sc_hd__tapvpwrvgnd_1
XFILLER_0_49_173 VGND VGND VPWR VPWR sky130_fd_sc_hd__fill_1
X_11551_ _05390_ VGND VGND VPWR VPWR _00465_ sky130_fd_sc_hd__clkbuf_1
X_10502_ _03900_ _04712_ _03839_ VGND VGND VPWR VPWR _04713_ sky130_fd_sc_hd__a21o_1
XFILLER_0_64_165 VPWR VGND VPWR VGND sky130_ef_sc_hd__decap_12
XFILLER_0_64_154 VGND VGND VPWR VPWR sky130_fd_sc_hd__fill_2
XFILLER_0_123_727 VGND VGND VPWR VPWR sky130_fd_sc_hd__fill_1
XFILLER_0_107_256 VGND VGND VPWR VPWR sky130_fd_sc_hd__decap_3
X_11482_ _05353_ VGND VGND VPWR VPWR _00433_ sky130_fd_sc_hd__clkbuf_1
XFILLER_0_52_338 VGND VGND VPWR VPWR sky130_fd_sc_hd__fill_2
X_14270_ latched_rd\[1\] _07560_ _07561_ net397 VGND VGND VPWR VPWR _00992_ sky130_fd_sc_hd__a22o_1
X_10433_ _04645_ _02548_ _04509_ VGND VGND VPWR VPWR _04646_ sky130_fd_sc_hd__mux2_1
X_13221_ _06434_ _06706_ VGND VGND VPWR VPWR _06707_ sky130_fd_sc_hd__and2_1
X_10364_ decoded_imm\[22\] net185 VGND VGND VPWR VPWR _04578_ sky130_fd_sc_hd__nand2_1
X_13152_ cpuregs\[4\]\[11\] cpuregs\[5\]\[11\] _06575_ VGND VGND VPWR VPWR _06640_
+ sky130_fd_sc_hd__mux2_1
XFILLER_0_21_725 VGND VGND VPWR VPWR sky130_fd_sc_hd__decap_3
X_12103_ latched_branch latched_store _03586_ VGND VGND VPWR VPWR _05742_ sky130_fd_sc_hd__and3_1
X_10295_ _04473_ _04476_ _04474_ VGND VGND VPWR VPWR _04511_ sky130_fd_sc_hd__o21ai_1
X_13083_ _06537_ _06570_ _06572_ VGND VGND VPWR VPWR _06573_ sky130_fd_sc_hd__a21o_1
XTAP_909 VGND VPWR sky130_fd_sc_hd__tapvpwrvgnd_1
X_16911_ clknet_leaf_82_clk _01475_ VGND VGND VPWR VPWR cpuregs\[8\]\[30\] sky130_fd_sc_hd__dfxtp_1
X_12034_ _05692_ VGND VGND VPWR VPWR _05693_ sky130_fd_sc_hd__buf_2
X_16842_ clknet_leaf_72_clk _01406_ VGND VGND VPWR VPWR cpuregs\[7\]\[25\] sky130_fd_sc_hd__dfxtp_1
X_16773_ clknet_leaf_84_clk _01337_ VGND VGND VPWR VPWR cpuregs\[5\]\[20\] sky130_fd_sc_hd__dfxtp_1
X_13985_ instr_or _07324_ _07346_ _07384_ VGND VGND VPWR VPWR _07403_ sky130_fd_sc_hd__a22o_1
XFILLER_0_34_13 VGND VGND VPWR VPWR sky130_fd_sc_hd__fill_1
X_15724_ clknet_leaf_56_clk _00374_ VGND VGND VPWR VPWR cpuregs\[21\]\[18\] sky130_fd_sc_hd__dfxtp_1
X_12936_ _03311_ VGND VGND VPWR VPWR _06430_ sky130_fd_sc_hd__buf_4
XFILLER_0_34_35 VGND VGND VPWR VPWR sky130_fd_sc_hd__fill_1
X_15655_ clknet_leaf_103_clk _00305_ VGND VGND VPWR VPWR cpuregs\[14\]\[13\] sky130_fd_sc_hd__dfxtp_1
X_12867_ _06343_ _06365_ _03332_ VGND VGND VPWR VPWR _06366_ sky130_fd_sc_hd__o21a_1
X_14606_ _01669_ VGND VGND VPWR VPWR _01176_ sky130_fd_sc_hd__clkbuf_1
XFILLER_0_55_110 VGND VGND VPWR VPWR sky130_fd_sc_hd__fill_2
X_15586_ clknet_leaf_128_clk _00236_ VGND VGND VPWR VPWR cpuregs\[28\]\[8\] sky130_fd_sc_hd__dfxtp_1
X_11818_ count_instr\[4\] _05529_ count_instr\[5\] VGND VGND VPWR VPWR _05537_ sky130_fd_sc_hd__a21o_1
XTAP_1692 VGND VPWR sky130_fd_sc_hd__tapvpwrvgnd_1
XTAP_1681 VGND VPWR sky130_fd_sc_hd__tapvpwrvgnd_1
XTAP_1670 VGND VPWR sky130_fd_sc_hd__tapvpwrvgnd_1
X_14537_ net793 _05200_ _01623_ VGND VGND VPWR VPWR _01633_ sky130_fd_sc_hd__mux2_1
X_12798_ net526 net75 _06313_ VGND VGND VPWR VPWR _06314_ sky130_fd_sc_hd__mux2_1
X_11749_ _05495_ VGND VGND VPWR VPWR _00558_ sky130_fd_sc_hd__clkbuf_1
XFILLER_0_55_165 VGND VGND VPWR VPWR sky130_fd_sc_hd__decap_3
XFILLER_0_16_508 VGND VGND VPWR VPWR sky130_fd_sc_hd__fill_1
XFILLER_0_43_305 VGND VGND VPWR VPWR sky130_fd_sc_hd__fill_2
X_14468_ _01596_ VGND VGND VPWR VPWR _01079_ sky130_fd_sc_hd__clkbuf_1
X_14399_ _05022_ net1195 _01551_ VGND VGND VPWR VPWR _01560_ sky130_fd_sc_hd__mux2_1
X_13419_ _06899_ VGND VGND VPWR VPWR _00824_ sky130_fd_sc_hd__clkbuf_1
X_16207_ clknet_leaf_54_clk _00824_ VGND VGND VPWR VPWR net212 sky130_fd_sc_hd__dfxtp_1
Xpicorv32_302 VGND VGND VPWR VPWR picorv32_302/HI pcpi_insn[13] sky130_fd_sc_hd__conb_1
XFILLER_0_24_541 VGND VGND VPWR VPWR sky130_fd_sc_hd__decap_3
Xpicorv32_335 VGND VGND VPWR VPWR picorv32_335/HI trace_data[13] sky130_fd_sc_hd__conb_1
XFILLER_0_122_760 VGND VGND VPWR VPWR sky130_fd_sc_hd__fill_2
X_16138_ clknet_leaf_22_clk _07625_ VGND VGND VPWR VPWR reg_out\[16\] sky130_fd_sc_hd__dfxtp_1
Xpicorv32_313 VGND VGND VPWR VPWR picorv32_313/HI pcpi_insn[24] sky130_fd_sc_hd__conb_1
Xpicorv32_324 VGND VGND VPWR VPWR picorv32_324/HI trace_data[2] sky130_fd_sc_hd__conb_1
Xpicorv32_357 VGND VGND VPWR VPWR picorv32_357/HI trace_data[35] sky130_fd_sc_hd__conb_1
XFILLER_0_51_393 VGND VGND VPWR VPWR sky130_fd_sc_hd__decap_4
Xpicorv32_346 VGND VGND VPWR VPWR picorv32_346/HI trace_data[24] sky130_fd_sc_hd__conb_1
XFILLER_0_121_281 VGND VGND VPWR VPWR sky130_fd_sc_hd__fill_2
X_08960_ _03264_ VGND VGND VPWR VPWR net75 sky130_fd_sc_hd__buf_2
XFILLER_0_52_7 VGND VGND VPWR VPWR sky130_fd_sc_hd__fill_2
X_16069_ clknet_leaf_147_clk _00719_ VGND VGND VPWR VPWR count_cycle\[12\] sky130_fd_sc_hd__dfxtp_1
Xclkbuf_leaf_5_clk clknet_4_1_0_clk VGND VGND VPWR VPWR clknet_leaf_5_clk sky130_fd_sc_hd__clkbuf_16
X_08891_ net219 _03204_ _03205_ VGND VGND VPWR VPWR net113 sky130_fd_sc_hd__a21o_2
XFILLER_0_45_6 VGND VGND VPWR VPWR sky130_fd_sc_hd__fill_2
X_07911_ count_instr\[39\] _02269_ _02235_ _02316_ VGND VGND VPWR VPWR _02317_ sky130_fd_sc_hd__a211o_1
X_07842_ _02246_ _02252_ VGND VGND VPWR VPWR _02253_ sky130_fd_sc_hd__or2_1
X_09512_ _00016_ VGND VGND VPWR VPWR _03747_ sky130_fd_sc_hd__clkbuf_8
X_07773_ is_sb_sh_sw VGND VGND VPWR VPWR _02189_ sky130_fd_sc_hd__clkbuf_4
X_09443_ _03677_ _03678_ VGND VGND VPWR VPWR _03679_ sky130_fd_sc_hd__or2_1
X_09374_ _03615_ VGND VGND VPWR VPWR _03616_ sky130_fd_sc_hd__clkbuf_4
XPHY_219 VGND VGND VPWR VPWR sky130_fd_sc_hd__decap_3
XPHY_208 VGND VGND VPWR VPWR sky130_fd_sc_hd__decap_3
XFILLER_0_93_216 VGND VGND VPWR VPWR sky130_fd_sc_hd__fill_2
X_08325_ _02704_ _02705_ VGND VGND VPWR VPWR _02706_ sky130_fd_sc_hd__and2_1
XFILLER_0_46_132 VGND VGND VPWR VPWR sky130_fd_sc_hd__decap_8
XFILLER_0_117_521 VGND VGND VPWR VPWR sky130_fd_sc_hd__fill_1
XFILLER_0_132_502 VGND VGND VPWR VPWR sky130_fd_sc_hd__decap_3
X_08256_ reg_pc\[30\] decoded_imm\[30\] VGND VGND VPWR VPWR _02639_ sky130_fd_sc_hd__nand2_1
XFILLER_0_7_785 VPWR VGND VPWR VGND sky130_ef_sc_hd__decap_12
XFILLER_0_34_338 VGND VGND VPWR VPWR sky130_fd_sc_hd__fill_2
X_08187_ _02573_ _02574_ VGND VGND VPWR VPWR _02575_ sky130_fd_sc_hd__or2_1
XFILLER_0_104_226 VGND VGND VPWR VPWR sky130_fd_sc_hd__decap_4
XFILLER_0_15_541 VGND VGND VPWR VPWR sky130_fd_sc_hd__decap_3
XFILLER_0_42_371 VGND VGND VPWR VPWR sky130_fd_sc_hd__fill_1
X_10080_ _02082_ _04298_ _04299_ _04301_ VGND VGND VPWR VPWR _04302_ sky130_fd_sc_hd__a31o_1
X_10982_ _05072_ VGND VGND VPWR VPWR _00214_ sky130_fd_sc_hd__clkbuf_1
X_13770_ cpuregs\[6\]\[30\] cpuregs\[7\]\[30\] _06383_ VGND VGND VPWR VPWR _07239_
+ sky130_fd_sc_hd__mux2_1
XFILLER_0_69_213 VGND VGND VPWR VPWR sky130_fd_sc_hd__decap_6
X_12721_ _04869_ _04873_ _06253_ _02152_ VGND VGND VPWR VPWR _06255_ sky130_fd_sc_hd__a31o_1
X_15440_ clknet_leaf_44_clk _00090_ VGND VGND VPWR VPWR net184 sky130_fd_sc_hd__dfxtp_4
XFILLER_0_84_205 VGND VGND VPWR VPWR sky130_fd_sc_hd__fill_2
X_12652_ count_cycle\[44\] _06200_ count_cycle\[45\] VGND VGND VPWR VPWR _06205_ sky130_fd_sc_hd__a21o_1
XFILLER_0_139_167 VGND VGND VPWR VPWR sky130_fd_sc_hd__fill_1
X_11603_ _04997_ net1335 _05411_ VGND VGND VPWR VPWR _05418_ sky130_fd_sc_hd__mux2_1
X_15371_ _03635_ net1321 _02063_ VGND VGND VPWR VPWR _02073_ sky130_fd_sc_hd__mux2_1
XFILLER_0_93_794 VGND VGND VPWR VPWR sky130_fd_sc_hd__fill_2
X_12583_ count_cycle\[23\] count_cycle\[24\] count_cycle\[25\] _06150_ VGND VGND VPWR
+ VPWR _06156_ sky130_fd_sc_hd__and4_2
XFILLER_0_37_165 VGND VGND VPWR VPWR sky130_fd_sc_hd__decap_3
XFILLER_0_123_502 VGND VGND VPWR VPWR sky130_fd_sc_hd__fill_2
X_14322_ decoded_imm\[17\] _07587_ _07590_ _07593_ VGND VGND VPWR VPWR _01012_ sky130_fd_sc_hd__o22a_1
X_11534_ _05381_ VGND VGND VPWR VPWR _00457_ sky130_fd_sc_hd__clkbuf_1
X_14253_ net485 net120 _07518_ VGND VGND VPWR VPWR _07552_ sky130_fd_sc_hd__mux2_1
X_11465_ _05344_ VGND VGND VPWR VPWR _00425_ sky130_fd_sc_hd__clkbuf_1
X_10416_ _03795_ _04622_ _04628_ VGND VGND VPWR VPWR _04629_ sky130_fd_sc_hd__or3_2
X_13204_ _06459_ _06688_ _06690_ _06563_ VGND VGND VPWR VPWR _06691_ sky130_fd_sc_hd__a211o_1
XFILLER_0_60_190 VGND VGND VPWR VPWR sky130_fd_sc_hd__decap_6
X_14184_ mem_state\[0\] _07510_ _07514_ VGND VGND VPWR VPWR _07515_ sky130_fd_sc_hd__mux2_1
X_11396_ net1158 _05171_ _05302_ VGND VGND VPWR VPWR _05308_ sky130_fd_sc_hd__mux2_1
X_10347_ cpuregs\[22\]\[21\] cpuregs\[23\]\[21\] _03750_ VGND VGND VPWR VPWR _04562_
+ sky130_fd_sc_hd__mux2_1
XFILLER_0_103_281 VGND VGND VPWR VPWR sky130_fd_sc_hd__decap_4
X_13135_ _06461_ _06623_ VGND VGND VPWR VPWR _06624_ sky130_fd_sc_hd__and2_1
XFILLER_0_21_588 VGND VGND VPWR VPWR sky130_fd_sc_hd__decap_8
XTAP_706 VGND VPWR sky130_fd_sc_hd__tapvpwrvgnd_1
X_10278_ cpuregs\[20\]\[19\] cpuregs\[21\]\[19\] _03801_ VGND VGND VPWR VPWR _04495_
+ sky130_fd_sc_hd__mux2_1
XTAP_717 VGND VPWR sky130_fd_sc_hd__tapvpwrvgnd_1
X_13066_ _06447_ _06554_ _06556_ _06453_ VGND VGND VPWR VPWR _06557_ sky130_fd_sc_hd__a211o_1
XTAP_728 VGND VPWR sky130_fd_sc_hd__tapvpwrvgnd_1
XTAP_739 VGND VPWR sky130_fd_sc_hd__tapvpwrvgnd_1
X_12017_ count_instr\[61\] count_instr\[60\] _05677_ VGND VGND VPWR VPWR _05680_ sky130_fd_sc_hd__and3_1
XFILLER_0_136_69 VPWR VGND VPWR VGND sky130_ef_sc_hd__decap_12
X_16825_ clknet_leaf_113_clk _01389_ VGND VGND VPWR VPWR cpuregs\[7\]\[8\] sky130_fd_sc_hd__dfxtp_1
Xmax_cap1 _01755_ VGND VGND VPWR VPWR net1666 sky130_fd_sc_hd__dlymetal6s2s_1
X_16756_ clknet_leaf_121_clk _01320_ VGND VGND VPWR VPWR cpuregs\[5\]\[3\] sky130_fd_sc_hd__dfxtp_1
X_13968_ _07377_ _07391_ VGND VGND VPWR VPWR _07392_ sky130_fd_sc_hd__and2_1
X_15707_ clknet_leaf_126_clk _00357_ VGND VGND VPWR VPWR cpuregs\[21\]\[1\] sky130_fd_sc_hd__dfxtp_1
X_12919_ _06413_ VGND VGND VPWR VPWR _00810_ sky130_fd_sc_hd__clkbuf_1
X_16687_ clknet_leaf_124_clk _01254_ VGND VGND VPWR VPWR cpuregs\[3\]\[1\] sky130_fd_sc_hd__dfxtp_1
X_13899_ _07290_ _07324_ VGND VGND VPWR VPWR _07347_ sky130_fd_sc_hd__nor2_1
X_15638_ clknet_leaf_66_clk _00288_ VGND VGND VPWR VPWR cpuregs\[31\]\[28\] sky130_fd_sc_hd__dfxtp_1
XTAP_2190 VGND VPWR sky130_fd_sc_hd__tapvpwrvgnd_1
XFILLER_0_8_516 VGND VGND VPWR VPWR sky130_fd_sc_hd__fill_2
X_15569_ clknet_leaf_74_clk _00219_ VGND VGND VPWR VPWR cpuregs\[2\]\[23\] sky130_fd_sc_hd__dfxtp_1
XFILLER_0_90_219 VPWR VGND VPWR VGND sky130_ef_sc_hd__decap_12
XFILLER_0_56_474 VGND VGND VPWR VPWR sky130_fd_sc_hd__fill_2
XFILLER_0_16_305 VGND VGND VPWR VPWR sky130_fd_sc_hd__decap_3
X_08110_ _02437_ _02438_ _02502_ VGND VGND VPWR VPWR _02503_ sky130_fd_sc_hd__a21o_1
XFILLER_0_83_271 VGND VGND VPWR VPWR sky130_fd_sc_hd__fill_2
XFILLER_0_16_327 VGND VGND VPWR VPWR sky130_fd_sc_hd__decap_6
X_09090_ cpuregs\[0\]\[3\] cpuregs\[1\]\[3\] cpuregs\[2\]\[3\] cpuregs\[3\]\[3\] _03313_
+ _03314_ VGND VGND VPWR VPWR _03370_ sky130_fd_sc_hd__mux4_1
X_08041_ _02412_ _02423_ _02409_ VGND VGND VPWR VPWR _02438_ sky130_fd_sc_hd__or3b_1
Xhold902 cpuregs\[23\]\[17\] VGND VGND VPWR VPWR net1260 sky130_fd_sc_hd__dlygate4sd3_1
XFILLER_0_4_755 VGND VGND VPWR VPWR sky130_fd_sc_hd__fill_1
Xhold913 cpuregs\[25\]\[8\] VGND VGND VPWR VPWR net1271 sky130_fd_sc_hd__dlygate4sd3_1
XFILLER_0_3_287 VGND VGND VPWR VPWR sky130_fd_sc_hd__fill_1
Xhold935 cpuregs\[15\]\[4\] VGND VGND VPWR VPWR net1293 sky130_fd_sc_hd__dlygate4sd3_1
XFILLER_0_12_533 VGND VGND VPWR VPWR sky130_fd_sc_hd__fill_2
Xhold924 cpuregs\[21\]\[3\] VGND VGND VPWR VPWR net1282 sky130_fd_sc_hd__dlygate4sd3_1
Xhold946 cpuregs\[16\]\[9\] VGND VGND VPWR VPWR net1304 sky130_fd_sc_hd__dlygate4sd3_1
Xhold957 cpuregs\[9\]\[21\] VGND VGND VPWR VPWR net1315 sky130_fd_sc_hd__dlygate4sd3_1
Xhold968 cpuregs\[15\]\[20\] VGND VGND VPWR VPWR net1326 sky130_fd_sc_hd__dlygate4sd3_1
Xhold979 reg_next_pc\[11\] VGND VGND VPWR VPWR net1337 sky130_fd_sc_hd__dlygate4sd3_1
X_09992_ _03868_ _04216_ _03675_ VGND VGND VPWR VPWR _04217_ sky130_fd_sc_hd__a21o_1
X_08943_ reg_out\[14\] reg_next_pc\[14\] _03248_ VGND VGND VPWR VPWR _03253_ sky130_fd_sc_hd__mux2_1
Xclkbuf_4_15_0_clk clknet_0_clk VGND VGND VPWR VPWR clknet_4_15_0_clk sky130_fd_sc_hd__clkbuf_8
XFILLER_0_43_3 VGND VGND VPWR VPWR sky130_fd_sc_hd__fill_2
X_08874_ net209 _03204_ _03212_ VGND VGND VPWR VPWR net103 sky130_fd_sc_hd__a21o_4
X_07825_ instr_rdcycleh VGND VGND VPWR VPWR _02237_ sky130_fd_sc_hd__clkbuf_4
X_07756_ is_sll_srl_sra _02172_ is_sb_sh_sw _02174_ VGND VGND VPWR VPWR _02175_ sky130_fd_sc_hd__or4b_1
X_09426_ _03661_ VGND VGND VPWR VPWR _03662_ sky130_fd_sc_hd__buf_4
X_07687_ _02084_ _02114_ VGND VGND VPWR VPWR _02115_ sky130_fd_sc_hd__or2_4
XFILLER_0_109_318 VGND VGND VPWR VPWR sky130_fd_sc_hd__decap_8
XFILLER_0_47_441 VGND VGND VPWR VPWR sky130_fd_sc_hd__fill_2
X_09357_ reg_pc\[24\] _03593_ _03459_ VGND VGND VPWR VPWR _03601_ sky130_fd_sc_hd__o21a_1
X_08308_ net176 _02688_ VGND VGND VPWR VPWR _02689_ sky130_fd_sc_hd__xnor2_1
X_09288_ reg_pc\[15\] _03534_ VGND VGND VPWR VPWR _03541_ sky130_fd_sc_hd__nand2_1
XFILLER_0_74_282 VGND VGND VPWR VPWR sky130_fd_sc_hd__decap_3
X_08239_ _02286_ _02610_ _02623_ VGND VGND VPWR VPWR _07638_ sky130_fd_sc_hd__o21a_1
XFILLER_0_50_606 VGND VGND VPWR VPWR sky130_fd_sc_hd__fill_1
XFILLER_0_34_168 VGND VGND VPWR VPWR sky130_fd_sc_hd__fill_1
X_11250_ _05230_ VGND VGND VPWR VPWR _00324_ sky130_fd_sc_hd__clkbuf_1
XFILLER_0_15_393 VGND VGND VPWR VPWR sky130_fd_sc_hd__decap_8
X_10201_ _03796_ _04415_ _04419_ _03658_ VGND VGND VPWR VPWR _04420_ sky130_fd_sc_hd__o211a_1
X_11181_ _05183_ VGND VGND VPWR VPWR _00302_ sky130_fd_sc_hd__clkbuf_1
X_10132_ _03837_ _04352_ _03826_ VGND VGND VPWR VPWR _04353_ sky130_fd_sc_hd__a21o_1
XFILLER_0_100_273 VGND VGND VPWR VPWR sky130_fd_sc_hd__decap_4
X_14940_ _03552_ net1386 _01840_ VGND VGND VPWR VPWR _01847_ sky130_fd_sc_hd__mux2_1
X_10063_ _03837_ _04285_ _03826_ VGND VGND VPWR VPWR _04286_ sky130_fd_sc_hd__a21o_1
X_14871_ _01810_ VGND VGND VPWR VPWR _01300_ sky130_fd_sc_hd__clkbuf_1
X_16610_ clknet_leaf_83_clk _01177_ VGND VGND VPWR VPWR cpuregs\[9\]\[20\] sky130_fd_sc_hd__dfxtp_1
X_13822_ _05687_ _02200_ cpu_state\[2\] VGND VGND VPWR VPWR _07289_ sky130_fd_sc_hd__a21oi_1
X_13753_ cpuregs\[28\]\[29\] cpuregs\[29\]\[29\] _07018_ VGND VGND VPWR VPWR _07223_
+ sky130_fd_sc_hd__mux2_1
XFILLER_0_97_352 VGND VGND VPWR VPWR sky130_fd_sc_hd__fill_1
X_16541_ clknet_leaf_9_clk _01118_ VGND VGND VPWR VPWR mem_rdata_q\[25\] sky130_fd_sc_hd__dfxtp_2
XFILLER_0_15_15 VGND VGND VPWR VPWR sky130_fd_sc_hd__fill_2
X_10965_ _05005_ net749 _05063_ VGND VGND VPWR VPWR _05064_ sky130_fd_sc_hd__mux2_1
X_12704_ _06230_ _06241_ count_cycle\[59\] VGND VGND VPWR VPWR _06243_ sky130_fd_sc_hd__a21o_1
X_16472_ clknet_leaf_64_clk _01054_ VGND VGND VPWR VPWR cpuregs\[18\]\[25\] sky130_fd_sc_hd__dfxtp_1
X_13684_ _06969_ _07151_ _07153_ _03309_ _07155_ VGND VGND VPWR VPWR _07156_ sky130_fd_sc_hd__o311a_1
X_10896_ _03557_ VGND VGND VPWR VPWR _05020_ sky130_fd_sc_hd__buf_2
XFILLER_0_109_830 VGND VGND VPWR VPWR sky130_fd_sc_hd__fill_2
XFILLER_0_65_260 VGND VGND VPWR VPWR sky130_fd_sc_hd__decap_4
X_15423_ clknet_leaf_17_clk _00073_ VGND VGND VPWR VPWR net197 sky130_fd_sc_hd__dfxtp_2
X_12635_ count_cycle\[38\] count_cycle\[39\] count_cycle\[40\] _06186_ VGND VGND VPWR
+ VPWR _06193_ sky130_fd_sc_hd__and4_2
XFILLER_0_31_25 VGND VGND VPWR VPWR sky130_fd_sc_hd__fill_2
X_15354_ _02064_ VGND VGND VPWR VPWR _01529_ sky130_fd_sc_hd__clkbuf_1
X_12566_ _06144_ VGND VGND VPWR VPWR _00726_ sky130_fd_sc_hd__clkbuf_1
XFILLER_0_108_362 VGND VGND VPWR VPWR sky130_fd_sc_hd__fill_2
X_11517_ _05371_ VGND VGND VPWR VPWR _00450_ sky130_fd_sc_hd__clkbuf_1
X_14305_ mem_rdata_q\[23\] _07576_ VGND VGND VPWR VPWR _07583_ sky130_fd_sc_hd__and2_1
XFILLER_0_53_455 VGND VGND VPWR VPWR sky130_fd_sc_hd__fill_1
XFILLER_0_26_669 VGND VGND VPWR VPWR sky130_fd_sc_hd__decap_4
X_12497_ _06005_ _05761_ VGND VGND VPWR VPWR _06096_ sky130_fd_sc_hd__xnor2_1
X_15285_ net511 VGND VGND VPWR VPWR _02028_ sky130_fd_sc_hd__clkbuf_1
X_14236_ _07543_ VGND VGND VPWR VPWR _00976_ sky130_fd_sc_hd__clkbuf_1
X_11448_ net655 _05223_ _05301_ VGND VGND VPWR VPWR _05335_ sky130_fd_sc_hd__mux2_1
Xhold209 _07441_ VGND VGND VPWR VPWR net567 sky130_fd_sc_hd__dlygate4sd3_1
X_11379_ _05298_ VGND VGND VPWR VPWR _00385_ sky130_fd_sc_hd__clkbuf_1
X_14167_ _05047_ net967 _07470_ VGND VGND VPWR VPWR _07504_ sky130_fd_sc_hd__mux2_1
XTAP_503 VGND VPWR sky130_fd_sc_hd__tapvpwrvgnd_1
XTAP_514 VGND VPWR sky130_fd_sc_hd__tapvpwrvgnd_1
XTAP_525 VGND VPWR sky130_fd_sc_hd__tapvpwrvgnd_1
X_13118_ _06431_ _06606_ VGND VGND VPWR VPWR _06607_ sky130_fd_sc_hd__and2_1
XTAP_536 VGND VPWR sky130_fd_sc_hd__tapvpwrvgnd_1
XTAP_547 VGND VPWR sky130_fd_sc_hd__tapvpwrvgnd_1
XTAP_558 VGND VPWR sky130_fd_sc_hd__tapvpwrvgnd_1
X_14098_ net652 _07357_ VGND VGND VPWR VPWR _07467_ sky130_fd_sc_hd__and2_1
XFILLER_0_56_33 VGND VGND VPWR VPWR sky130_fd_sc_hd__fill_1
XTAP_569 VGND VPWR sky130_fd_sc_hd__tapvpwrvgnd_1
X_13049_ _06351_ _06539_ _03377_ VGND VGND VPWR VPWR _06540_ sky130_fd_sc_hd__a21o_1
XFILLER_0_56_77 VGND VGND VPWR VPWR sky130_fd_sc_hd__decap_6
X_16808_ clknet_leaf_74_clk _01372_ VGND VGND VPWR VPWR cpuregs\[6\]\[23\] sky130_fd_sc_hd__dfxtp_1
XFILLER_0_89_831 VGND VGND VPWR VPWR sky130_fd_sc_hd__fill_1
X_08590_ _02674_ _02953_ _02960_ _02849_ VGND VGND VPWR VPWR alu_out\[10\] sky130_fd_sc_hd__a22o_1
X_16739_ clknet_leaf_85_clk _01303_ VGND VGND VPWR VPWR cpuregs\[4\]\[18\] sky130_fd_sc_hd__dfxtp_1
XFILLER_0_91_517 VGND VGND VPWR VPWR sky130_fd_sc_hd__fill_1
X_09211_ reg_pc\[5\] _03468_ VGND VGND VPWR VPWR _03474_ sky130_fd_sc_hd__and2_1
XFILLER_0_8_346 VGND VGND VPWR VPWR sky130_fd_sc_hd__fill_1
XFILLER_0_17_614 VGND VGND VPWR VPWR sky130_fd_sc_hd__fill_2
XFILLER_0_127_660 VGND VGND VPWR VPWR sky130_fd_sc_hd__fill_2
XFILLER_0_91_539 VGND VGND VPWR VPWR sky130_fd_sc_hd__fill_1
XFILLER_0_16_124 VGND VGND VPWR VPWR sky130_fd_sc_hd__decap_4
X_09142_ _02179_ _03395_ _03420_ _02508_ VGND VGND VPWR VPWR _00006_ sky130_fd_sc_hd__o22a_1
XFILLER_0_114_321 VGND VGND VPWR VPWR sky130_fd_sc_hd__fill_2
XFILLER_0_71_263 VGND VGND VPWR VPWR sky130_fd_sc_hd__decap_4
XFILLER_0_32_639 VGND VGND VPWR VPWR sky130_fd_sc_hd__fill_1
X_09073_ _03324_ _03353_ _03317_ VGND VGND VPWR VPWR _03354_ sky130_fd_sc_hd__a21o_1
XFILLER_0_114_387 VGND VGND VPWR VPWR sky130_fd_sc_hd__fill_2
XFILLER_0_114_365 VGND VGND VPWR VPWR sky130_fd_sc_hd__decap_6
Xhold721 cpuregs\[25\]\[14\] VGND VGND VPWR VPWR net1079 sky130_fd_sc_hd__dlygate4sd3_1
Xhold710 cpuregs\[6\]\[2\] VGND VGND VPWR VPWR net1068 sky130_fd_sc_hd__dlygate4sd3_1
X_08024_ net498 _02232_ _02421_ VGND VGND VPWR VPWR _02422_ sky130_fd_sc_hd__a21oi_4
XFILLER_0_97_73 VGND VGND VPWR VPWR sky130_fd_sc_hd__fill_1
Xhold754 cpuregs\[6\]\[0\] VGND VGND VPWR VPWR net1112 sky130_fd_sc_hd__dlygate4sd3_1
Xhold732 cpuregs\[9\]\[3\] VGND VGND VPWR VPWR net1090 sky130_fd_sc_hd__dlygate4sd3_1
Xhold743 cpuregs\[28\]\[9\] VGND VGND VPWR VPWR net1101 sky130_fd_sc_hd__dlygate4sd3_1
Xhold787 cpuregs\[13\]\[20\] VGND VGND VPWR VPWR net1145 sky130_fd_sc_hd__dlygate4sd3_1
Xhold776 cpuregs\[11\]\[15\] VGND VGND VPWR VPWR net1134 sky130_fd_sc_hd__dlygate4sd3_1
Xhold765 cpuregs\[9\]\[10\] VGND VGND VPWR VPWR net1123 sky130_fd_sc_hd__dlygate4sd3_1
XFILLER_0_12_396 VGND VGND VPWR VPWR sky130_fd_sc_hd__fill_2
X_09975_ _03799_ VGND VGND VPWR VPWR _04200_ sky130_fd_sc_hd__clkbuf_8
Xhold798 cpuregs\[13\]\[4\] VGND VGND VPWR VPWR net1156 sky130_fd_sc_hd__dlygate4sd3_1
X_08926_ reg_out\[9\] reg_next_pc\[9\] _03225_ VGND VGND VPWR VPWR _03241_ sky130_fd_sc_hd__mux2_1
X_08857_ _02208_ _03202_ _02219_ VGND VGND VPWR VPWR net133 sky130_fd_sc_hd__o21ai_4
X_07808_ cpu_state\[6\] VGND VGND VPWR VPWR _02221_ sky130_fd_sc_hd__clkbuf_4
X_08788_ _02730_ _02986_ _03142_ VGND VGND VPWR VPWR _03143_ sky130_fd_sc_hd__a21o_1
XFILLER_0_79_385 VGND VGND VPWR VPWR sky130_fd_sc_hd__decap_6
XFILLER_0_67_503 VGND VGND VPWR VPWR sky130_fd_sc_hd__fill_1
X_07739_ _02159_ VGND VGND VPWR VPWR _02160_ sky130_fd_sc_hd__buf_4
X_10750_ _04932_ VGND VGND VPWR VPWR _00122_ sky130_fd_sc_hd__clkbuf_1
XFILLER_0_94_322 VGND VGND VPWR VPWR sky130_fd_sc_hd__fill_1
XFILLER_0_94_377 VGND VGND VPWR VPWR sky130_fd_sc_hd__fill_2
X_10681_ _03901_ _04886_ _03731_ VGND VGND VPWR VPWR _04887_ sky130_fd_sc_hd__a21o_1
XFILLER_0_82_528 VGND VGND VPWR VPWR sky130_fd_sc_hd__decap_4
X_09409_ _03645_ VGND VGND VPWR VPWR _03646_ sky130_fd_sc_hd__buf_2
X_12420_ _06004_ _05747_ VGND VGND VPWR VPWR _06026_ sky130_fd_sc_hd__xor2_1
XFILLER_0_75_591 VGND VGND VPWR VPWR sky130_fd_sc_hd__decap_3
XFILLER_0_63_775 VGND VGND VPWR VPWR sky130_fd_sc_hd__fill_1
XFILLER_0_105_332 VGND VGND VPWR VPWR sky130_fd_sc_hd__decap_4
X_12351_ decoded_imm_j\[17\] _05728_ _05954_ VGND VGND VPWR VPWR _05963_ sky130_fd_sc_hd__a21oi_1
XFILLER_0_50_414 VGND VGND VPWR VPWR sky130_fd_sc_hd__decap_6
XFILLER_0_23_617 VGND VGND VPWR VPWR sky130_fd_sc_hd__decap_4
X_11302_ _05257_ VGND VGND VPWR VPWR _00349_ sky130_fd_sc_hd__clkbuf_1
XFILLER_0_133_696 VGND VGND VPWR VPWR sky130_fd_sc_hd__decap_4
X_12282_ decoded_imm_j\[13\] _05718_ VGND VGND VPWR VPWR _05899_ sky130_fd_sc_hd__nand2_1
X_15070_ net1615 _05188_ _01912_ VGND VGND VPWR VPWR _01916_ sky130_fd_sc_hd__mux2_1
X_11233_ _05218_ VGND VGND VPWR VPWR _00319_ sky130_fd_sc_hd__clkbuf_1
X_14021_ mem_rdata_q\[27\] net20 _07422_ VGND VGND VPWR VPWR _07427_ sky130_fd_sc_hd__mux2_1
XFILLER_0_31_650 VGND VGND VPWR VPWR sky130_fd_sc_hd__decap_4
X_11164_ net886 _05171_ _05161_ VGND VGND VPWR VPWR _05172_ sky130_fd_sc_hd__mux2_1
X_10115_ _04116_ _04331_ _04335_ _04063_ VGND VGND VPWR VPWR _04336_ sky130_fd_sc_hd__o211a_1
X_15972_ clknet_leaf_147_clk _00622_ VGND VGND VPWR VPWR count_instr\[41\] sky130_fd_sc_hd__dfxtp_1
X_11095_ _05132_ VGND VGND VPWR VPWR _00267_ sky130_fd_sc_hd__clkbuf_1
X_10046_ _04116_ _04264_ _04268_ _04063_ VGND VGND VPWR VPWR _04269_ sky130_fd_sc_hd__o211a_1
X_14923_ _03498_ net1064 _01829_ VGND VGND VPWR VPWR _01838_ sky130_fd_sc_hd__mux2_1
Xhold92 cpuregs\[0\]\[23\] VGND VGND VPWR VPWR net450 sky130_fd_sc_hd__dlygate4sd3_1
Xhold70 count_instr\[16\] VGND VGND VPWR VPWR net428 sky130_fd_sc_hd__dlygate4sd3_1
Xhold81 is_compare VGND VGND VPWR VPWR net439 sky130_fd_sc_hd__dlygate4sd3_1
X_14854_ _01801_ VGND VGND VPWR VPWR _01292_ sky130_fd_sc_hd__clkbuf_1
X_13805_ _00011_ _07265_ _07272_ VGND VGND VPWR VPWR _07273_ sky130_fd_sc_hd__or3_2
X_11997_ count_instr\[54\] _05664_ _05640_ VGND VGND VPWR VPWR _05667_ sky130_fd_sc_hd__a21oi_1
X_14785_ _01764_ VGND VGND VPWR VPWR _01260_ sky130_fd_sc_hd__clkbuf_1
XFILLER_0_133_37 VGND VGND VPWR VPWR sky130_fd_sc_hd__decap_3
X_13736_ _06431_ _07203_ _07205_ VGND VGND VPWR VPWR _07206_ sky130_fd_sc_hd__a21o_1
X_10948_ _04989_ net1493 _05052_ VGND VGND VPWR VPWR _05055_ sky130_fd_sc_hd__mux2_1
X_16524_ clknet_leaf_14_clk _01101_ VGND VGND VPWR VPWR mem_rdata_q\[8\] sky130_fd_sc_hd__dfxtp_1
XFILLER_0_85_377 VGND VGND VPWR VPWR sky130_fd_sc_hd__decap_6
X_16455_ clknet_leaf_145_clk _01037_ VGND VGND VPWR VPWR cpuregs\[18\]\[8\] sky130_fd_sc_hd__dfxtp_1
X_13667_ _06442_ _07135_ _07139_ _06428_ VGND VGND VPWR VPWR _07140_ sky130_fd_sc_hd__o211a_1
X_15406_ clknet_leaf_81_clk _00061_ VGND VGND VPWR VPWR cpuregs\[11\]\[24\] sky130_fd_sc_hd__dfxtp_1
X_10879_ _05008_ net1426 _05006_ VGND VGND VPWR VPWR _05009_ sky130_fd_sc_hd__mux2_1
XFILLER_0_38_260 VGND VGND VPWR VPWR sky130_fd_sc_hd__decap_4
X_13598_ cpuregs\[20\]\[24\] cpuregs\[21\]\[24\] _06784_ VGND VGND VPWR VPWR _07073_
+ sky130_fd_sc_hd__mux2_1
XFILLER_0_5_305 VGND VGND VPWR VPWR sky130_fd_sc_hd__fill_1
X_16386_ clknet_leaf_1_clk _00968_ VGND VGND VPWR VPWR net139 sky130_fd_sc_hd__dfxtp_1
X_12618_ _06181_ VGND VGND VPWR VPWR _00741_ sky130_fd_sc_hd__clkbuf_1
XFILLER_0_26_455 VGND VGND VPWR VPWR sky130_fd_sc_hd__fill_2
XFILLER_0_81_561 VGND VGND VPWR VPWR sky130_fd_sc_hd__fill_1
X_15337_ _02055_ VGND VGND VPWR VPWR _01521_ sky130_fd_sc_hd__clkbuf_1
X_12549_ count_cycle\[14\] count_cycle\[15\] _06127_ VGND VGND VPWR VPWR _06132_ sky130_fd_sc_hd__and3_1
XANTENNA_1 _00011_ VGND VGND VPWR VPWR sky130_fd_sc_hd__diode_2
XFILLER_0_41_447 VGND VGND VPWR VPWR sky130_fd_sc_hd__fill_1
X_15268_ _02019_ VGND VGND VPWR VPWR _01488_ sky130_fd_sc_hd__clkbuf_1
XFILLER_0_124_696 VGND VGND VPWR VPWR sky130_fd_sc_hd__decap_4
XFILLER_0_111_335 VGND VGND VPWR VPWR sky130_fd_sc_hd__fill_1
XFILLER_0_6_24 VGND VGND VPWR VPWR sky130_fd_sc_hd__fill_1
X_14219_ _07534_ VGND VGND VPWR VPWR _00968_ sky130_fd_sc_hd__clkbuf_1
X_15199_ _01972_ VGND VGND VPWR VPWR _01984_ sky130_fd_sc_hd__buf_4
XTAP_333 VGND VPWR sky130_fd_sc_hd__tapvpwrvgnd_1
XTAP_311 VGND VPWR sky130_fd_sc_hd__tapvpwrvgnd_1
XTAP_300 VGND VPWR sky130_fd_sc_hd__tapvpwrvgnd_1
XTAP_322 VGND VPWR sky130_fd_sc_hd__tapvpwrvgnd_1
XTAP_366 VGND VPWR sky130_fd_sc_hd__tapvpwrvgnd_1
XTAP_355 VGND VPWR sky130_fd_sc_hd__tapvpwrvgnd_1
XTAP_344 VGND VPWR sky130_fd_sc_hd__tapvpwrvgnd_1
X_09760_ _03685_ _03975_ _03983_ _03688_ _03990_ VGND VGND VPWR VPWR _03991_ sky130_fd_sc_hd__a311o_2
X_08711_ _03070_ _03056_ VGND VGND VPWR VPWR _03072_ sky130_fd_sc_hd__nand2_1
XTAP_388 VGND VPWR sky130_fd_sc_hd__tapvpwrvgnd_1
XTAP_399 VGND VPWR sky130_fd_sc_hd__tapvpwrvgnd_1
XTAP_377 VGND VPWR sky130_fd_sc_hd__tapvpwrvgnd_1
X_09691_ _03724_ _03920_ _03922_ VGND VGND VPWR VPWR _03923_ sky130_fd_sc_hd__a21o_1
X_08642_ _02416_ _02688_ _02839_ _02857_ VGND VGND VPWR VPWR _03009_ sky130_fd_sc_hd__a31o_1
XFILLER_0_83_53 VGND VGND VPWR VPWR sky130_fd_sc_hd__decap_3
Xrebuffer24 _05594_ VGND VGND VPWR VPWR net382 sky130_fd_sc_hd__clkbuf_1
Xrebuffer13 net372 VGND VGND VPWR VPWR net371 sky130_fd_sc_hd__clkbuf_1
XFILLER_0_89_683 VGND VGND VPWR VPWR sky130_fd_sc_hd__fill_2
X_08573_ _02671_ _02935_ _02922_ VGND VGND VPWR VPWR _02945_ sky130_fd_sc_hd__o21a_1
XPHY_17 VGND VGND VPWR VPWR sky130_fd_sc_hd__decap_3
XPHY_28 VGND VGND VPWR VPWR sky130_fd_sc_hd__decap_3
XPHY_39 VGND VGND VPWR VPWR sky130_fd_sc_hd__decap_3
XFILLER_0_91_325 VGND VGND VPWR VPWR sky130_fd_sc_hd__fill_2
XFILLER_0_134_427 VGND VGND VPWR VPWR sky130_fd_sc_hd__fill_1
XFILLER_0_29_293 VGND VGND VPWR VPWR sky130_fd_sc_hd__fill_1
X_09125_ _03328_ _03403_ _03332_ VGND VGND VPWR VPWR _03404_ sky130_fd_sc_hd__o21a_1
XFILLER_0_60_734 VGND VGND VPWR VPWR sky130_fd_sc_hd__fill_1
X_09056_ _00008_ VGND VGND VPWR VPWR _03337_ sky130_fd_sc_hd__buf_4
XFILLER_0_44_296 VGND VGND VPWR VPWR sky130_fd_sc_hd__fill_1
X_08007_ _02197_ _02402_ _02406_ VGND VGND VPWR VPWR _02407_ sky130_fd_sc_hd__a21oi_1
Xhold562 cpuregs\[4\]\[27\] VGND VGND VPWR VPWR net920 sky130_fd_sc_hd__dlygate4sd3_1
Xhold551 count_instr\[34\] VGND VGND VPWR VPWR net909 sky130_fd_sc_hd__dlygate4sd3_1
Xhold540 cpuregs\[10\]\[9\] VGND VGND VPWR VPWR net898 sky130_fd_sc_hd__dlygate4sd3_1
Xhold573 cpuregs\[24\]\[21\] VGND VGND VPWR VPWR net931 sky130_fd_sc_hd__dlygate4sd3_1
Xhold584 cpuregs\[16\]\[31\] VGND VGND VPWR VPWR net942 sky130_fd_sc_hd__dlygate4sd3_1
Xhold595 cpuregs\[6\]\[1\] VGND VGND VPWR VPWR net953 sky130_fd_sc_hd__dlygate4sd3_1
X_09958_ _03862_ _04163_ _04183_ VGND VGND VPWR VPWR _04184_ sky130_fd_sc_hd__o21a_1
X_08909_ _02263_ _03229_ _03227_ VGND VGND VPWR VPWR _03230_ sky130_fd_sc_hd__mux2_1
X_09889_ _03661_ VGND VGND VPWR VPWR _04116_ sky130_fd_sc_hd__clkbuf_8
Xhold1240 cpuregs\[27\]\[6\] VGND VGND VPWR VPWR net1598 sky130_fd_sc_hd__dlygate4sd3_1
Xhold1251 cpuregs\[17\]\[2\] VGND VGND VPWR VPWR net1609 sky130_fd_sc_hd__dlygate4sd3_1
Xhold1262 _01010_ VGND VGND VPWR VPWR net1620 sky130_fd_sc_hd__dlygate4sd3_1
Xhold1273 _01005_ VGND VGND VPWR VPWR net1631 sky130_fd_sc_hd__dlygate4sd3_1
Xhold1284 cpuregs\[29\]\[14\] VGND VGND VPWR VPWR net1642 sky130_fd_sc_hd__dlygate4sd3_1
X_11920_ _05609_ _05576_ _05610_ VGND VGND VPWR VPWR _05611_ sky130_fd_sc_hd__and3b_1
Xhold1295 reg_pc\[12\] VGND VGND VPWR VPWR net1653 sky130_fd_sc_hd__dlygate4sd3_1
XFILLER_0_67_300 VGND VGND VPWR VPWR sky130_fd_sc_hd__decap_6
X_11851_ _05539_ _05560_ VGND VGND VPWR VPWR _05561_ sky130_fd_sc_hd__nor2_1
X_11782_ _05512_ VGND VGND VPWR VPWR _00574_ sky130_fd_sc_hd__clkbuf_1
X_10802_ _04961_ VGND VGND VPWR VPWR _00145_ sky130_fd_sc_hd__clkbuf_1
X_14570_ _04989_ net1484 _01648_ VGND VGND VPWR VPWR _01651_ sky130_fd_sc_hd__mux2_1
X_13521_ _03317_ VGND VGND VPWR VPWR _06998_ sky130_fd_sc_hd__buf_4
X_10733_ _04923_ VGND VGND VPWR VPWR _00114_ sky130_fd_sc_hd__clkbuf_1
XFILLER_0_138_766 VPWR VGND VPWR VGND sky130_ef_sc_hd__decap_12
XFILLER_0_12_27 VGND VGND VPWR VPWR sky130_fd_sc_hd__fill_1
XFILLER_0_125_427 VGND VGND VPWR VPWR sky130_fd_sc_hd__decap_4
X_10664_ decoded_imm\[30\] _02646_ VGND VGND VPWR VPWR _04870_ sky130_fd_sc_hd__or2_1
X_13452_ cpuregs\[12\]\[20\] cpuregs\[13\]\[20\] cpuregs\[14\]\[20\] cpuregs\[15\]\[20\]
+ _06696_ _06728_ VGND VGND VPWR VPWR _06931_ sky130_fd_sc_hd__mux4_1
X_16240_ clknet_leaf_22_clk alu_out\[13\] VGND VGND VPWR VPWR alu_out_q\[13\] sky130_fd_sc_hd__dfxtp_1
X_10595_ _03837_ _04802_ _03839_ VGND VGND VPWR VPWR _04803_ sky130_fd_sc_hd__a21o_1
X_12403_ _05792_ _06007_ _06008_ _06010_ VGND VGND VPWR VPWR _06011_ sky130_fd_sc_hd__a22o_1
X_13383_ _06864_ net211 _06629_ VGND VGND VPWR VPWR _06865_ sky130_fd_sc_hd__mux2_1
X_16171_ clknet_leaf_108_clk _00789_ VGND VGND VPWR VPWR net44 sky130_fd_sc_hd__dfxtp_1
XFILLER_0_3_809 VPWR VGND VPWR VGND sky130_ef_sc_hd__decap_12
X_12334_ _05908_ _05946_ VGND VGND VPWR VPWR _05947_ sky130_fd_sc_hd__or2_1
X_15122_ _01943_ VGND VGND VPWR VPWR _01418_ sky130_fd_sc_hd__clkbuf_1
X_15053_ net1228 _05171_ _01901_ VGND VGND VPWR VPWR _01907_ sky130_fd_sc_hd__mux2_1
X_12265_ _05714_ _05868_ VGND VGND VPWR VPWR _05884_ sky130_fd_sc_hd__nor2_1
X_14004_ mem_rdata_q\[26\] _07414_ _07416_ mem_rdata_q\[27\] VGND VGND VPWR VPWR _07418_
+ sky130_fd_sc_hd__and4b_1
Xoutput60 net60 VGND VGND VPWR VPWR mem_addr[5] sky130_fd_sc_hd__clkbuf_4
X_11216_ _03590_ VGND VGND VPWR VPWR _05207_ sky130_fd_sc_hd__clkbuf_4
X_12196_ decoded_imm_j\[6\] _05704_ VGND VGND VPWR VPWR _05820_ sky130_fd_sc_hd__or2_1
XFILLER_0_31_491 VGND VGND VPWR VPWR sky130_fd_sc_hd__fill_2
Xoutput71 net71 VGND VGND VPWR VPWR mem_la_addr[15] sky130_fd_sc_hd__clkbuf_4
Xoutput82 net82 VGND VGND VPWR VPWR mem_la_addr[26] sky130_fd_sc_hd__clkbuf_4
XFILLER_0_128_37 VGND VGND VPWR VPWR sky130_fd_sc_hd__decap_3
X_11147_ _04903_ _04944_ VGND VGND VPWR VPWR _05160_ sky130_fd_sc_hd__nor2_4
Xoutput93 net93 VGND VGND VPWR VPWR mem_la_addr[7] sky130_fd_sc_hd__clkbuf_4
XFILLER_0_37_35 VPWR VGND VPWR VGND sky130_ef_sc_hd__decap_12
XFILLER_0_37_57 VGND VGND VPWR VPWR sky130_fd_sc_hd__fill_2
X_11078_ _03444_ _04942_ VGND VGND VPWR VPWR _05123_ sky130_fd_sc_hd__nor2_2
X_15955_ clknet_leaf_154_clk _00605_ VGND VGND VPWR VPWR count_instr\[24\] sky130_fd_sc_hd__dfxtp_1
X_15886_ clknet_leaf_62_clk _00536_ VGND VGND VPWR VPWR cpuregs\[20\]\[20\] sky130_fd_sc_hd__dfxtp_1
X_10029_ _03690_ _04252_ _03959_ VGND VGND VPWR VPWR _04253_ sky130_fd_sc_hd__o21a_1
X_14906_ _01828_ VGND VGND VPWR VPWR _01829_ sky130_fd_sc_hd__clkbuf_8
X_14837_ _04905_ _01791_ VGND VGND VPWR VPWR _01792_ sky130_fd_sc_hd__or2_4
XFILLER_0_86_642 VGND VGND VPWR VPWR sky130_fd_sc_hd__fill_2
XFILLER_0_53_67 VGND VGND VPWR VPWR sky130_fd_sc_hd__fill_1
X_16507_ clknet_leaf_64_clk _01089_ VGND VGND VPWR VPWR cpuregs\[19\]\[28\] sky130_fd_sc_hd__dfxtp_1
XFILLER_0_128_221 VPWR VGND VPWR VGND sky130_ef_sc_hd__decap_12
XFILLER_0_86_664 VGND VGND VPWR VPWR sky130_fd_sc_hd__decap_4
XFILLER_0_86_653 VGND VGND VPWR VPWR sky130_fd_sc_hd__decap_3
XFILLER_0_58_377 VGND VGND VPWR VPWR sky130_fd_sc_hd__decap_3
XFILLER_0_58_344 VGND VGND VPWR VPWR sky130_fd_sc_hd__decap_3
XFILLER_0_46_517 VGND VGND VPWR VPWR sky130_fd_sc_hd__fill_2
X_14768_ _04902_ _04900_ _04901_ _03444_ VGND VGND VPWR VPWR _01755_ sky130_fd_sc_hd__nor4_1
X_13719_ cpuregs\[22\]\[28\] cpuregs\[23\]\[28\] _06386_ VGND VGND VPWR VPWR _07190_
+ sky130_fd_sc_hd__mux2_1
X_14699_ _01718_ VGND VGND VPWR VPWR _01220_ sky130_fd_sc_hd__clkbuf_1
X_16438_ clknet_leaf_26_clk _01020_ VGND VGND VPWR VPWR decoded_imm\[9\] sky130_fd_sc_hd__dfxtp_4
XFILLER_0_39_591 VGND VGND VPWR VPWR sky130_fd_sc_hd__decap_4
X_16369_ clknet_leaf_14_clk _00951_ VGND VGND VPWR VPWR is_compare sky130_fd_sc_hd__dfxtp_1
XFILLER_0_112_622 VGND VGND VPWR VPWR sky130_fd_sc_hd__fill_2
XFILLER_0_112_677 VGND VGND VPWR VPWR sky130_fd_sc_hd__fill_1
XFILLER_0_41_288 VGND VGND VPWR VPWR sky130_fd_sc_hd__fill_1
XFILLER_0_111_198 VGND VGND VPWR VPWR sky130_fd_sc_hd__fill_1
X_09812_ _03984_ _04038_ _04040_ VGND VGND VPWR VPWR _04041_ sky130_fd_sc_hd__a21o_1
XFILLER_0_94_85 VGND VGND VPWR VPWR sky130_fd_sc_hd__fill_2
X_09743_ cpuregs\[24\]\[5\] cpuregs\[25\]\[5\] cpuregs\[26\]\[5\] cpuregs\[27\]\[5\]
+ _03666_ _03669_ VGND VGND VPWR VPWR _03974_ sky130_fd_sc_hd__mux4_1
X_09674_ _03688_ _03893_ _03906_ VGND VGND VPWR VPWR _03907_ sky130_fd_sc_hd__or3_2
XTAP_2019 VGND VPWR sky130_fd_sc_hd__tapvpwrvgnd_1
XTAP_2008 VGND VPWR sky130_fd_sc_hd__tapvpwrvgnd_1
X_08625_ _02803_ _02992_ VGND VGND VPWR VPWR _02993_ sky130_fd_sc_hd__nor2_1
X_08556_ _02340_ _02671_ _02839_ _02841_ VGND VGND VPWR VPWR _02929_ sky130_fd_sc_hd__a31o_1
XTAP_1329 VGND VPWR sky130_fd_sc_hd__tapvpwrvgnd_1
XTAP_1318 VGND VPWR sky130_fd_sc_hd__tapvpwrvgnd_1
XTAP_1307 VGND VPWR sky130_fd_sc_hd__tapvpwrvgnd_1
X_08487_ _02864_ _02865_ VGND VGND VPWR VPWR _02866_ sky130_fd_sc_hd__nand2_1
XFILLER_0_18_753 VGND VGND VPWR VPWR sky130_fd_sc_hd__decap_3
XFILLER_0_134_246 VGND VGND VPWR VPWR sky130_fd_sc_hd__fill_1
XFILLER_0_17_252 VGND VGND VPWR VPWR sky130_fd_sc_hd__decap_3
XFILLER_0_122_419 VGND VGND VPWR VPWR sky130_fd_sc_hd__fill_1
XFILLER_0_45_594 VGND VGND VPWR VPWR sky130_fd_sc_hd__fill_2
X_09108_ _03345_ _03385_ _03387_ VGND VGND VPWR VPWR _03388_ sky130_fd_sc_hd__a21o_1
XFILLER_0_33_756 VGND VGND VPWR VPWR sky130_fd_sc_hd__fill_1
XFILLER_0_115_471 VGND VGND VPWR VPWR sky130_fd_sc_hd__fill_1
X_10380_ _03739_ _04589_ _04593_ _03873_ VGND VGND VPWR VPWR _04594_ sky130_fd_sc_hd__o211a_1
X_09039_ _03318_ _03319_ VGND VGND VPWR VPWR _03320_ sky130_fd_sc_hd__or2_1
Xhold381 cpuregs\[19\]\[27\] VGND VGND VPWR VPWR net739 sky130_fd_sc_hd__dlygate4sd3_1
XFILLER_0_130_496 VPWR VGND VPWR VGND sky130_ef_sc_hd__decap_12
XFILLER_0_102_165 VGND VGND VPWR VPWR sky130_fd_sc_hd__fill_1
X_12050_ _05690_ reg_pc\[6\] VGND VGND VPWR VPWR _05705_ sky130_fd_sc_hd__or2_1
Xhold370 cpuregs\[30\]\[12\] VGND VGND VPWR VPWR net728 sky130_fd_sc_hd__dlygate4sd3_1
X_11001_ _05082_ VGND VGND VPWR VPWR _00223_ sky130_fd_sc_hd__clkbuf_1
Xhold392 cpuregs\[12\]\[6\] VGND VGND VPWR VPWR net750 sky130_fd_sc_hd__dlygate4sd3_1
X_12952_ _06442_ _06445_ VGND VGND VPWR VPWR _06446_ sky130_fd_sc_hd__or2_1
X_15740_ clknet_leaf_131_clk _00390_ VGND VGND VPWR VPWR cpuregs\[15\]\[2\] sky130_fd_sc_hd__dfxtp_1
X_15671_ clknet_leaf_70_clk _00321_ VGND VGND VPWR VPWR cpuregs\[14\]\[29\] sky130_fd_sc_hd__dfxtp_1
Xhold1070 cpuregs\[10\]\[13\] VGND VGND VPWR VPWR net1428 sky130_fd_sc_hd__dlygate4sd3_1
X_11903_ net465 net382 _05598_ VGND VGND VPWR VPWR _00609_ sky130_fd_sc_hd__o21a_1
Xhold1081 cpuregs\[7\]\[1\] VGND VGND VPWR VPWR net1439 sky130_fd_sc_hd__dlygate4sd3_1
Xhold1092 cpuregs\[24\]\[1\] VGND VGND VPWR VPWR net1450 sky130_fd_sc_hd__dlygate4sd3_1
X_14622_ _05041_ net1637 _01670_ VGND VGND VPWR VPWR _01678_ sky130_fd_sc_hd__mux2_1
XFILLER_0_87_439 VGND VGND VPWR VPWR sky130_fd_sc_hd__decap_6
X_12883_ _03321_ _06380_ VGND VGND VPWR VPWR _06381_ sky130_fd_sc_hd__or2_1
XTAP_1852 VGND VPWR sky130_fd_sc_hd__tapvpwrvgnd_1
XTAP_1830 VGND VPWR sky130_fd_sc_hd__tapvpwrvgnd_1
XTAP_1841 VGND VPWR sky130_fd_sc_hd__tapvpwrvgnd_1
X_11834_ _05547_ _05530_ _05548_ VGND VGND VPWR VPWR _05549_ sky130_fd_sc_hd__and3b_1
XFILLER_0_23_15 VGND VGND VPWR VPWR sky130_fd_sc_hd__decap_8
XFILLER_0_135_9 VGND VGND VPWR VPWR sky130_fd_sc_hd__decap_4
X_14553_ _01641_ VGND VGND VPWR VPWR _01151_ sky130_fd_sc_hd__clkbuf_1
XTAP_1885 VGND VPWR sky130_fd_sc_hd__tapvpwrvgnd_1
XTAP_1874 VGND VPWR sky130_fd_sc_hd__tapvpwrvgnd_1
XTAP_1863 VGND VPWR sky130_fd_sc_hd__tapvpwrvgnd_1
X_11765_ _05503_ VGND VGND VPWR VPWR _00566_ sky130_fd_sc_hd__clkbuf_1
XFILLER_0_55_325 VGND VGND VPWR VPWR sky130_fd_sc_hd__decap_3
XFILLER_0_126_725 VGND VGND VPWR VPWR sky130_fd_sc_hd__decap_8
X_14484_ net769 _05215_ _01598_ VGND VGND VPWR VPWR _01605_ sky130_fd_sc_hd__mux2_1
X_13504_ cpuregs\[20\]\[21\] cpuregs\[21\]\[21\] _06784_ VGND VGND VPWR VPWR _06982_
+ sky130_fd_sc_hd__mux2_1
XTAP_1896 VGND VPWR sky130_fd_sc_hd__tapvpwrvgnd_1
X_11696_ net1087 _05198_ _05458_ VGND VGND VPWR VPWR _05467_ sky130_fd_sc_hd__mux2_1
XFILLER_0_67_196 VGND VGND VPWR VPWR sky130_fd_sc_hd__fill_2
X_10716_ _04914_ VGND VGND VPWR VPWR _00106_ sky130_fd_sc_hd__clkbuf_1
XFILLER_0_130_27 VGND VGND VPWR VPWR sky130_fd_sc_hd__fill_1
X_10647_ cpuregs\[20\]\[29\] cpuregs\[21\]\[29\] _03767_ VGND VGND VPWR VPWR _04854_
+ sky130_fd_sc_hd__mux2_1
X_13435_ _06631_ _06905_ _06914_ VGND VGND VPWR VPWR _06915_ sky130_fd_sc_hd__or3_2
X_16223_ clknet_leaf_7_clk _00840_ VGND VGND VPWR VPWR latched_branch sky130_fd_sc_hd__dfxtp_4
XFILLER_0_24_701 VGND VGND VPWR VPWR sky130_fd_sc_hd__fill_1
XFILLER_0_140_205 VGND VGND VPWR VPWR sky130_fd_sc_hd__decap_8
Xrebuffer4 net363 VGND VGND VPWR VPWR net362 sky130_fd_sc_hd__clkbuf_1
XFILLER_0_24_734 VGND VGND VPWR VPWR sky130_fd_sc_hd__fill_2
X_10578_ _04786_ VGND VGND VPWR VPWR _00096_ sky130_fd_sc_hd__clkbuf_1
X_13366_ _06631_ _06839_ _06847_ VGND VGND VPWR VPWR _06848_ sky130_fd_sc_hd__or3_2
X_16154_ clknet_leaf_145_clk _00772_ VGND VGND VPWR VPWR net55 sky130_fd_sc_hd__dfxtp_1
X_12317_ _02154_ _05931_ VGND VGND VPWR VPWR _05932_ sky130_fd_sc_hd__nor2_1
X_15105_ net1041 _05223_ _01900_ VGND VGND VPWR VPWR _01934_ sky130_fd_sc_hd__mux2_1
X_13297_ cpuregs\[16\]\[15\] cpuregs\[17\]\[15\] cpuregs\[18\]\[15\] cpuregs\[19\]\[15\]
+ _06614_ _06648_ VGND VGND VPWR VPWR _06781_ sky130_fd_sc_hd__mux4_1
X_16085_ clknet_leaf_3_clk _00735_ VGND VGND VPWR VPWR count_cycle\[28\] sky130_fd_sc_hd__dfxtp_1
X_15036_ _01897_ VGND VGND VPWR VPWR _01378_ sky130_fd_sc_hd__clkbuf_1
X_12248_ _05867_ _05712_ _05710_ VGND VGND VPWR VPWR _05868_ sky130_fd_sc_hd__and3b_1
XFILLER_0_139_69 VGND VGND VPWR VPWR sky130_fd_sc_hd__fill_2
X_12179_ _05773_ _05799_ _05702_ VGND VGND VPWR VPWR _05804_ sky130_fd_sc_hd__o21ba_1
X_15938_ clknet_leaf_145_clk _00588_ VGND VGND VPWR VPWR count_instr\[7\] sky130_fd_sc_hd__dfxtp_1
X_08410_ net198 _02789_ _02790_ _02280_ VGND VGND VPWR VPWR _02791_ sky130_fd_sc_hd__o22a_1
X_15869_ clknet_leaf_127_clk _00519_ VGND VGND VPWR VPWR cpuregs\[20\]\[3\] sky130_fd_sc_hd__dfxtp_1
X_09390_ net1225 _03629_ _03578_ VGND VGND VPWR VPWR _03630_ sky130_fd_sc_hd__mux2_1
XFILLER_0_86_450 VGND VGND VPWR VPWR sky130_fd_sc_hd__fill_2
XFILLER_0_129_552 VGND VGND VPWR VPWR sky130_fd_sc_hd__fill_1
X_08341_ _02710_ _02721_ VGND VGND VPWR VPWR _02722_ sky130_fd_sc_hd__nor2_1
XFILLER_0_73_111 VGND VGND VPWR VPWR sky130_fd_sc_hd__fill_1
XFILLER_0_46_325 VGND VGND VPWR VPWR sky130_fd_sc_hd__fill_2
XFILLER_0_19_517 VGND VGND VPWR VPWR sky130_fd_sc_hd__fill_1
XFILLER_0_74_645 VGND VGND VPWR VPWR sky130_fd_sc_hd__fill_1
X_08272_ count_instr\[63\] _02203_ VGND VGND VPWR VPWR _02654_ sky130_fd_sc_hd__and2_1
XFILLER_0_6_444 VGND VGND VPWR VPWR sky130_fd_sc_hd__fill_1
XFILLER_0_104_419 VGND VGND VPWR VPWR sky130_fd_sc_hd__fill_1
XFILLER_0_131_216 VGND VGND VPWR VPWR sky130_fd_sc_hd__decap_8
XFILLER_0_89_63 VGND VGND VPWR VPWR sky130_fd_sc_hd__fill_1
XFILLER_0_120_93 VGND VGND VPWR VPWR sky130_fd_sc_hd__fill_1
XFILLER_0_112_441 VGND VGND VPWR VPWR sky130_fd_sc_hd__fill_1
XFILLER_0_2_683 VGND VGND VPWR VPWR sky130_fd_sc_hd__fill_1
X_07987_ _02384_ _02387_ VGND VGND VPWR VPWR _02388_ sky130_fd_sc_hd__xor2_1
X_09726_ _03953_ _03956_ VGND VGND VPWR VPWR _03957_ sky130_fd_sc_hd__nand2_1
XTAP_1104 VGND VPWR sky130_fd_sc_hd__tapvpwrvgnd_1
X_09657_ cpuregs\[20\]\[3\] cpuregs\[21\]\[3\] _03881_ VGND VGND VPWR VPWR _03890_
+ sky130_fd_sc_hd__mux2_1
X_08608_ _02975_ _02976_ VGND VGND VPWR VPWR _02977_ sky130_fd_sc_hd__and2_1
XTAP_1137 VGND VPWR sky130_fd_sc_hd__tapvpwrvgnd_1
XTAP_1126 VGND VPWR sky130_fd_sc_hd__tapvpwrvgnd_1
XTAP_1115 VGND VPWR sky130_fd_sc_hd__tapvpwrvgnd_1
X_09588_ cpuregs\[22\]\[2\] cpuregs\[23\]\[2\] _03750_ VGND VGND VPWR VPWR _03822_
+ sky130_fd_sc_hd__mux2_1
X_08539_ _02906_ _02912_ VGND VGND VPWR VPWR _02914_ sky130_fd_sc_hd__nand2_1
XTAP_1159 VGND VPWR sky130_fd_sc_hd__tapvpwrvgnd_1
XTAP_1148 VGND VPWR sky130_fd_sc_hd__tapvpwrvgnd_1
XFILLER_0_49_163 VGND VGND VPWR VPWR sky130_fd_sc_hd__decap_4
X_11550_ _05012_ net726 _05386_ VGND VGND VPWR VPWR _05390_ sky130_fd_sc_hd__mux2_1
X_10501_ cpuregs\[28\]\[25\] cpuregs\[29\]\[25\] _03797_ VGND VGND VPWR VPWR _04712_
+ sky130_fd_sc_hd__mux2_1
XFILLER_0_80_604 VGND VGND VPWR VPWR sky130_fd_sc_hd__fill_1
XFILLER_0_64_177 VGND VGND VPWR VPWR sky130_fd_sc_hd__fill_1
X_11481_ net673 _05188_ _05349_ VGND VGND VPWR VPWR _05353_ sky130_fd_sc_hd__mux2_1
X_13220_ cpuregs\[6\]\[13\] cpuregs\[7\]\[13\] _06511_ VGND VGND VPWR VPWR _06706_
+ sky130_fd_sc_hd__mux2_1
XFILLER_0_52_328 VGND VGND VPWR VPWR sky130_fd_sc_hd__fill_1
XFILLER_0_18_583 VGND VGND VPWR VPWR sky130_fd_sc_hd__fill_2
X_10432_ _02083_ _04614_ _04615_ _04644_ VGND VGND VPWR VPWR _04645_ sky130_fd_sc_hd__a31o_1
XFILLER_0_60_350 VGND VGND VPWR VPWR sky130_fd_sc_hd__fill_2
X_10363_ _04577_ VGND VGND VPWR VPWR _00090_ sky130_fd_sc_hd__clkbuf_1
X_13151_ _03345_ VGND VGND VPWR VPWR _06639_ sky130_fd_sc_hd__clkbuf_4
X_12102_ _05695_ VGND VGND VPWR VPWR _05741_ sky130_fd_sc_hd__clkbuf_4
X_13082_ _06351_ _06571_ _03377_ VGND VGND VPWR VPWR _06572_ sky130_fd_sc_hd__a21o_1
X_16910_ clknet_leaf_81_clk _01474_ VGND VGND VPWR VPWR cpuregs\[8\]\[29\] sky130_fd_sc_hd__dfxtp_1
X_10294_ _04510_ VGND VGND VPWR VPWR _00088_ sky130_fd_sc_hd__clkbuf_1
X_12033_ _03454_ reg_next_pc\[2\] _03221_ VGND VGND VPWR VPWR _05692_ sky130_fd_sc_hd__mux2_1
XFILLER_0_18_26 VGND VGND VPWR VPWR sky130_fd_sc_hd__fill_2
X_16841_ clknet_leaf_60_clk _01405_ VGND VGND VPWR VPWR cpuregs\[7\]\[24\] sky130_fd_sc_hd__dfxtp_1
X_16772_ clknet_leaf_88_clk _01336_ VGND VGND VPWR VPWR cpuregs\[5\]\[19\] sky130_fd_sc_hd__dfxtp_1
X_15723_ clknet_leaf_96_clk _00373_ VGND VGND VPWR VPWR cpuregs\[21\]\[17\] sky130_fd_sc_hd__dfxtp_1
X_13984_ _07402_ VGND VGND VPWR VPWR _00877_ sky130_fd_sc_hd__clkbuf_1
XFILLER_0_125_27 VPWR VGND VPWR VGND sky130_ef_sc_hd__decap_12
X_12935_ _06417_ _06420_ _06427_ _06428_ VGND VGND VPWR VPWR _06429_ sky130_fd_sc_hd__o211a_1
XTAP_2350 VGND VPWR sky130_fd_sc_hd__tapvpwrvgnd_1
XFILLER_0_140_7 VGND VGND VPWR VPWR sky130_fd_sc_hd__fill_1
XFILLER_0_75_409 VGND VGND VPWR VPWR sky130_fd_sc_hd__fill_2
XFILLER_0_68_450 VGND VGND VPWR VPWR sky130_fd_sc_hd__decap_4
X_15654_ clknet_leaf_104_clk _00304_ VGND VGND VPWR VPWR cpuregs\[14\]\[12\] sky130_fd_sc_hd__dfxtp_1
X_12866_ cpuregs\[12\]\[0\] cpuregs\[13\]\[0\] cpuregs\[14\]\[0\] cpuregs\[15\]\[0\]
+ _06364_ _03400_ VGND VGND VPWR VPWR _06365_ sky130_fd_sc_hd__mux4_1
XTAP_1660 VGND VPWR sky130_fd_sc_hd__tapvpwrvgnd_1
X_14605_ _05024_ net1475 _01659_ VGND VGND VPWR VPWR _01669_ sky130_fd_sc_hd__mux2_1
X_11817_ count_instr\[3\] count_instr\[2\] _05525_ _05535_ VGND VGND VPWR VPWR _05536_
+ sky130_fd_sc_hd__and4_1
X_15585_ clknet_leaf_131_clk _00235_ VGND VGND VPWR VPWR cpuregs\[28\]\[7\] sky130_fd_sc_hd__dfxtp_1
X_12797_ _06293_ VGND VGND VPWR VPWR _06313_ sky130_fd_sc_hd__clkbuf_16
XFILLER_0_133_6 VPWR VGND VPWR VGND sky130_ef_sc_hd__decap_12
XTAP_1693 VGND VPWR sky130_fd_sc_hd__tapvpwrvgnd_1
XTAP_1682 VGND VPWR sky130_fd_sc_hd__tapvpwrvgnd_1
XTAP_1671 VGND VPWR sky130_fd_sc_hd__tapvpwrvgnd_1
X_14536_ _01632_ VGND VGND VPWR VPWR _01143_ sky130_fd_sc_hd__clkbuf_1
XFILLER_0_28_347 VGND VGND VPWR VPWR sky130_fd_sc_hd__decap_4
XFILLER_0_70_103 VGND VGND VPWR VPWR sky130_fd_sc_hd__decap_3
X_11748_ _05005_ net1258 _05494_ VGND VGND VPWR VPWR _05495_ sky130_fd_sc_hd__mux2_1
XFILLER_0_55_177 VGND VGND VPWR VPWR sky130_fd_sc_hd__fill_2
XFILLER_0_126_566 VGND VGND VPWR VPWR sky130_fd_sc_hd__fill_1
X_11679_ _05446_ VGND VGND VPWR VPWR _05458_ sky130_fd_sc_hd__buf_4
X_14467_ net770 _05198_ _01587_ VGND VGND VPWR VPWR _01596_ sky130_fd_sc_hd__mux2_1
XFILLER_0_24_531 VGND VGND VPWR VPWR sky130_fd_sc_hd__fill_1
X_13418_ _06898_ net212 _06629_ VGND VGND VPWR VPWR _06899_ sky130_fd_sc_hd__mux2_1
X_16206_ clknet_leaf_54_clk _00823_ VGND VGND VPWR VPWR net211 sky130_fd_sc_hd__dfxtp_4
X_14398_ _01559_ VGND VGND VPWR VPWR _01046_ sky130_fd_sc_hd__clkbuf_1
XFILLER_0_3_436 VGND VGND VPWR VPWR sky130_fd_sc_hd__fill_2
Xpicorv32_314 VGND VGND VPWR VPWR picorv32_314/HI pcpi_insn[25] sky130_fd_sc_hd__conb_1
X_16137_ clknet_leaf_23_clk _07624_ VGND VGND VPWR VPWR reg_out\[15\] sky130_fd_sc_hd__dfxtp_1
X_13349_ _06762_ _06818_ _06831_ _06802_ decoded_imm\[16\] VGND VGND VPWR VPWR _06832_
+ sky130_fd_sc_hd__a32o_1
Xpicorv32_325 VGND VGND VPWR VPWR picorv32_325/HI trace_data[3] sky130_fd_sc_hd__conb_1
XFILLER_0_3_447 VGND VGND VPWR VPWR sky130_fd_sc_hd__fill_1
Xpicorv32_336 VGND VGND VPWR VPWR picorv32_336/HI trace_data[14] sky130_fd_sc_hd__conb_1
Xpicorv32_303 VGND VGND VPWR VPWR picorv32_303/HI pcpi_insn[14] sky130_fd_sc_hd__conb_1
Xpicorv32_358 VGND VGND VPWR VPWR picorv32_358/HI trace_valid sky130_fd_sc_hd__conb_1
XFILLER_0_59_55 VGND VGND VPWR VPWR sky130_fd_sc_hd__fill_1
Xpicorv32_347 VGND VGND VPWR VPWR picorv32_347/HI trace_data[25] sky130_fd_sc_hd__conb_1
XFILLER_0_11_236 VGND VGND VPWR VPWR sky130_fd_sc_hd__fill_2
XFILLER_0_11_258 VGND VGND VPWR VPWR sky130_fd_sc_hd__fill_1
X_16068_ clknet_leaf_147_clk _00718_ VGND VGND VPWR VPWR count_cycle\[11\] sky130_fd_sc_hd__dfxtp_1
X_15019_ _03584_ net919 _01887_ VGND VGND VPWR VPWR _01889_ sky130_fd_sc_hd__mux2_1
X_08890_ _03220_ VGND VGND VPWR VPWR net112 sky130_fd_sc_hd__buf_4
X_07910_ count_instr\[7\] _02236_ count_cycle\[39\] _02204_ VGND VGND VPWR VPWR _02316_
+ sky130_fd_sc_hd__a22o_1
XFILLER_0_75_43 VGND VGND VPWR VPWR sky130_fd_sc_hd__decap_4
X_07841_ _02194_ _02249_ _02251_ _02199_ VGND VGND VPWR VPWR _02252_ sky130_fd_sc_hd__a22o_1
X_07772_ _02187_ _02106_ _02188_ _02104_ VGND VGND VPWR VPWR _00026_ sky130_fd_sc_hd__a22o_1
X_09511_ _03736_ _03740_ _03742_ _03745_ _03660_ VGND VGND VPWR VPWR _03746_ sky130_fd_sc_hd__o221a_1
XFILLER_0_78_269 VGND VGND VPWR VPWR sky130_fd_sc_hd__fill_1
X_09442_ cpuregs\[20\]\[0\] cpuregs\[21\]\[0\] cpuregs\[22\]\[0\] cpuregs\[23\]\[0\]
+ _03667_ _03670_ VGND VGND VPWR VPWR _03678_ sky130_fd_sc_hd__mux4_1
X_09373_ _03612_ _03613_ _03449_ _03614_ VGND VGND VPWR VPWR _03615_ sky130_fd_sc_hd__a2bb2o_2
XPHY_209 VGND VGND VPWR VPWR sky130_fd_sc_hd__decap_3
X_08324_ net185 net217 VGND VGND VPWR VPWR _02705_ sky130_fd_sc_hd__nand2_1
XFILLER_0_86_291 VGND VGND VPWR VPWR sky130_fd_sc_hd__decap_3
XFILLER_0_129_393 VGND VGND VPWR VPWR sky130_fd_sc_hd__fill_1
XFILLER_0_6_241 VGND VGND VPWR VPWR sky130_fd_sc_hd__decap_8
X_08255_ count_cycle\[30\] _02202_ _02636_ _02637_ VGND VGND VPWR VPWR _02638_ sky130_fd_sc_hd__a211o_2
X_08186_ reg_pc\[25\] decoded_imm\[25\] VGND VGND VPWR VPWR _02574_ sky130_fd_sc_hd__and2_1
XFILLER_0_61_169 VGND VGND VPWR VPWR sky130_fd_sc_hd__fill_2
XFILLER_0_7_797 VPWR VGND VPWR VGND sky130_ef_sc_hd__decap_12
XFILLER_0_132_558 VGND VGND VPWR VPWR sky130_fd_sc_hd__fill_1
XFILLER_0_113_783 VGND VGND VPWR VPWR sky130_fd_sc_hd__fill_1
XFILLER_0_11_770 VPWR VGND VPWR VGND sky130_ef_sc_hd__decap_12
X_09709_ _03864_ VGND VGND VPWR VPWR _03941_ sky130_fd_sc_hd__buf_6
X_10981_ _05022_ net1094 _05063_ VGND VGND VPWR VPWR _05072_ sky130_fd_sc_hd__mux2_1
XFILLER_0_69_225 VPWR VGND VPWR VGND sky130_ef_sc_hd__decap_12
XFILLER_0_139_113 VPWR VGND VPWR VGND sky130_ef_sc_hd__decap_12
XFILLER_0_139_102 VGND VGND VPWR VPWR sky130_fd_sc_hd__decap_8
X_12720_ _04869_ _04873_ _06253_ VGND VGND VPWR VPWR _06254_ sky130_fd_sc_hd__a21oi_1
X_12651_ count_cycle\[44\] count_cycle\[45\] _06200_ VGND VGND VPWR VPWR _06204_ sky130_fd_sc_hd__and3_1
XFILLER_0_127_319 VGND VGND VPWR VPWR sky130_fd_sc_hd__fill_1
X_11602_ _05417_ VGND VGND VPWR VPWR _00489_ sky130_fd_sc_hd__clkbuf_1
XFILLER_0_37_111 VGND VGND VPWR VPWR sky130_fd_sc_hd__fill_1
X_15370_ _02072_ VGND VGND VPWR VPWR _01537_ sky130_fd_sc_hd__clkbuf_1
XFILLER_0_53_615 VGND VGND VPWR VPWR sky130_fd_sc_hd__fill_1
X_12582_ net559 _06152_ _06155_ VGND VGND VPWR VPWR _00731_ sky130_fd_sc_hd__o21ba_1
XFILLER_0_135_330 VGND VGND VPWR VPWR sky130_fd_sc_hd__decap_6
X_14321_ _07320_ decoded_imm_j\[17\] _07570_ net562 _07357_ VGND VGND VPWR VPWR _07593_
+ sky130_fd_sc_hd__a221o_1
X_11533_ _04995_ net1294 _05375_ VGND VGND VPWR VPWR _05381_ sky130_fd_sc_hd__mux2_1
X_14252_ _07551_ VGND VGND VPWR VPWR _00984_ sky130_fd_sc_hd__clkbuf_1
X_11464_ net608 _05171_ _05338_ VGND VGND VPWR VPWR _05344_ sky130_fd_sc_hd__mux2_1
XFILLER_0_40_309 VGND VGND VPWR VPWR sky130_fd_sc_hd__decap_6
X_10415_ _04125_ _04623_ _04627_ _03829_ VGND VGND VPWR VPWR _04628_ sky130_fd_sc_hd__o211a_1
XFILLER_0_123_558 VGND VGND VPWR VPWR sky130_fd_sc_hd__fill_2
X_13203_ _06461_ _06689_ VGND VGND VPWR VPWR _06690_ sky130_fd_sc_hd__and2_1
XFILLER_0_104_772 VGND VGND VPWR VPWR sky130_fd_sc_hd__fill_1
XFILLER_0_61_692 VGND VGND VPWR VPWR sky130_fd_sc_hd__fill_2
X_14183_ _07512_ _07513_ _02085_ VGND VGND VPWR VPWR _07514_ sky130_fd_sc_hd__a21o_1
X_11395_ _05307_ VGND VGND VPWR VPWR _00392_ sky130_fd_sc_hd__clkbuf_1
X_10346_ cpuregs\[16\]\[21\] cpuregs\[17\]\[21\] cpuregs\[18\]\[21\] cpuregs\[19\]\[21\]
+ _03819_ _03799_ VGND VGND VPWR VPWR _04561_ sky130_fd_sc_hd__mux4_1
X_13134_ cpuregs\[30\]\[10\] cpuregs\[31\]\[10\] _06462_ VGND VGND VPWR VPWR _06623_
+ sky130_fd_sc_hd__mux2_1
XTAP_707 VGND VPWR sky130_fd_sc_hd__tapvpwrvgnd_1
XFILLER_0_29_14 VGND VGND VPWR VPWR sky130_fd_sc_hd__fill_1
X_10277_ cpuregs\[22\]\[19\] cpuregs\[23\]\[19\] _04194_ VGND VGND VPWR VPWR _04494_
+ sky130_fd_sc_hd__mux2_1
X_13065_ _03341_ _06555_ VGND VGND VPWR VPWR _06556_ sky130_fd_sc_hd__and2_1
XTAP_718 VGND VPWR sky130_fd_sc_hd__tapvpwrvgnd_1
XTAP_729 VGND VPWR sky130_fd_sc_hd__tapvpwrvgnd_1
X_12016_ net553 _05677_ _05679_ VGND VGND VPWR VPWR _00641_ sky130_fd_sc_hd__o21a_1
X_16824_ clknet_leaf_112_clk _01388_ VGND VGND VPWR VPWR cpuregs\[7\]\[7\] sky130_fd_sc_hd__dfxtp_1
X_13967_ instr_sll _07367_ _07334_ _07384_ VGND VGND VPWR VPWR _07391_ sky130_fd_sc_hd__a22o_1
X_16755_ clknet_leaf_101_clk _01319_ VGND VGND VPWR VPWR cpuregs\[5\]\[2\] sky130_fd_sc_hd__dfxtp_1
X_15706_ clknet_leaf_126_clk _00356_ VGND VGND VPWR VPWR cpuregs\[21\]\[0\] sky130_fd_sc_hd__dfxtp_1
X_16686_ clknet_leaf_119_clk _01253_ VGND VGND VPWR VPWR cpuregs\[3\]\[0\] sky130_fd_sc_hd__dfxtp_1
X_12918_ _06412_ net251 _06375_ VGND VGND VPWR VPWR _06413_ sky130_fd_sc_hd__mux2_1
XTAP_2180 VGND VPWR sky130_fd_sc_hd__tapvpwrvgnd_1
X_15637_ clknet_leaf_68_clk _00287_ VGND VGND VPWR VPWR cpuregs\[31\]\[27\] sky130_fd_sc_hd__dfxtp_1
X_13898_ mem_rdata_q\[12\] mem_rdata_q\[13\] _07327_ VGND VGND VPWR VPWR _07346_ sky130_fd_sc_hd__and3b_1
XTAP_2191 VGND VPWR sky130_fd_sc_hd__tapvpwrvgnd_1
X_12849_ _03346_ VGND VGND VPWR VPWR _06348_ sky130_fd_sc_hd__buf_4
X_15568_ clknet_leaf_79_clk _00218_ VGND VGND VPWR VPWR cpuregs\[2\]\[22\] sky130_fd_sc_hd__dfxtp_1
XTAP_1490 VGND VPWR sky130_fd_sc_hd__tapvpwrvgnd_1
XFILLER_0_17_818 VGND VGND VPWR VPWR sky130_fd_sc_hd__decap_4
X_15499_ clknet_leaf_99_clk _00149_ VGND VGND VPWR VPWR cpuregs\[30\]\[17\] sky130_fd_sc_hd__dfxtp_1
X_14519_ net773 _05181_ _01623_ VGND VGND VPWR VPWR _01624_ sky130_fd_sc_hd__mux2_1
X_08040_ reg_pc\[15\] decoded_imm\[15\] _02436_ VGND VGND VPWR VPWR _02437_ sky130_fd_sc_hd__a21oi_1
XFILLER_0_9_46 VGND VGND VPWR VPWR sky130_fd_sc_hd__decap_6
Xhold903 cpuregs\[21\]\[2\] VGND VGND VPWR VPWR net1261 sky130_fd_sc_hd__dlygate4sd3_1
Xhold914 cpuregs\[31\]\[0\] VGND VGND VPWR VPWR net1272 sky130_fd_sc_hd__dlygate4sd3_1
Xhold925 cpuregs\[24\]\[4\] VGND VGND VPWR VPWR net1283 sky130_fd_sc_hd__dlygate4sd3_1
XFILLER_0_24_394 VGND VGND VPWR VPWR sky130_fd_sc_hd__fill_1
Xhold936 cpuregs\[16\]\[5\] VGND VGND VPWR VPWR net1294 sky130_fd_sc_hd__dlygate4sd3_1
Xhold958 cpuregs\[8\]\[28\] VGND VGND VPWR VPWR net1316 sky130_fd_sc_hd__dlygate4sd3_1
Xhold947 cpuregs\[10\]\[23\] VGND VGND VPWR VPWR net1305 sky130_fd_sc_hd__dlygate4sd3_1
X_09991_ cpuregs\[28\]\[11\] cpuregs\[29\]\[11\] _03768_ VGND VGND VPWR VPWR _04216_
+ sky130_fd_sc_hd__mux2_1
XFILLER_0_10_93 VGND VGND VPWR VPWR sky130_fd_sc_hd__fill_1
Xhold969 cpuregs\[4\]\[3\] VGND VGND VPWR VPWR net1327 sky130_fd_sc_hd__dlygate4sd3_1
X_08942_ _03252_ VGND VGND VPWR VPWR net69 sky130_fd_sc_hd__clkbuf_4
XFILLER_0_86_75 VGND VGND VPWR VPWR sky130_fd_sc_hd__fill_1
X_08873_ _02143_ net249 net209 _02133_ VGND VGND VPWR VPWR _03212_ sky130_fd_sc_hd__a22o_1
XFILLER_0_19_91 VGND VGND VPWR VPWR sky130_fd_sc_hd__fill_2
XFILLER_0_36_3 VGND VGND VPWR VPWR sky130_fd_sc_hd__fill_2
XFILLER_0_98_309 VGND VGND VPWR VPWR sky130_fd_sc_hd__decap_4
X_07824_ instr_rdinstr VGND VGND VPWR VPWR _02236_ sky130_fd_sc_hd__clkbuf_4
X_07755_ instr_rdcycle is_slli_srli_srai _02173_ _02131_ VGND VGND VPWR VPWR _02174_
+ sky130_fd_sc_hd__and4bb_1
X_07686_ mem_do_wdata _02112_ VGND VGND VPWR VPWR _02114_ sky130_fd_sc_hd__nand2_1
XFILLER_0_67_729 VGND VGND VPWR VPWR sky130_fd_sc_hd__fill_1
X_09425_ _00014_ VGND VGND VPWR VPWR _03661_ sky130_fd_sc_hd__buf_4
XFILLER_0_66_239 VGND VGND VPWR VPWR sky130_fd_sc_hd__decap_6
X_09356_ reg_pc\[24\] _03593_ VGND VGND VPWR VPWR _03600_ sky130_fd_sc_hd__nand2_1
XFILLER_0_35_615 VGND VGND VPWR VPWR sky130_fd_sc_hd__fill_1
X_08307_ net208 VGND VGND VPWR VPWR _02688_ sky130_fd_sc_hd__clkbuf_4
X_09287_ reg_out\[15\] alu_out_q\[15\] _03435_ VGND VGND VPWR VPWR _03540_ sky130_fd_sc_hd__mux2_1
XFILLER_0_74_294 VPWR VGND VPWR VGND sky130_ef_sc_hd__decap_12
X_08238_ _02147_ _02618_ _02619_ _02622_ _02284_ VGND VGND VPWR VPWR _02623_ sky130_fd_sc_hd__a311o_1
XFILLER_0_90_754 VGND VGND VPWR VPWR sky130_fd_sc_hd__fill_2
XFILLER_0_7_561 VGND VGND VPWR VPWR sky130_fd_sc_hd__fill_1
XFILLER_0_132_377 VGND VGND VPWR VPWR sky130_fd_sc_hd__decap_3
X_08169_ _02501_ _02503_ _02557_ VGND VGND VPWR VPWR _02558_ sky130_fd_sc_hd__a21oi_2
X_10200_ _03984_ _04416_ _04418_ VGND VGND VPWR VPWR _04419_ sky130_fd_sc_hd__a21o_1
X_11180_ net714 _05181_ _05182_ VGND VGND VPWR VPWR _05183_ sky130_fd_sc_hd__mux2_1
XFILLER_0_101_753 VGND VGND VPWR VPWR sky130_fd_sc_hd__fill_2
X_10131_ cpuregs\[28\]\[15\] cpuregs\[29\]\[15\] _03754_ VGND VGND VPWR VPWR _04352_
+ sky130_fd_sc_hd__mux2_1
X_10062_ cpuregs\[28\]\[13\] cpuregs\[29\]\[13\] _03754_ VGND VGND VPWR VPWR _04285_
+ sky130_fd_sc_hd__mux2_1
XFILLER_0_100_296 VPWR VGND VPWR VGND sky130_ef_sc_hd__decap_12
X_14870_ _03544_ net959 _01804_ VGND VGND VPWR VPWR _01810_ sky130_fd_sc_hd__mux2_1
XFILLER_0_97_320 VPWR VGND VPWR VGND sky130_ef_sc_hd__decap_12
X_13821_ _07288_ VGND VGND VPWR VPWR _00837_ sky130_fd_sc_hd__clkbuf_1
X_13752_ cpuregs\[24\]\[29\] cpuregs\[25\]\[29\] cpuregs\[26\]\[29\] cpuregs\[27\]\[29\]
+ _06443_ _06444_ VGND VGND VPWR VPWR _07222_ sky130_fd_sc_hd__mux4_1
XFILLER_0_106_29 VGND VGND VPWR VPWR sky130_fd_sc_hd__fill_2
X_16540_ clknet_leaf_7_clk _01117_ VGND VGND VPWR VPWR mem_rdata_q\[24\] sky130_fd_sc_hd__dfxtp_1
X_10964_ _05051_ VGND VGND VPWR VPWR _05063_ sky130_fd_sc_hd__clkbuf_8
X_12703_ count_cycle\[59\] _06230_ _06241_ VGND VGND VPWR VPWR _06242_ sky130_fd_sc_hd__and3_1
X_13683_ _06911_ _07154_ VGND VGND VPWR VPWR _07155_ sky130_fd_sc_hd__or2_1
X_16471_ clknet_leaf_53_clk _01053_ VGND VGND VPWR VPWR cpuregs\[18\]\[24\] sky130_fd_sc_hd__dfxtp_1
X_10895_ _05019_ VGND VGND VPWR VPWR _00180_ sky130_fd_sc_hd__clkbuf_1
X_15422_ clknet_leaf_15_clk _00072_ VGND VGND VPWR VPWR net196 sky130_fd_sc_hd__dfxtp_2
X_12634_ _06191_ _06189_ _06192_ VGND VGND VPWR VPWR _00746_ sky130_fd_sc_hd__a21oi_1
X_15353_ _03577_ net1196 _02063_ VGND VGND VPWR VPWR _02064_ sky130_fd_sc_hd__mux2_1
X_12565_ _06142_ _06128_ _06143_ VGND VGND VPWR VPWR _06144_ sky130_fd_sc_hd__and3b_1
XFILLER_0_25_103 VGND VGND VPWR VPWR sky130_fd_sc_hd__fill_2
XFILLER_0_38_497 VGND VGND VPWR VPWR sky130_fd_sc_hd__decap_4
X_11516_ net581 _05223_ _05337_ VGND VGND VPWR VPWR _05371_ sky130_fd_sc_hd__mux2_1
X_14304_ _07569_ _07573_ _07582_ _07575_ decoded_imm\[24\] VGND VGND VPWR VPWR _01005_
+ sky130_fd_sc_hd__o32a_1
X_12496_ _06086_ _06089_ _06087_ VGND VGND VPWR VPWR _06095_ sky130_fd_sc_hd__o21ai_1
XFILLER_0_123_333 VGND VGND VPWR VPWR sky130_fd_sc_hd__decap_3
X_15284_ _02027_ VGND VGND VPWR VPWR _01496_ sky130_fd_sc_hd__clkbuf_1
XFILLER_0_22_810 VGND VGND VPWR VPWR sky130_fd_sc_hd__fill_2
XFILLER_0_25_169 VGND VGND VPWR VPWR sky130_fd_sc_hd__decap_4
X_14235_ net710 net110 _07541_ VGND VGND VPWR VPWR _07543_ sky130_fd_sc_hd__mux2_1
X_11447_ _05334_ VGND VGND VPWR VPWR _00417_ sky130_fd_sc_hd__clkbuf_1
XFILLER_0_111_517 VGND VGND VPWR VPWR sky130_fd_sc_hd__fill_1
XFILLER_0_1_715 VGND VGND VPWR VPWR sky130_fd_sc_hd__decap_3
X_14166_ _07503_ VGND VGND VPWR VPWR _00946_ sky130_fd_sc_hd__clkbuf_1
X_11378_ _05045_ net1448 _05288_ VGND VGND VPWR VPWR _05298_ sky130_fd_sc_hd__mux2_1
XFILLER_0_0_225 VGND VGND VPWR VPWR sky130_fd_sc_hd__fill_2
X_10329_ _04541_ _04543_ VGND VGND VPWR VPWR _04544_ sky130_fd_sc_hd__nand2_1
X_13117_ cpuregs\[4\]\[10\] cpuregs\[5\]\[10\] _06575_ VGND VGND VPWR VPWR _06606_
+ sky130_fd_sc_hd__mux2_1
XTAP_504 VGND VPWR sky130_fd_sc_hd__tapvpwrvgnd_1
XTAP_515 VGND VPWR sky130_fd_sc_hd__tapvpwrvgnd_1
XTAP_526 VGND VPWR sky130_fd_sc_hd__tapvpwrvgnd_1
XTAP_537 VGND VPWR sky130_fd_sc_hd__tapvpwrvgnd_1
XTAP_548 VGND VPWR sky130_fd_sc_hd__tapvpwrvgnd_1
X_14097_ _02189_ _07306_ _01098_ _07463_ VGND VGND VPWR VPWR _00914_ sky130_fd_sc_hd__a22o_1
XTAP_559 VGND VPWR sky130_fd_sc_hd__tapvpwrvgnd_1
X_13048_ cpuregs\[10\]\[8\] cpuregs\[11\]\[8\] _06424_ VGND VGND VPWR VPWR _06539_
+ sky130_fd_sc_hd__mux2_1
X_16807_ clknet_leaf_76_clk _01371_ VGND VGND VPWR VPWR cpuregs\[6\]\[22\] sky130_fd_sc_hd__dfxtp_1
XFILLER_0_22_9 VGND VGND VPWR VPWR sky130_fd_sc_hd__fill_2
X_16738_ clknet_leaf_87_clk _01302_ VGND VGND VPWR VPWR cpuregs\[4\]\[17\] sky130_fd_sc_hd__dfxtp_1
X_14999_ _01878_ VGND VGND VPWR VPWR _01360_ sky130_fd_sc_hd__clkbuf_1
XFILLER_0_119_617 VGND VGND VPWR VPWR sky130_fd_sc_hd__decap_4
X_16669_ clknet_leaf_93_clk _01236_ VGND VGND VPWR VPWR cpuregs\[29\]\[15\] sky130_fd_sc_hd__dfxtp_1
XFILLER_0_8_325 VGND VGND VPWR VPWR sky130_fd_sc_hd__decap_4
X_09210_ _03473_ VGND VGND VPWR VPWR _00041_ sky130_fd_sc_hd__clkbuf_1
XFILLER_0_56_272 VGND VGND VPWR VPWR sky130_fd_sc_hd__decap_6
X_09141_ _03419_ decoded_imm_j\[4\] is_slli_srli_srai VGND VGND VPWR VPWR _03420_
+ sky130_fd_sc_hd__mux2_1
XFILLER_0_126_160 VGND VGND VPWR VPWR sky130_fd_sc_hd__fill_1
X_09072_ cpuregs\[18\]\[2\] cpuregs\[19\]\[2\] _03312_ VGND VGND VPWR VPWR _03353_
+ sky130_fd_sc_hd__mux2_1
X_08023_ count_instr\[47\] _02269_ _02235_ _02420_ VGND VGND VPWR VPWR _02421_ sky130_fd_sc_hd__a211o_1
Xhold700 cpuregs\[26\]\[10\] VGND VGND VPWR VPWR net1058 sky130_fd_sc_hd__dlygate4sd3_1
Xhold711 cpuregs\[11\]\[9\] VGND VGND VPWR VPWR net1069 sky130_fd_sc_hd__dlygate4sd3_1
Xhold722 cpuregs\[6\]\[23\] VGND VGND VPWR VPWR net1080 sky130_fd_sc_hd__dlygate4sd3_1
Xhold744 cpuregs\[23\]\[29\] VGND VGND VPWR VPWR net1102 sky130_fd_sc_hd__dlygate4sd3_1
Xhold733 cpuregs\[18\]\[20\] VGND VGND VPWR VPWR net1091 sky130_fd_sc_hd__dlygate4sd3_1
Xhold755 cpuregs\[8\]\[13\] VGND VGND VPWR VPWR net1113 sky130_fd_sc_hd__dlygate4sd3_1
Xhold788 cpuregs\[31\]\[26\] VGND VGND VPWR VPWR net1146 sky130_fd_sc_hd__dlygate4sd3_1
Xhold766 cpuregs\[20\]\[19\] VGND VGND VPWR VPWR net1124 sky130_fd_sc_hd__dlygate4sd3_1
Xhold777 cpuregs\[10\]\[7\] VGND VGND VPWR VPWR net1135 sky130_fd_sc_hd__dlygate4sd3_1
Xhold799 cpuregs\[16\]\[10\] VGND VGND VPWR VPWR net1157 sky130_fd_sc_hd__dlygate4sd3_1
X_09974_ _03732_ _04193_ _04198_ _03684_ VGND VGND VPWR VPWR _04199_ sky130_fd_sc_hd__o211a_1
X_08925_ _03240_ VGND VGND VPWR VPWR net94 sky130_fd_sc_hd__clkbuf_4
X_08856_ _03203_ VGND VGND VPWR VPWR net132 sky130_fd_sc_hd__buf_2
X_07807_ net1 net130 _02217_ _02219_ VGND VGND VPWR VPWR _02220_ sky130_fd_sc_hd__a22o_1
X_08787_ _02593_ net221 _02915_ _03031_ VGND VGND VPWR VPWR _03142_ sky130_fd_sc_hd__a31o_1
XFILLER_0_79_320 VGND VGND VPWR VPWR sky130_fd_sc_hd__fill_1
X_07738_ cpu_state\[4\] VGND VGND VPWR VPWR _02159_ sky130_fd_sc_hd__buf_4
XFILLER_0_94_334 VGND VGND VPWR VPWR sky130_fd_sc_hd__fill_1
X_07669_ mem_do_wdata net34 cpu_state\[5\] VGND VGND VPWR VPWR _02099_ sky130_fd_sc_hd__and3b_1
XFILLER_0_137_425 VGND VGND VPWR VPWR sky130_fd_sc_hd__fill_1
X_09408_ _03643_ _03644_ _03460_ VGND VGND VPWR VPWR _03645_ sky130_fd_sc_hd__mux2_4
XFILLER_0_109_127 VGND VGND VPWR VPWR sky130_fd_sc_hd__decap_8
X_10680_ cpuregs\[0\]\[30\] cpuregs\[1\]\[30\] _03902_ VGND VGND VPWR VPWR _04886_
+ sky130_fd_sc_hd__mux2_1
X_09339_ _03585_ VGND VGND VPWR VPWR _00058_ sky130_fd_sc_hd__clkbuf_1
XFILLER_0_47_272 VGND VGND VPWR VPWR sky130_fd_sc_hd__fill_1
X_12350_ _05960_ _05961_ VGND VGND VPWR VPWR _05962_ sky130_fd_sc_hd__and2_1
X_11301_ net606 _05213_ _05251_ VGND VGND VPWR VPWR _05257_ sky130_fd_sc_hd__mux2_1
XFILLER_0_132_141 VGND VGND VPWR VPWR sky130_fd_sc_hd__fill_2
X_12281_ decoded_imm_j\[13\] _05718_ VGND VGND VPWR VPWR _05898_ sky130_fd_sc_hd__nor2_1
XFILLER_0_62_297 VGND VGND VPWR VPWR sky130_fd_sc_hd__decap_8
XFILLER_0_22_139 VGND VGND VPWR VPWR sky130_fd_sc_hd__fill_1
XFILLER_0_132_185 VGND VGND VPWR VPWR sky130_fd_sc_hd__fill_1
X_11232_ net1340 _05217_ _05203_ VGND VGND VPWR VPWR _05218_ sky130_fd_sc_hd__mux2_1
XFILLER_0_120_336 VGND VGND VPWR VPWR sky130_fd_sc_hd__decap_3
X_14020_ _07426_ VGND VGND VPWR VPWR _00887_ sky130_fd_sc_hd__clkbuf_1
XFILLER_0_120_347 VGND VGND VPWR VPWR sky130_fd_sc_hd__fill_1
X_11163_ _03477_ VGND VGND VPWR VPWR _05171_ sky130_fd_sc_hd__clkbuf_4
X_10114_ _03766_ _04332_ _04334_ VGND VGND VPWR VPWR _04335_ sky130_fd_sc_hd__a21o_1
X_15971_ clknet_leaf_148_clk _00621_ VGND VGND VPWR VPWR count_instr\[40\] sky130_fd_sc_hd__dfxtp_1
X_11094_ net1268 _03491_ _05124_ VGND VGND VPWR VPWR _05132_ sky130_fd_sc_hd__mux2_1
X_10045_ _03766_ _04265_ _04267_ VGND VGND VPWR VPWR _04268_ sky130_fd_sc_hd__a21o_1
X_14922_ _01837_ VGND VGND VPWR VPWR _01324_ sky130_fd_sc_hd__clkbuf_1
XFILLER_0_117_39 VGND VGND VPWR VPWR sky130_fd_sc_hd__fill_1
Xhold82 reg_next_pc\[9\] VGND VGND VPWR VPWR net440 sky130_fd_sc_hd__dlygate4sd3_1
Xhold60 count_cycle\[53\] VGND VGND VPWR VPWR net418 sky130_fd_sc_hd__dlygate4sd3_1
Xhold71 count_instr\[36\] VGND VGND VPWR VPWR net429 sky130_fd_sc_hd__dlygate4sd3_1
XFILLER_0_26_26 VGND VGND VPWR VPWR sky130_fd_sc_hd__fill_2
X_14853_ _03491_ net1414 _01793_ VGND VGND VPWR VPWR _01801_ sky130_fd_sc_hd__mux2_1
X_13804_ _06969_ _07267_ _07269_ _03309_ _07271_ VGND VGND VPWR VPWR _07272_ sky130_fd_sc_hd__o311a_1
Xhold93 count_instr\[49\] VGND VGND VPWR VPWR net451 sky130_fd_sc_hd__dlygate4sd3_1
X_11996_ _05666_ VGND VGND VPWR VPWR _00634_ sky130_fd_sc_hd__clkbuf_1
X_14784_ net1384 _05175_ _01756_ VGND VGND VPWR VPWR _01764_ sky130_fd_sc_hd__mux2_1
X_13735_ _03340_ _07204_ _06998_ VGND VGND VPWR VPWR _07205_ sky130_fd_sc_hd__a21o_1
XFILLER_0_85_334 VGND VGND VPWR VPWR sky130_fd_sc_hd__fill_2
X_16523_ clknet_leaf_139_clk _01100_ VGND VGND VPWR VPWR mem_rdata_q\[7\] sky130_fd_sc_hd__dfxtp_1
X_10947_ _05054_ VGND VGND VPWR VPWR _00197_ sky130_fd_sc_hd__clkbuf_1
X_13666_ _06421_ _07136_ _07138_ _06894_ VGND VGND VPWR VPWR _07139_ sky130_fd_sc_hd__a211o_1
XFILLER_0_45_209 VGND VGND VPWR VPWR sky130_fd_sc_hd__fill_2
X_16454_ clknet_leaf_128_clk _01036_ VGND VGND VPWR VPWR cpuregs\[18\]\[7\] sky130_fd_sc_hd__dfxtp_1
X_15405_ clknet_leaf_77_clk _00060_ VGND VGND VPWR VPWR cpuregs\[11\]\[23\] sky130_fd_sc_hd__dfxtp_1
X_10878_ _03518_ VGND VGND VPWR VPWR _05008_ sky130_fd_sc_hd__buf_2
X_12617_ _06178_ _06179_ _06180_ VGND VGND VPWR VPWR _06181_ sky130_fd_sc_hd__and3b_1
X_16385_ clknet_leaf_37_clk _00967_ VGND VGND VPWR VPWR net138 sky130_fd_sc_hd__dfxtp_1
X_13597_ _06849_ _07071_ VGND VGND VPWR VPWR _07072_ sky130_fd_sc_hd__or2_1
Xclkbuf_4_14_0_clk clknet_0_clk VGND VGND VPWR VPWR clknet_4_14_0_clk sky130_fd_sc_hd__clkbuf_8
XFILLER_0_54_765 VGND VGND VPWR VPWR sky130_fd_sc_hd__fill_2
XFILLER_0_5_328 VGND VGND VPWR VPWR sky130_fd_sc_hd__fill_2
X_15336_ _03525_ net634 _02052_ VGND VGND VPWR VPWR _02055_ sky130_fd_sc_hd__mux2_1
XFILLER_0_53_264 VGND VGND VPWR VPWR sky130_fd_sc_hd__fill_2
X_12548_ net578 _06127_ _06131_ VGND VGND VPWR VPWR _00721_ sky130_fd_sc_hd__o21a_1
X_12479_ _06075_ _06076_ _06077_ _06079_ VGND VGND VPWR VPWR _06080_ sky130_fd_sc_hd__o31ai_1
XFILLER_0_123_152 VGND VGND VPWR VPWR sky130_fd_sc_hd__decap_4
XANTENNA_2 _02368_ VGND VGND VPWR VPWR sky130_fd_sc_hd__diode_2
X_15267_ net488 VGND VGND VPWR VPWR _02019_ sky130_fd_sc_hd__clkbuf_1
XFILLER_0_41_437 VGND VGND VPWR VPWR sky130_fd_sc_hd__fill_2
X_14218_ net527 net101 _07530_ VGND VGND VPWR VPWR _07534_ sky130_fd_sc_hd__mux2_1
XFILLER_0_111_358 VGND VGND VPWR VPWR sky130_fd_sc_hd__decap_4
XFILLER_0_111_347 VGND VGND VPWR VPWR sky130_fd_sc_hd__fill_2
XFILLER_0_6_47 VGND VGND VPWR VPWR sky130_fd_sc_hd__fill_2
XFILLER_0_10_813 VGND VGND VPWR VPWR sky130_fd_sc_hd__decap_3
X_15198_ _01983_ VGND VGND VPWR VPWR _01454_ sky130_fd_sc_hd__clkbuf_1
X_14149_ _05029_ net1312 _07493_ VGND VGND VPWR VPWR _07495_ sky130_fd_sc_hd__mux2_1
XFILLER_0_67_55 VGND VGND VPWR VPWR sky130_fd_sc_hd__fill_1
XTAP_312 VGND VPWR sky130_fd_sc_hd__tapvpwrvgnd_1
XTAP_301 VGND VPWR sky130_fd_sc_hd__tapvpwrvgnd_1
XTAP_323 VGND VPWR sky130_fd_sc_hd__tapvpwrvgnd_1
XTAP_367 VGND VPWR sky130_fd_sc_hd__tapvpwrvgnd_1
XTAP_356 VGND VPWR sky130_fd_sc_hd__tapvpwrvgnd_1
XTAP_345 VGND VPWR sky130_fd_sc_hd__tapvpwrvgnd_1
XTAP_334 VGND VPWR sky130_fd_sc_hd__tapvpwrvgnd_1
X_08710_ _03070_ _03056_ _03058_ VGND VGND VPWR VPWR _03071_ sky130_fd_sc_hd__o21ai_1
XTAP_389 VGND VPWR sky130_fd_sc_hd__tapvpwrvgnd_1
XTAP_378 VGND VPWR sky130_fd_sc_hd__tapvpwrvgnd_1
X_09690_ _03719_ _03921_ _03731_ VGND VGND VPWR VPWR _03922_ sky130_fd_sc_hd__a21o_1
X_08641_ _02416_ _02688_ _02879_ VGND VGND VPWR VPWR _03008_ sky130_fd_sc_hd__a21oi_1
Xrebuffer25 net384 VGND VGND VPWR VPWR net383 sky130_fd_sc_hd__clkbuf_2
Xrebuffer14 net373 VGND VGND VPWR VPWR net372 sky130_fd_sc_hd__clkbuf_1
XFILLER_0_89_673 VGND VGND VPWR VPWR sky130_fd_sc_hd__fill_1
XFILLER_0_88_161 VGND VGND VPWR VPWR sky130_fd_sc_hd__fill_1
XFILLER_0_83_98 VGND VGND VPWR VPWR sky130_fd_sc_hd__fill_1
X_08572_ _02677_ _02895_ _02943_ VGND VGND VPWR VPWR _02944_ sky130_fd_sc_hd__a21o_1
XPHY_18 VGND VGND VPWR VPWR sky130_fd_sc_hd__decap_3
XPHY_29 VGND VGND VPWR VPWR sky130_fd_sc_hd__decap_3
XFILLER_0_123_71 VGND VGND VPWR VPWR sky130_fd_sc_hd__fill_1
XFILLER_0_123_60 VGND VGND VPWR VPWR sky130_fd_sc_hd__decap_3
XFILLER_0_91_337 VGND VGND VPWR VPWR sky130_fd_sc_hd__decap_3
XFILLER_0_9_645 VGND VGND VPWR VPWR sky130_fd_sc_hd__fill_2
XFILLER_0_134_406 VGND VGND VPWR VPWR sky130_fd_sc_hd__fill_2
XFILLER_0_91_359 VGND VGND VPWR VPWR sky130_fd_sc_hd__fill_1
XFILLER_0_44_220 VGND VGND VPWR VPWR sky130_fd_sc_hd__fill_2
XFILLER_0_60_713 VGND VGND VPWR VPWR sky130_fd_sc_hd__fill_2
X_09124_ cpuregs\[12\]\[4\] cpuregs\[13\]\[4\] cpuregs\[14\]\[4\] cpuregs\[15\]\[4\]
+ _03329_ _03330_ VGND VGND VPWR VPWR _03403_ sky130_fd_sc_hd__mux4_1
XFILLER_0_72_595 VGND VGND VPWR VPWR sky130_fd_sc_hd__fill_1
X_09055_ _03312_ VGND VGND VPWR VPWR _03336_ sky130_fd_sc_hd__clkbuf_8
XFILLER_0_130_645 VGND VGND VPWR VPWR sky130_fd_sc_hd__fill_2
X_08006_ _02242_ _02403_ _02405_ _02194_ _02199_ VGND VGND VPWR VPWR _02406_ sky130_fd_sc_hd__a221o_1
Xhold530 cpuregs\[19\]\[14\] VGND VGND VPWR VPWR net888 sky130_fd_sc_hd__dlygate4sd3_1
XFILLER_0_4_394 VGND VGND VPWR VPWR sky130_fd_sc_hd__decap_3
Xhold552 cpuregs\[12\]\[29\] VGND VGND VPWR VPWR net910 sky130_fd_sc_hd__dlygate4sd3_1
XFILLER_0_102_347 VGND VGND VPWR VPWR sky130_fd_sc_hd__fill_1
Xhold563 cpuregs\[8\]\[17\] VGND VGND VPWR VPWR net921 sky130_fd_sc_hd__dlygate4sd3_1
Xhold541 cpuregs\[11\]\[17\] VGND VGND VPWR VPWR net899 sky130_fd_sc_hd__dlygate4sd3_1
XFILLER_0_12_150 VGND VGND VPWR VPWR sky130_fd_sc_hd__decap_6
XFILLER_0_13_673 VGND VGND VPWR VPWR sky130_fd_sc_hd__decap_6
Xhold596 cpuregs\[18\]\[10\] VGND VGND VPWR VPWR net954 sky130_fd_sc_hd__dlygate4sd3_1
Xhold585 cpuregs\[1\]\[11\] VGND VGND VPWR VPWR net943 sky130_fd_sc_hd__dlygate4sd3_1
Xhold574 cpuregs\[25\]\[2\] VGND VGND VPWR VPWR net932 sky130_fd_sc_hd__dlygate4sd3_1
X_09957_ reg_pc\[10\] _03776_ _04176_ _04182_ _03946_ VGND VGND VPWR VPWR _04183_
+ sky130_fd_sc_hd__a221o_1
X_08908_ reg_out\[3\] reg_next_pc\[3\] _03225_ VGND VGND VPWR VPWR _03229_ sky130_fd_sc_hd__mux2_1
Xhold1230 cpuregs\[26\]\[26\] VGND VGND VPWR VPWR net1588 sky130_fd_sc_hd__dlygate4sd3_1
Xhold1252 cpuregs\[9\]\[24\] VGND VGND VPWR VPWR net1610 sky130_fd_sc_hd__dlygate4sd3_1
XFILLER_0_99_437 VGND VGND VPWR VPWR sky130_fd_sc_hd__fill_2
X_09888_ _02294_ _02340_ _02403_ _02366_ _03847_ _03916_ VGND VGND VPWR VPWR _04115_
+ sky130_fd_sc_hd__mux4_1
Xhold1241 cpuregs\[21\]\[7\] VGND VGND VPWR VPWR net1599 sky130_fd_sc_hd__dlygate4sd3_1
XTAP_890 VGND VPWR sky130_fd_sc_hd__tapvpwrvgnd_1
X_08839_ _02646_ _03189_ VGND VGND VPWR VPWR _03190_ sky130_fd_sc_hd__and2_1
Xhold1274 cpuregs\[4\]\[24\] VGND VGND VPWR VPWR net1632 sky130_fd_sc_hd__dlygate4sd3_1
Xhold1263 cpuregs\[31\]\[1\] VGND VGND VPWR VPWR net1621 sky130_fd_sc_hd__dlygate4sd3_1
Xhold1285 cpuregs\[29\]\[9\] VGND VGND VPWR VPWR net1643 sky130_fd_sc_hd__dlygate4sd3_1
XFILLER_0_95_610 VGND VGND VPWR VPWR sky130_fd_sc_hd__fill_2
Xhold1296 decoded_imm\[5\] VGND VGND VPWR VPWR net1654 sky130_fd_sc_hd__dlygate4sd3_1
X_11850_ count_instr\[14\] _05557_ VGND VGND VPWR VPWR _05560_ sky130_fd_sc_hd__and2_1
X_11781_ _05039_ net1232 _05505_ VGND VGND VPWR VPWR _05512_ sky130_fd_sc_hd__mux2_1
XFILLER_0_67_334 VGND VGND VPWR VPWR sky130_fd_sc_hd__fill_2
X_10801_ net996 _03532_ _04957_ VGND VGND VPWR VPWR _04961_ sky130_fd_sc_hd__mux2_1
X_13520_ cpuregs\[10\]\[22\] cpuregs\[11\]\[22\] _06766_ VGND VGND VPWR VPWR _06997_
+ sky130_fd_sc_hd__mux2_1
X_10732_ net691 _03538_ _04918_ VGND VGND VPWR VPWR _04923_ sky130_fd_sc_hd__mux2_1
XFILLER_0_138_778 VPWR VGND VPWR VGND sky130_ef_sc_hd__decap_12
X_10663_ decoded_imm\[30\] _02646_ VGND VGND VPWR VPWR _04869_ sky130_fd_sc_hd__nand2_1
XFILLER_0_94_197 VGND VGND VPWR VPWR sky130_fd_sc_hd__fill_1
X_13451_ _06930_ VGND VGND VPWR VPWR _00825_ sky130_fd_sc_hd__clkbuf_1
X_16170_ clknet_leaf_38_clk _00788_ VGND VGND VPWR VPWR net43 sky130_fd_sc_hd__dfxtp_1
X_10594_ cpuregs\[12\]\[28\] cpuregs\[13\]\[28\] _03880_ VGND VGND VPWR VPWR _04802_
+ sky130_fd_sc_hd__mux2_1
X_12402_ _05811_ _06009_ VGND VGND VPWR VPWR _06010_ sky130_fd_sc_hd__nor2_1
XFILLER_0_106_620 VGND VGND VPWR VPWR sky130_fd_sc_hd__fill_2
X_13382_ _06762_ _06848_ _06863_ _06802_ decoded_imm\[17\] VGND VGND VPWR VPWR _06864_
+ sky130_fd_sc_hd__a32o_1
XFILLER_0_23_415 VGND VGND VPWR VPWR sky130_fd_sc_hd__decap_3
X_12333_ _05898_ _05917_ _05945_ _05899_ VGND VGND VPWR VPWR _05946_ sky130_fd_sc_hd__or4b_1
X_15121_ net968 _03477_ _01937_ VGND VGND VPWR VPWR _01943_ sky130_fd_sc_hd__mux2_1
XFILLER_0_35_297 VGND VGND VPWR VPWR sky130_fd_sc_hd__decap_8
XFILLER_0_121_623 VGND VGND VPWR VPWR sky130_fd_sc_hd__decap_4
X_15052_ _01906_ VGND VGND VPWR VPWR _01385_ sky130_fd_sc_hd__clkbuf_1
X_12264_ _05881_ _05882_ VGND VGND VPWR VPWR _05883_ sky130_fd_sc_hd__and2b_1
X_14003_ net1398 _07382_ _07412_ _07417_ VGND VGND VPWR VPWR _00881_ sky130_fd_sc_hd__a22o_1
XFILLER_0_31_470 VGND VGND VPWR VPWR sky130_fd_sc_hd__fill_1
Xoutput61 net61 VGND VGND VPWR VPWR mem_addr[6] sky130_fd_sc_hd__clkbuf_4
XFILLER_0_120_166 VGND VGND VPWR VPWR sky130_fd_sc_hd__decap_3
X_11215_ _05206_ VGND VGND VPWR VPWR _00313_ sky130_fd_sc_hd__clkbuf_1
X_12195_ decoded_imm_j\[6\] _05704_ VGND VGND VPWR VPWR _05819_ sky130_fd_sc_hd__nand2_1
Xoutput50 net50 VGND VGND VPWR VPWR mem_addr[25] sky130_fd_sc_hd__clkbuf_4
XFILLER_0_128_27 VGND VGND VPWR VPWR sky130_fd_sc_hd__fill_1
Xoutput72 net72 VGND VGND VPWR VPWR mem_la_addr[16] sky130_fd_sc_hd__buf_2
X_11146_ _03439_ VGND VGND VPWR VPWR _05159_ sky130_fd_sc_hd__clkbuf_4
Xoutput83 net83 VGND VGND VPWR VPWR mem_la_addr[27] sky130_fd_sc_hd__clkbuf_4
Xoutput94 net94 VGND VGND VPWR VPWR mem_la_addr[8] sky130_fd_sc_hd__clkbuf_4
X_11077_ _05122_ VGND VGND VPWR VPWR _00259_ sky130_fd_sc_hd__clkbuf_1
X_15954_ clknet_leaf_153_clk _00604_ VGND VGND VPWR VPWR count_instr\[23\] sky130_fd_sc_hd__dfxtp_1
XFILLER_0_37_47 VGND VGND VPWR VPWR sky130_fd_sc_hd__fill_1
X_10028_ _04248_ _04249_ _04250_ _04251_ _04030_ _04103_ VGND VGND VPWR VPWR _04252_
+ sky130_fd_sc_hd__mux4_2
X_14905_ _04983_ _01791_ VGND VGND VPWR VPWR _01828_ sky130_fd_sc_hd__or2_4
X_15885_ clknet_leaf_56_clk _00535_ VGND VGND VPWR VPWR cpuregs\[20\]\[19\] sky130_fd_sc_hd__dfxtp_1
X_14836_ _04902_ _04900_ _04901_ VGND VGND VPWR VPWR _01791_ sky130_fd_sc_hd__or3b_4
XFILLER_0_98_481 VGND VGND VPWR VPWR sky130_fd_sc_hd__fill_1
X_14767_ _01754_ VGND VGND VPWR VPWR _01252_ sky130_fd_sc_hd__clkbuf_1
X_16506_ clknet_leaf_45_clk _01088_ VGND VGND VPWR VPWR cpuregs\[19\]\[27\] sky130_fd_sc_hd__dfxtp_1
X_13718_ cpuregs\[20\]\[28\] cpuregs\[21\]\[28\] _06456_ VGND VGND VPWR VPWR _07189_
+ sky130_fd_sc_hd__mux2_1
XFILLER_0_85_142 VPWR VGND VPWR VGND sky130_ef_sc_hd__decap_12
X_11979_ _05648_ _05652_ _05653_ _02164_ VGND VGND VPWR VPWR _00630_ sky130_fd_sc_hd__a211oi_1
XFILLER_0_129_756 VGND VGND VPWR VPWR sky130_fd_sc_hd__fill_2
XFILLER_0_128_233 VPWR VGND VPWR VGND sky130_ef_sc_hd__decap_12
XFILLER_0_86_698 VGND VGND VPWR VPWR sky130_fd_sc_hd__fill_2
X_14698_ net916 _05225_ _01683_ VGND VGND VPWR VPWR _01718_ sky130_fd_sc_hd__mux2_1
XFILLER_0_73_304 VGND VGND VPWR VPWR sky130_fd_sc_hd__decap_4
XFILLER_0_129_789 VGND VGND VPWR VPWR sky130_fd_sc_hd__fill_1
X_13649_ _06970_ _07121_ VGND VGND VPWR VPWR _07122_ sky130_fd_sc_hd__and2_1
XFILLER_0_73_337 VGND VGND VPWR VPWR sky130_fd_sc_hd__decap_3
X_16437_ clknet_leaf_26_clk _01019_ VGND VGND VPWR VPWR decoded_imm\[10\] sky130_fd_sc_hd__dfxtp_2
XFILLER_0_54_551 VGND VGND VPWR VPWR sky130_fd_sc_hd__fill_2
XFILLER_0_6_648 VGND VGND VPWR VPWR sky130_fd_sc_hd__decap_4
XFILLER_0_26_253 VGND VGND VPWR VPWR sky130_fd_sc_hd__fill_1
X_16368_ clknet_leaf_2_clk _00950_ VGND VGND VPWR VPWR is_alu_reg_reg sky130_fd_sc_hd__dfxtp_1
XFILLER_0_5_169 VGND VGND VPWR VPWR sky130_fd_sc_hd__decap_3
X_15319_ _03472_ net1341 _02041_ VGND VGND VPWR VPWR _02046_ sky130_fd_sc_hd__mux2_1
XFILLER_0_26_297 VGND VGND VPWR VPWR sky130_fd_sc_hd__decap_3
XFILLER_0_42_757 VGND VGND VPWR VPWR sky130_fd_sc_hd__fill_2
XFILLER_0_111_111 VGND VGND VPWR VPWR sky130_fd_sc_hd__fill_1
XFILLER_0_75_7 VGND VGND VPWR VPWR sky130_fd_sc_hd__fill_2
Xclkbuf_leaf_120_clk clknet_4_10_0_clk VGND VGND VPWR VPWR clknet_leaf_120_clk sky130_fd_sc_hd__clkbuf_16
X_16299_ clknet_leaf_3_clk _00884_ VGND VGND VPWR VPWR instr_rdinstrh sky130_fd_sc_hd__dfxtp_2
X_09811_ _03722_ _04039_ _03674_ VGND VGND VPWR VPWR _04040_ sky130_fd_sc_hd__a21o_1
X_09742_ _03863_ _03965_ _03972_ VGND VGND VPWR VPWR _03973_ sky130_fd_sc_hd__or3_2
X_09673_ _03663_ _03896_ _03905_ _03685_ VGND VGND VPWR VPWR _03906_ sky130_fd_sc_hd__o211a_1
XTAP_2009 VGND VPWR sky130_fd_sc_hd__tapvpwrvgnd_1
X_08624_ net207 _02991_ VGND VGND VPWR VPWR _02992_ sky130_fd_sc_hd__xor2_1
X_08555_ _02663_ _02920_ _02928_ _02849_ VGND VGND VPWR VPWR alu_out\[7\] sky130_fd_sc_hd__a22o_1
XTAP_1319 VGND VPWR sky130_fd_sc_hd__tapvpwrvgnd_1
XTAP_1308 VGND VPWR sky130_fd_sc_hd__tapvpwrvgnd_1
XFILLER_0_119_222 VGND VGND VPWR VPWR sky130_fd_sc_hd__fill_2
XFILLER_0_76_186 VGND VGND VPWR VPWR sky130_fd_sc_hd__decap_8
X_08486_ _02755_ _02854_ _02853_ VGND VGND VPWR VPWR _02865_ sky130_fd_sc_hd__a21o_1
XFILLER_0_91_145 VGND VGND VPWR VPWR sky130_fd_sc_hd__decap_8
XFILLER_0_91_134 VGND VGND VPWR VPWR sky130_fd_sc_hd__decap_4
XFILLER_0_80_808 VGND VGND VPWR VPWR sky130_fd_sc_hd__decap_4
XFILLER_0_72_381 VGND VGND VPWR VPWR sky130_fd_sc_hd__fill_1
X_09107_ _03324_ _03386_ _00009_ VGND VGND VPWR VPWR _03387_ sky130_fd_sc_hd__a21o_1
Xclkbuf_leaf_111_clk clknet_4_11_0_clk VGND VGND VPWR VPWR clknet_leaf_111_clk sky130_fd_sc_hd__clkbuf_16
X_09038_ cpuregs\[0\]\[2\] cpuregs\[1\]\[2\] cpuregs\[2\]\[2\] cpuregs\[3\]\[2\] _03313_
+ _03314_ VGND VGND VPWR VPWR _03319_ sky130_fd_sc_hd__mux4_1
Xhold360 cpuregs\[28\]\[22\] VGND VGND VPWR VPWR net718 sky130_fd_sc_hd__dlygate4sd3_1
Xhold371 cpuregs\[7\]\[2\] VGND VGND VPWR VPWR net729 sky130_fd_sc_hd__dlygate4sd3_1
X_11000_ _05041_ net1140 _05074_ VGND VGND VPWR VPWR _05082_ sky130_fd_sc_hd__mux2_1
Xhold382 cpuregs\[28\]\[31\] VGND VGND VPWR VPWR net740 sky130_fd_sc_hd__dlygate4sd3_1
Xhold393 cpuregs\[20\]\[9\] VGND VGND VPWR VPWR net751 sky130_fd_sc_hd__dlygate4sd3_1
Xhold1060 cpuregs\[8\]\[31\] VGND VGND VPWR VPWR net1418 sky130_fd_sc_hd__dlygate4sd3_1
X_12951_ cpuregs\[16\]\[5\] cpuregs\[17\]\[5\] cpuregs\[18\]\[5\] cpuregs\[19\]\[5\]
+ _06443_ _06444_ VGND VGND VPWR VPWR _06445_ sky130_fd_sc_hd__mux4_1
X_15670_ clknet_leaf_68_clk _00320_ VGND VGND VPWR VPWR cpuregs\[14\]\[28\] sky130_fd_sc_hd__dfxtp_1
Xhold1082 cpuregs\[13\]\[29\] VGND VGND VPWR VPWR net1440 sky130_fd_sc_hd__dlygate4sd3_1
Xhold1071 cpuregs\[21\]\[0\] VGND VGND VPWR VPWR net1429 sky130_fd_sc_hd__dlygate4sd3_1
X_12882_ cpuregs\[0\]\[1\] cpuregs\[1\]\[1\] cpuregs\[2\]\[1\] cpuregs\[3\]\[1\] _03323_
+ _03325_ VGND VGND VPWR VPWR _06380_ sky130_fd_sc_hd__mux4_1
X_11902_ _05539_ _05597_ VGND VGND VPWR VPWR _05598_ sky130_fd_sc_hd__nor2_1
Xhold1093 cpuregs\[6\]\[5\] VGND VGND VPWR VPWR net1451 sky130_fd_sc_hd__dlygate4sd3_1
X_14621_ _01677_ VGND VGND VPWR VPWR _01183_ sky130_fd_sc_hd__clkbuf_1
X_11833_ count_instr\[8\] _05542_ count_instr\[9\] VGND VGND VPWR VPWR _05548_ sky130_fd_sc_hd__a21o_1
XFILLER_0_114_29 VGND VGND VPWR VPWR sky130_fd_sc_hd__fill_2
XTAP_1831 VGND VPWR sky130_fd_sc_hd__tapvpwrvgnd_1
XTAP_1842 VGND VPWR sky130_fd_sc_hd__tapvpwrvgnd_1
XTAP_1820 VGND VPWR sky130_fd_sc_hd__tapvpwrvgnd_1
XFILLER_0_68_643 VGND VGND VPWR VPWR sky130_fd_sc_hd__fill_1
XFILLER_0_138_542 VGND VGND VPWR VPWR sky130_fd_sc_hd__fill_1
X_14552_ net1541 _05215_ _01634_ VGND VGND VPWR VPWR _01641_ sky130_fd_sc_hd__mux2_1
XTAP_1875 VGND VPWR sky130_fd_sc_hd__tapvpwrvgnd_1
XTAP_1864 VGND VPWR sky130_fd_sc_hd__tapvpwrvgnd_1
XTAP_1853 VGND VPWR sky130_fd_sc_hd__tapvpwrvgnd_1
X_11764_ _05022_ net1172 _05494_ VGND VGND VPWR VPWR _05503_ sky130_fd_sc_hd__mux2_1
XFILLER_0_95_495 VGND VGND VPWR VPWR sky130_fd_sc_hd__fill_1
XFILLER_0_83_602 VGND VGND VPWR VPWR sky130_fd_sc_hd__decap_4
X_14483_ _01604_ VGND VGND VPWR VPWR _01086_ sky130_fd_sc_hd__clkbuf_1
X_13503_ _06849_ _06980_ VGND VGND VPWR VPWR _06981_ sky130_fd_sc_hd__or2_1
XTAP_1897 VGND VPWR sky130_fd_sc_hd__tapvpwrvgnd_1
XTAP_1886 VGND VPWR sky130_fd_sc_hd__tapvpwrvgnd_1
X_11695_ _05466_ VGND VGND VPWR VPWR _00533_ sky130_fd_sc_hd__clkbuf_1
XFILLER_0_55_337 VGND VGND VPWR VPWR sky130_fd_sc_hd__fill_1
X_10715_ net750 _03484_ _04907_ VGND VGND VPWR VPWR _04914_ sky130_fd_sc_hd__mux2_1
X_10646_ cpuregs\[22\]\[29\] cpuregs\[23\]\[29\] _03801_ VGND VGND VPWR VPWR _04853_
+ sky130_fd_sc_hd__mux2_1
X_13434_ _06638_ _06908_ _06910_ _06739_ _06913_ VGND VGND VPWR VPWR _06914_ sky130_fd_sc_hd__o311a_1
X_16222_ clknet_leaf_13_clk _00839_ VGND VGND VPWR VPWR latched_stalu sky130_fd_sc_hd__dfxtp_2
XFILLER_0_24_713 VGND VGND VPWR VPWR sky130_fd_sc_hd__decap_4
XFILLER_0_125_258 VGND VGND VPWR VPWR sky130_fd_sc_hd__fill_2
X_16153_ clknet_leaf_35_clk _07642_ VGND VGND VPWR VPWR reg_out\[31\] sky130_fd_sc_hd__dfxtp_1
XFILLER_0_113_409 VGND VGND VPWR VPWR sky130_fd_sc_hd__fill_2
Xrebuffer5 net364 VGND VGND VPWR VPWR net363 sky130_fd_sc_hd__clkbuf_1
XFILLER_0_36_584 VGND VGND VPWR VPWR sky130_fd_sc_hd__decap_4
X_10577_ _04785_ _02605_ _04509_ VGND VGND VPWR VPWR _04786_ sky130_fd_sc_hd__mux2_1
X_15104_ _01933_ VGND VGND VPWR VPWR _01410_ sky130_fd_sc_hd__clkbuf_1
X_13365_ _06638_ _06841_ _06844_ _06739_ _06846_ VGND VGND VPWR VPWR _06847_ sky130_fd_sc_hd__o311a_1
Xclkbuf_leaf_102_clk clknet_4_11_0_clk VGND VGND VPWR VPWR clknet_leaf_102_clk sky130_fd_sc_hd__clkbuf_16
XFILLER_0_23_245 VGND VGND VPWR VPWR sky130_fd_sc_hd__fill_1
XFILLER_0_24_757 VGND VGND VPWR VPWR sky130_fd_sc_hd__decap_3
XFILLER_0_121_431 VGND VGND VPWR VPWR sky130_fd_sc_hd__decap_4
X_13296_ _06377_ VGND VGND VPWR VPWR _06780_ sky130_fd_sc_hd__clkbuf_4
X_12316_ _05723_ _05920_ VGND VGND VPWR VPWR _05931_ sky130_fd_sc_hd__nor2_1
X_16084_ clknet_leaf_1_clk net454 VGND VGND VPWR VPWR count_cycle\[27\] sky130_fd_sc_hd__dfxtp_1
X_15035_ _03635_ net1393 _01887_ VGND VGND VPWR VPWR _01897_ sky130_fd_sc_hd__mux2_1
X_12247_ _05704_ _05706_ _05708_ _05812_ VGND VGND VPWR VPWR _05867_ sky130_fd_sc_hd__nand4_1
X_12178_ _05741_ net431 _05725_ _05803_ VGND VGND VPWR VPWR _00679_ sky130_fd_sc_hd__o211a_1
X_11129_ _05150_ VGND VGND VPWR VPWR _00283_ sky130_fd_sc_hd__clkbuf_1
XFILLER_0_3_15 VPWR VGND VPWR VGND sky130_ef_sc_hd__decap_12
X_15937_ clknet_leaf_147_clk _00587_ VGND VGND VPWR VPWR count_instr\[6\] sky130_fd_sc_hd__dfxtp_1
X_15868_ clknet_leaf_132_clk _00518_ VGND VGND VPWR VPWR cpuregs\[20\]\[2\] sky130_fd_sc_hd__dfxtp_1
X_14819_ _01782_ VGND VGND VPWR VPWR _01276_ sky130_fd_sc_hd__clkbuf_1
X_15799_ clknet_leaf_64_clk _00449_ VGND VGND VPWR VPWR cpuregs\[26\]\[29\] sky130_fd_sc_hd__dfxtp_1
X_08340_ _02711_ _02712_ _02715_ _02720_ VGND VGND VPWR VPWR _02721_ sky130_fd_sc_hd__a211o_1
X_08271_ net195 VGND VGND VPWR VPWR _02653_ sky130_fd_sc_hd__clkbuf_4
XFILLER_0_73_167 VGND VGND VPWR VPWR sky130_fd_sc_hd__fill_1
XFILLER_0_66_3 VGND VGND VPWR VPWR sky130_fd_sc_hd__decap_6
X_07986_ _02385_ _02386_ VGND VGND VPWR VPWR _02387_ sky130_fd_sc_hd__nand2_2
X_09725_ _03954_ _03955_ VGND VGND VPWR VPWR _03956_ sky130_fd_sc_hd__and2b_1
X_09656_ cpuregs\[22\]\[3\] cpuregs\[23\]\[3\] _03756_ VGND VGND VPWR VPWR _03889_
+ sky130_fd_sc_hd__mux2_1
XFILLER_0_96_226 VGND VGND VPWR VPWR sky130_fd_sc_hd__fill_1
X_08607_ net174 _02973_ _02974_ VGND VGND VPWR VPWR _02976_ sky130_fd_sc_hd__or3_1
XTAP_1105 VGND VPWR sky130_fd_sc_hd__tapvpwrvgnd_1
XTAP_1138 VGND VPWR sky130_fd_sc_hd__tapvpwrvgnd_1
XTAP_1127 VGND VPWR sky130_fd_sc_hd__tapvpwrvgnd_1
XTAP_1116 VGND VPWR sky130_fd_sc_hd__tapvpwrvgnd_1
X_09587_ cpuregs\[16\]\[2\] cpuregs\[17\]\[2\] cpuregs\[18\]\[2\] cpuregs\[19\]\[2\]
+ _03819_ _03820_ VGND VGND VPWR VPWR _03821_ sky130_fd_sc_hd__mux4_1
X_08538_ _02906_ _02912_ VGND VGND VPWR VPWR _02913_ sky130_fd_sc_hd__or2_1
XTAP_1149 VGND VPWR sky130_fd_sc_hd__tapvpwrvgnd_1
XFILLER_0_92_421 VGND VGND VPWR VPWR sky130_fd_sc_hd__fill_1
X_08469_ net240 VGND VGND VPWR VPWR _02849_ sky130_fd_sc_hd__clkbuf_4
XFILLER_0_9_250 VGND VGND VPWR VPWR sky130_fd_sc_hd__decap_4
X_10500_ cpuregs\[30\]\[25\] cpuregs\[31\]\[25\] _03881_ VGND VGND VPWR VPWR _04711_
+ sky130_fd_sc_hd__mux2_1
XFILLER_0_107_225 VGND VGND VPWR VPWR sky130_fd_sc_hd__decap_6
XFILLER_0_107_214 VGND VGND VPWR VPWR sky130_fd_sc_hd__decap_8
XFILLER_0_65_679 VGND VGND VPWR VPWR sky130_fd_sc_hd__fill_2
XFILLER_0_107_269 VGND VGND VPWR VPWR sky130_fd_sc_hd__decap_3
X_11480_ _05352_ VGND VGND VPWR VPWR _00432_ sky130_fd_sc_hd__clkbuf_1
X_10431_ _03780_ _04616_ _04643_ _03793_ VGND VGND VPWR VPWR _04644_ sky130_fd_sc_hd__a22o_1
X_10362_ _04576_ _02522_ _04509_ VGND VGND VPWR VPWR _04577_ sky130_fd_sc_hd__mux2_1
X_13150_ _03311_ VGND VGND VPWR VPWR _06638_ sky130_fd_sc_hd__buf_4
XFILLER_0_60_362 VGND VGND VPWR VPWR sky130_fd_sc_hd__fill_2
X_12101_ _05735_ _05739_ _05740_ _05730_ VGND VGND VPWR VPWR _00665_ sky130_fd_sc_hd__o211a_1
X_10293_ _04508_ _02493_ _04509_ VGND VGND VPWR VPWR _04510_ sky130_fd_sc_hd__mux2_1
X_13081_ cpuregs\[10\]\[9\] cpuregs\[11\]\[9\] _06424_ VGND VGND VPWR VPWR _06571_
+ sky130_fd_sc_hd__mux2_1
X_12032_ _05688_ _05689_ _05691_ _02142_ VGND VGND VPWR VPWR _00645_ sky130_fd_sc_hd__o211a_1
Xhold190 net59 VGND VGND VPWR VPWR net548 sky130_fd_sc_hd__dlygate4sd3_1
X_16840_ clknet_leaf_74_clk _01404_ VGND VGND VPWR VPWR cpuregs\[7\]\[23\] sky130_fd_sc_hd__dfxtp_1
X_16771_ clknet_leaf_85_clk _01335_ VGND VGND VPWR VPWR cpuregs\[5\]\[18\] sky130_fd_sc_hd__dfxtp_1
X_13983_ _07377_ _07401_ VGND VGND VPWR VPWR _07402_ sky130_fd_sc_hd__and2_1
X_15722_ clknet_leaf_54_clk _00372_ VGND VGND VPWR VPWR cpuregs\[21\]\[16\] sky130_fd_sc_hd__dfxtp_1
X_12934_ _03332_ VGND VGND VPWR VPWR _06428_ sky130_fd_sc_hd__clkbuf_8
XFILLER_0_125_39 VGND VGND VPWR VPWR sky130_fd_sc_hd__fill_1
XTAP_2351 VGND VPWR sky130_fd_sc_hd__tapvpwrvgnd_1
XTAP_2340 VGND VPWR sky130_fd_sc_hd__tapvpwrvgnd_1
X_15653_ clknet_leaf_100_clk _00303_ VGND VGND VPWR VPWR cpuregs\[14\]\[11\] sky130_fd_sc_hd__dfxtp_1
X_12865_ _03322_ VGND VGND VPWR VPWR _06364_ sky130_fd_sc_hd__clkbuf_8
X_12796_ _06312_ VGND VGND VPWR VPWR _00788_ sky130_fd_sc_hd__clkbuf_1
X_14604_ _01668_ VGND VGND VPWR VPWR _01175_ sky130_fd_sc_hd__clkbuf_1
XTAP_1650 VGND VPWR sky130_fd_sc_hd__tapvpwrvgnd_1
X_15584_ clknet_leaf_127_clk _00234_ VGND VGND VPWR VPWR cpuregs\[28\]\[6\] sky130_fd_sc_hd__dfxtp_1
X_11816_ count_instr\[5\] count_instr\[4\] VGND VGND VPWR VPWR _05535_ sky130_fd_sc_hd__and2_1
XTAP_1694 VGND VPWR sky130_fd_sc_hd__tapvpwrvgnd_1
XTAP_1683 VGND VPWR sky130_fd_sc_hd__tapvpwrvgnd_1
XTAP_1672 VGND VPWR sky130_fd_sc_hd__tapvpwrvgnd_1
XTAP_1661 VGND VPWR sky130_fd_sc_hd__tapvpwrvgnd_1
X_11747_ _05482_ VGND VGND VPWR VPWR _05494_ sky130_fd_sc_hd__buf_4
X_14535_ net1060 _05198_ _01623_ VGND VGND VPWR VPWR _01632_ sky130_fd_sc_hd__mux2_1
XFILLER_0_126_512 VGND VGND VPWR VPWR sky130_fd_sc_hd__fill_1
XFILLER_0_28_359 VGND VGND VPWR VPWR sky130_fd_sc_hd__fill_2
X_16205_ clknet_leaf_40_clk _00822_ VGND VGND VPWR VPWR net210 sky130_fd_sc_hd__dfxtp_1
X_14466_ _01595_ VGND VGND VPWR VPWR _01078_ sky130_fd_sc_hd__clkbuf_1
XFILLER_0_52_830 VGND VGND VPWR VPWR sky130_fd_sc_hd__fill_2
X_11678_ _05457_ VGND VGND VPWR VPWR _00525_ sky130_fd_sc_hd__clkbuf_1
X_10629_ _03150_ _03845_ _03364_ VGND VGND VPWR VPWR _04836_ sky130_fd_sc_hd__a21o_1
X_13417_ _06762_ _06882_ _06897_ _06802_ decoded_imm\[18\] VGND VGND VPWR VPWR _06898_
+ sky130_fd_sc_hd__a32o_1
X_14397_ _05020_ net1191 _01551_ VGND VGND VPWR VPWR _01559_ sky130_fd_sc_hd__mux2_1
Xpicorv32_326 VGND VGND VPWR VPWR picorv32_326/HI trace_data[4] sky130_fd_sc_hd__conb_1
Xpicorv32_304 VGND VGND VPWR VPWR picorv32_304/HI pcpi_insn[15] sky130_fd_sc_hd__conb_1
Xpicorv32_315 VGND VGND VPWR VPWR picorv32_315/HI pcpi_insn[26] sky130_fd_sc_hd__conb_1
X_13348_ _06780_ _06820_ _06824_ _06830_ _06800_ VGND VGND VPWR VPWR _06831_ sky130_fd_sc_hd__a311o_1
X_16136_ clknet_leaf_23_clk _07623_ VGND VGND VPWR VPWR reg_out\[14\] sky130_fd_sc_hd__dfxtp_1
XFILLER_0_24_587 VGND VGND VPWR VPWR sky130_fd_sc_hd__fill_1
Xpicorv32_348 VGND VGND VPWR VPWR picorv32_348/HI trace_data[26] sky130_fd_sc_hd__conb_1
Xpicorv32_337 VGND VGND VPWR VPWR picorv32_337/HI trace_data[15] sky130_fd_sc_hd__conb_1
X_16067_ clknet_leaf_147_clk _00717_ VGND VGND VPWR VPWR count_cycle\[10\] sky130_fd_sc_hd__dfxtp_1
XFILLER_0_121_272 VGND VGND VPWR VPWR sky130_fd_sc_hd__fill_1
X_15018_ _01888_ VGND VGND VPWR VPWR _01369_ sky130_fd_sc_hd__clkbuf_1
X_13279_ cpuregs\[12\]\[15\] cpuregs\[13\]\[15\] cpuregs\[14\]\[15\] cpuregs\[15\]\[15\]
+ _06696_ _06728_ VGND VGND VPWR VPWR _06763_ sky130_fd_sc_hd__mux4_1
X_07840_ count_instr\[2\] instr_rdinstr count_cycle\[2\] _02173_ _02250_ VGND VGND
+ VPWR VPWR _02251_ sky130_fd_sc_hd__a221o_1
XFILLER_0_75_77 VGND VGND VPWR VPWR sky130_fd_sc_hd__decap_8
X_07771_ _02096_ _02093_ _02099_ instr_sh VGND VGND VPWR VPWR _02188_ sky130_fd_sc_hd__a22o_1
X_16969_ clknet_leaf_81_clk _01533_ VGND VGND VPWR VPWR cpuregs\[10\]\[24\] sky130_fd_sc_hd__dfxtp_1
X_09510_ _03720_ _03743_ _03744_ VGND VGND VPWR VPWR _03745_ sky130_fd_sc_hd__o21ai_1
XFILLER_0_79_727 VGND VGND VPWR VPWR sky130_fd_sc_hd__fill_1
XFILLER_0_78_226 VGND VGND VPWR VPWR sky130_fd_sc_hd__fill_1
XFILLER_0_91_54 VGND VGND VPWR VPWR sky130_fd_sc_hd__fill_2
X_09441_ _03676_ VGND VGND VPWR VPWR _03677_ sky130_fd_sc_hd__buf_4
X_09372_ reg_out\[26\] alu_out_q\[26\] _03437_ VGND VGND VPWR VPWR _03614_ sky130_fd_sc_hd__mux2_1
XFILLER_0_59_473 VGND VGND VPWR VPWR sky130_fd_sc_hd__fill_1
X_08323_ net185 net217 VGND VGND VPWR VPWR _02704_ sky130_fd_sc_hd__or2_1
XFILLER_0_19_326 VGND VGND VPWR VPWR sky130_fd_sc_hd__fill_1
XFILLER_0_24_70 VGND VGND VPWR VPWR sky130_fd_sc_hd__fill_2
XFILLER_0_62_605 VGND VGND VPWR VPWR sky130_fd_sc_hd__fill_1
XFILLER_0_34_307 VGND VGND VPWR VPWR sky130_fd_sc_hd__fill_1
XFILLER_0_105_707 VGND VGND VPWR VPWR sky130_fd_sc_hd__fill_1
X_08254_ count_instr\[30\] _02270_ count_cycle\[62\] _02204_ VGND VGND VPWR VPWR _02637_
+ sky130_fd_sc_hd__a22o_1
X_08185_ reg_pc\[25\] decoded_imm\[25\] VGND VGND VPWR VPWR _02573_ sky130_fd_sc_hd__nor2_1
XFILLER_0_105_729 VGND VGND VPWR VPWR sky130_fd_sc_hd__decap_3
XFILLER_0_112_283 VGND VGND VPWR VPWR sky130_fd_sc_hd__decap_4
XFILLER_0_100_467 VGND VGND VPWR VPWR sky130_fd_sc_hd__fill_1
XFILLER_0_11_782 VGND VGND VPWR VPWR sky130_fd_sc_hd__fill_2
X_07969_ count_instr\[43\] _02269_ _02235_ _02370_ VGND VGND VPWR VPWR _02371_ sky130_fd_sc_hd__a211o_1
X_09708_ cpuregs\[8\]\[4\] cpuregs\[9\]\[4\] cpuregs\[10\]\[4\] cpuregs\[11\]\[4\]
+ _03938_ _03939_ VGND VGND VPWR VPWR _03940_ sky130_fd_sc_hd__mux4_1
X_10980_ _05071_ VGND VGND VPWR VPWR _00213_ sky130_fd_sc_hd__clkbuf_1
XFILLER_0_69_237 VGND VGND VPWR VPWR sky130_fd_sc_hd__decap_3
X_09639_ _03696_ _03867_ _03871_ VGND VGND VPWR VPWR _03872_ sky130_fd_sc_hd__a21o_1
XFILLER_0_139_125 VPWR VGND VPWR VGND sky130_ef_sc_hd__decap_12
X_12650_ net1488 _06200_ _06203_ VGND VGND VPWR VPWR _00751_ sky130_fd_sc_hd__o21a_1
XFILLER_0_38_613 VGND VGND VPWR VPWR sky130_fd_sc_hd__fill_1
XFILLER_0_139_169 VGND VGND VPWR VPWR sky130_fd_sc_hd__fill_2
XFILLER_0_127_309 VGND VGND VPWR VPWR sky130_fd_sc_hd__fill_1
XFILLER_0_77_281 VGND VGND VPWR VPWR sky130_fd_sc_hd__decap_3
X_11601_ _04995_ net690 _05411_ VGND VGND VPWR VPWR _05417_ sky130_fd_sc_hd__mux2_1
XFILLER_0_92_240 VGND VGND VPWR VPWR sky130_fd_sc_hd__decap_3
X_14320_ net859 _07587_ _07590_ _07592_ VGND VGND VPWR VPWR _01011_ sky130_fd_sc_hd__o22a_1
X_12581_ count_cycle\[23\] count_cycle\[24\] _06150_ _05631_ VGND VGND VPWR VPWR _06155_
+ sky130_fd_sc_hd__a31o_1
X_11532_ _05380_ VGND VGND VPWR VPWR _00456_ sky130_fd_sc_hd__clkbuf_1
X_14251_ net535 net118 _07541_ VGND VGND VPWR VPWR _07551_ sky130_fd_sc_hd__mux2_1
X_11463_ _05343_ VGND VGND VPWR VPWR _00424_ sky130_fd_sc_hd__clkbuf_1
X_10414_ _04127_ _04624_ _04626_ VGND VGND VPWR VPWR _04627_ sky130_fd_sc_hd__a21o_1
X_13202_ cpuregs\[30\]\[12\] cpuregs\[31\]\[12\] _06462_ VGND VGND VPWR VPWR _06689_
+ sky130_fd_sc_hd__mux2_1
XFILLER_0_21_502 VGND VGND VPWR VPWR sky130_fd_sc_hd__fill_2
X_14182_ _03294_ _02086_ net235 VGND VGND VPWR VPWR _07513_ sky130_fd_sc_hd__a21oi_1
XFILLER_0_103_250 VGND VGND VPWR VPWR sky130_fd_sc_hd__decap_4
XFILLER_0_60_181 VGND VGND VPWR VPWR sky130_fd_sc_hd__fill_2
X_13133_ cpuregs\[28\]\[10\] cpuregs\[29\]\[10\] _06349_ VGND VGND VPWR VPWR _06622_
+ sky130_fd_sc_hd__mux2_1
X_11394_ net1293 _05169_ _05302_ VGND VGND VPWR VPWR _05307_ sky130_fd_sc_hd__mux2_1
X_10345_ _03795_ _04553_ _04559_ VGND VGND VPWR VPWR _04560_ sky130_fd_sc_hd__or3_2
XFILLER_0_103_294 VGND VGND VPWR VPWR sky130_fd_sc_hd__decap_4
X_10276_ cpuregs\[16\]\[19\] cpuregs\[17\]\[19\] cpuregs\[18\]\[19\] cpuregs\[19\]\[19\]
+ _04192_ _03719_ VGND VGND VPWR VPWR _04493_ sky130_fd_sc_hd__mux4_1
X_13064_ cpuregs\[22\]\[8\] cpuregs\[23\]\[8\] _06450_ VGND VGND VPWR VPWR _06555_
+ sky130_fd_sc_hd__mux2_1
XTAP_708 VGND VPWR sky130_fd_sc_hd__tapvpwrvgnd_1
XTAP_719 VGND VPWR sky130_fd_sc_hd__tapvpwrvgnd_1
X_12015_ count_instr\[60\] _05677_ _05640_ VGND VGND VPWR VPWR _05679_ sky130_fd_sc_hd__a21oi_1
X_16823_ clknet_leaf_117_clk _01387_ VGND VGND VPWR VPWR cpuregs\[7\]\[6\] sky130_fd_sc_hd__dfxtp_1
XFILLER_0_45_36 VGND VGND VPWR VPWR sky130_fd_sc_hd__fill_1
X_16754_ clknet_leaf_119_clk _01318_ VGND VGND VPWR VPWR cpuregs\[5\]\[1\] sky130_fd_sc_hd__dfxtp_1
X_13966_ _07390_ VGND VGND VPWR VPWR _00871_ sky130_fd_sc_hd__clkbuf_1
X_16685_ clknet_leaf_95_clk _01252_ VGND VGND VPWR VPWR cpuregs\[29\]\[31\] sky130_fd_sc_hd__dfxtp_1
X_15705_ clknet_leaf_97_clk _00355_ VGND VGND VPWR VPWR cpuregs\[27\]\[31\] sky130_fd_sc_hd__dfxtp_1
X_13897_ _07345_ VGND VGND VPWR VPWR _00850_ sky130_fd_sc_hd__clkbuf_1
X_12917_ decoded_imm\[4\] _03419_ _02171_ VGND VGND VPWR VPWR _06412_ sky130_fd_sc_hd__mux2_1
XTAP_2170 VGND VPWR sky130_fd_sc_hd__tapvpwrvgnd_1
X_15636_ clknet_leaf_61_clk _00286_ VGND VGND VPWR VPWR cpuregs\[31\]\[26\] sky130_fd_sc_hd__dfxtp_1
XFILLER_0_0_49 VGND VGND VPWR VPWR sky130_fd_sc_hd__decap_3
X_12848_ _06343_ _06346_ VGND VGND VPWR VPWR _06347_ sky130_fd_sc_hd__or2_1
XTAP_2192 VGND VPWR sky130_fd_sc_hd__tapvpwrvgnd_1
XTAP_2181 VGND VPWR sky130_fd_sc_hd__tapvpwrvgnd_1
XFILLER_0_118_309 VGND VGND VPWR VPWR sky130_fd_sc_hd__fill_1
XFILLER_0_75_229 VGND VGND VPWR VPWR sky130_fd_sc_hd__fill_1
XFILLER_0_61_57 VGND VGND VPWR VPWR sky130_fd_sc_hd__decap_4
XFILLER_0_61_35 VGND VGND VPWR VPWR sky130_fd_sc_hd__fill_1
XFILLER_0_29_635 VGND VGND VPWR VPWR sky130_fd_sc_hd__fill_1
X_15567_ clknet_leaf_74_clk _00217_ VGND VGND VPWR VPWR cpuregs\[2\]\[21\] sky130_fd_sc_hd__dfxtp_1
XTAP_1491 VGND VPWR sky130_fd_sc_hd__tapvpwrvgnd_1
XTAP_1480 VGND VPWR sky130_fd_sc_hd__tapvpwrvgnd_1
X_12779_ net582 net66 _06302_ VGND VGND VPWR VPWR _06304_ sky130_fd_sc_hd__mux2_1
X_14518_ _01611_ VGND VGND VPWR VPWR _01623_ sky130_fd_sc_hd__buf_4
X_15498_ clknet_leaf_95_clk _00148_ VGND VGND VPWR VPWR cpuregs\[30\]\[16\] sky130_fd_sc_hd__dfxtp_1
XFILLER_0_71_457 VGND VGND VPWR VPWR sky130_fd_sc_hd__decap_6
XFILLER_0_9_69 VGND VGND VPWR VPWR sky130_fd_sc_hd__fill_1
XFILLER_0_25_830 VGND VGND VPWR VPWR sky130_fd_sc_hd__fill_2
X_14449_ _01586_ VGND VGND VPWR VPWR _01070_ sky130_fd_sc_hd__clkbuf_1
Xhold904 cpuregs\[5\]\[26\] VGND VGND VPWR VPWR net1262 sky130_fd_sc_hd__dlygate4sd3_1
XFILLER_0_4_757 VPWR VGND VPWR VGND sky130_ef_sc_hd__decap_12
XFILLER_0_24_362 VGND VGND VPWR VPWR sky130_fd_sc_hd__fill_2
Xhold926 cpuregs\[16\]\[25\] VGND VGND VPWR VPWR net1284 sky130_fd_sc_hd__dlygate4sd3_1
Xhold915 cpuregs\[13\]\[26\] VGND VGND VPWR VPWR net1273 sky130_fd_sc_hd__dlygate4sd3_1
Xhold937 cpuregs\[21\]\[17\] VGND VGND VPWR VPWR net1295 sky130_fd_sc_hd__dlygate4sd3_1
XFILLER_0_3_278 VGND VGND VPWR VPWR sky130_fd_sc_hd__fill_2
X_16119_ clknet_leaf_0_clk _00769_ VGND VGND VPWR VPWR count_cycle\[62\] sky130_fd_sc_hd__dfxtp_1
Xhold948 cpuregs\[4\]\[29\] VGND VGND VPWR VPWR net1306 sky130_fd_sc_hd__dlygate4sd3_1
XFILLER_0_110_721 VGND VGND VPWR VPWR sky130_fd_sc_hd__decap_6
XFILLER_0_86_21 VGND VGND VPWR VPWR sky130_fd_sc_hd__fill_2
X_09990_ cpuregs\[30\]\[11\] cpuregs\[31\]\[11\] _04194_ VGND VGND VPWR VPWR _04215_
+ sky130_fd_sc_hd__mux2_1
XFILLER_0_10_83 VGND VGND VPWR VPWR sky130_fd_sc_hd__fill_1
Xhold959 cpuregs\[2\]\[13\] VGND VGND VPWR VPWR net1317 sky130_fd_sc_hd__dlygate4sd3_1
X_08941_ _02403_ _03251_ _03246_ VGND VGND VPWR VPWR _03252_ sky130_fd_sc_hd__mux2_1
XFILLER_0_86_43 VGND VGND VPWR VPWR sky130_fd_sc_hd__decap_3
X_08872_ _02688_ _03204_ _03211_ VGND VGND VPWR VPWR net102 sky130_fd_sc_hd__a21o_1
X_07823_ _02234_ VGND VGND VPWR VPWR _02235_ sky130_fd_sc_hd__clkbuf_4
X_07754_ instr_rdcycleh instr_rdinstr instr_rdinstrh VGND VGND VPWR VPWR _02173_ sky130_fd_sc_hd__nor3_4
X_07685_ _02084_ _02113_ VGND VGND VPWR VPWR net96 sky130_fd_sc_hd__nor2_4
Xclkbuf_leaf_91_clk clknet_4_14_0_clk VGND VGND VPWR VPWR clknet_leaf_91_clk sky130_fd_sc_hd__clkbuf_16
X_09424_ _03659_ VGND VGND VPWR VPWR _03660_ sky130_fd_sc_hd__buf_4
XFILLER_0_136_139 VGND VGND VPWR VPWR sky130_fd_sc_hd__fill_1
X_09355_ reg_out\[24\] alu_out_q\[24\] _03437_ VGND VGND VPWR VPWR _03599_ sky130_fd_sc_hd__mux2_1
XFILLER_0_74_251 VGND VGND VPWR VPWR sky130_fd_sc_hd__fill_1
XFILLER_0_19_156 VGND VGND VPWR VPWR sky130_fd_sc_hd__fill_2
X_08306_ _02391_ _02685_ VGND VGND VPWR VPWR _02687_ sky130_fd_sc_hd__nand2_1
X_09286_ _03539_ VGND VGND VPWR VPWR _00051_ sky130_fd_sc_hd__clkbuf_1
X_08237_ _02221_ _02465_ _02620_ _02160_ _02621_ VGND VGND VPWR VPWR _02622_ sky130_fd_sc_hd__a32o_1
XFILLER_0_62_457 VGND VGND VPWR VPWR sky130_fd_sc_hd__decap_3
XFILLER_0_62_446 VGND VGND VPWR VPWR sky130_fd_sc_hd__fill_2
XFILLER_0_15_351 VGND VGND VPWR VPWR sky130_fd_sc_hd__fill_1
XFILLER_0_43_671 VGND VGND VPWR VPWR sky130_fd_sc_hd__fill_1
X_08168_ _02498_ _02519_ _02556_ VGND VGND VPWR VPWR _02557_ sky130_fd_sc_hd__or3_1
X_08099_ net181 VGND VGND VPWR VPWR _02493_ sky130_fd_sc_hd__clkbuf_4
XFILLER_0_100_231 VGND VGND VPWR VPWR sky130_fd_sc_hd__fill_2
X_10130_ cpuregs\[30\]\[15\] cpuregs\[31\]\[15\] _03835_ VGND VGND VPWR VPWR _04351_
+ sky130_fd_sc_hd__mux2_1
X_10061_ cpuregs\[30\]\[13\] cpuregs\[31\]\[13\] _03835_ VGND VGND VPWR VPWR _04284_
+ sky130_fd_sc_hd__mux2_1
X_13820_ _07287_ net227 _06374_ VGND VGND VPWR VPWR _07288_ sky130_fd_sc_hd__mux2_1
X_13751_ _06348_ _07218_ _07220_ _06417_ VGND VGND VPWR VPWR _07221_ sky130_fd_sc_hd__a211o_1
XFILLER_0_97_332 VGND VGND VPWR VPWR sky130_fd_sc_hd__fill_1
X_10963_ _05062_ VGND VGND VPWR VPWR _00205_ sky130_fd_sc_hd__clkbuf_1
X_16470_ clknet_leaf_43_clk _01052_ VGND VGND VPWR VPWR cpuregs\[18\]\[23\] sky130_fd_sc_hd__dfxtp_1
Xclkbuf_leaf_82_clk clknet_4_14_0_clk VGND VGND VPWR VPWR clknet_leaf_82_clk sky130_fd_sc_hd__clkbuf_16
XFILLER_0_85_505 VGND VGND VPWR VPWR sky130_fd_sc_hd__fill_1
X_12702_ _06240_ _06238_ _06241_ _06230_ _02164_ VGND VGND VPWR VPWR _00765_ sky130_fd_sc_hd__a221oi_1
X_13682_ cpuregs\[0\]\[27\] cpuregs\[1\]\[27\] cpuregs\[2\]\[27\] cpuregs\[3\]\[27\]
+ _06344_ _06345_ VGND VGND VPWR VPWR _07154_ sky130_fd_sc_hd__mux4_1
X_10894_ _05018_ net1309 _05006_ VGND VGND VPWR VPWR _05019_ sky130_fd_sc_hd__mux2_1
X_15421_ clknet_leaf_15_clk _00071_ VGND VGND VPWR VPWR net193 sky130_fd_sc_hd__dfxtp_2
XFILLER_0_122_29 VGND VGND VPWR VPWR sky130_fd_sc_hd__decap_8
XFILLER_0_122_18 VGND VGND VPWR VPWR sky130_fd_sc_hd__decap_8
XFILLER_0_109_810 VGND VGND VPWR VPWR sky130_fd_sc_hd__fill_1
X_12633_ count_cycle\[38\] count_cycle\[39\] net360 _02085_ VGND VGND VPWR VPWR _06192_
+ sky130_fd_sc_hd__a31o_1
X_15352_ _02040_ VGND VGND VPWR VPWR _02063_ sky130_fd_sc_hd__buf_4
X_12564_ count_cycle\[19\] _06139_ VGND VGND VPWR VPWR _06143_ sky130_fd_sc_hd__or2_1
XFILLER_0_135_150 VPWR VGND VPWR VGND sky130_ef_sc_hd__decap_12
X_11515_ _05370_ VGND VGND VPWR VPWR _00449_ sky130_fd_sc_hd__clkbuf_1
XFILLER_0_108_386 VGND VGND VPWR VPWR sky130_fd_sc_hd__fill_2
X_15283_ net459 VGND VGND VPWR VPWR _02027_ sky130_fd_sc_hd__clkbuf_1
X_14303_ net1630 _07576_ VGND VGND VPWR VPWR _07582_ sky130_fd_sc_hd__and2_1
X_12495_ _05761_ _06085_ VGND VGND VPWR VPWR _06094_ sky130_fd_sc_hd__xnor2_1
XFILLER_0_80_265 VGND VGND VPWR VPWR sky130_fd_sc_hd__fill_2
X_14234_ _07542_ VGND VGND VPWR VPWR _00975_ sky130_fd_sc_hd__clkbuf_1
XFILLER_0_123_367 VGND VGND VPWR VPWR sky130_fd_sc_hd__fill_1
X_11446_ net1170 _05221_ _05324_ VGND VGND VPWR VPWR _05334_ sky130_fd_sc_hd__mux2_1
XFILLER_0_21_321 VGND VGND VPWR VPWR sky130_fd_sc_hd__fill_1
X_14165_ _05045_ net1431 _07493_ VGND VGND VPWR VPWR _07503_ sky130_fd_sc_hd__mux2_1
X_11377_ _05297_ VGND VGND VPWR VPWR _00384_ sky130_fd_sc_hd__clkbuf_1
XFILLER_0_0_237 VGND VGND VPWR VPWR sky130_fd_sc_hd__fill_2
X_10328_ _04542_ VGND VGND VPWR VPWR _04543_ sky130_fd_sc_hd__inv_2
X_13116_ _06535_ _06600_ _06604_ _06542_ VGND VGND VPWR VPWR _06605_ sky130_fd_sc_hd__o211a_1
XTAP_505 VGND VPWR sky130_fd_sc_hd__tapvpwrvgnd_1
XTAP_516 VGND VPWR sky130_fd_sc_hd__tapvpwrvgnd_1
X_14096_ net568 _07459_ _07466_ VGND VGND VPWR VPWR _00913_ sky130_fd_sc_hd__o21a_1
XTAP_527 VGND VPWR sky130_fd_sc_hd__tapvpwrvgnd_1
XTAP_538 VGND VPWR sky130_fd_sc_hd__tapvpwrvgnd_1
XTAP_549 VGND VPWR sky130_fd_sc_hd__tapvpwrvgnd_1
X_13047_ cpuregs\[8\]\[8\] cpuregs\[9\]\[8\] _06422_ VGND VGND VPWR VPWR _06538_ sky130_fd_sc_hd__mux2_1
X_10259_ _04441_ _04444_ _04440_ VGND VGND VPWR VPWR _04476_ sky130_fd_sc_hd__a21boi_1
X_16806_ clknet_leaf_76_clk _01370_ VGND VGND VPWR VPWR cpuregs\[6\]\[21\] sky130_fd_sc_hd__dfxtp_1
X_16737_ clknet_leaf_86_clk _01301_ VGND VGND VPWR VPWR cpuregs\[4\]\[16\] sky130_fd_sc_hd__dfxtp_1
X_14998_ _03519_ net835 _01876_ VGND VGND VPWR VPWR _01878_ sky130_fd_sc_hd__mux2_1
Xclkbuf_leaf_73_clk clknet_4_15_0_clk VGND VGND VPWR VPWR clknet_leaf_73_clk sky130_fd_sc_hd__clkbuf_16
XFILLER_0_72_67 VPWR VGND VPWR VGND sky130_ef_sc_hd__decap_12
X_13949_ _07377_ _07378_ VGND VGND VPWR VPWR _07379_ sky130_fd_sc_hd__and2_1
X_16668_ clknet_leaf_97_clk _01235_ VGND VGND VPWR VPWR cpuregs\[29\]\[14\] sky130_fd_sc_hd__dfxtp_1
XFILLER_0_57_763 VGND VGND VPWR VPWR sky130_fd_sc_hd__fill_2
XFILLER_0_29_432 VGND VGND VPWR VPWR sky130_fd_sc_hd__fill_1
X_16599_ clknet_leaf_109_clk _01166_ VGND VGND VPWR VPWR cpuregs\[9\]\[9\] sky130_fd_sc_hd__dfxtp_1
X_15619_ clknet_leaf_133_clk _00269_ VGND VGND VPWR VPWR cpuregs\[31\]\[9\] sky130_fd_sc_hd__dfxtp_1
X_09140_ _03307_ _03405_ _03418_ _03360_ VGND VGND VPWR VPWR _03419_ sky130_fd_sc_hd__o211a_1
XFILLER_0_29_476 VGND VGND VPWR VPWR sky130_fd_sc_hd__fill_1
XFILLER_0_114_301 VGND VGND VPWR VPWR sky130_fd_sc_hd__fill_1
X_09071_ cpuregs\[16\]\[2\] cpuregs\[17\]\[2\] _03342_ VGND VGND VPWR VPWR _03352_
+ sky130_fd_sc_hd__mux2_1
XFILLER_0_4_543 VGND VGND VPWR VPWR sky130_fd_sc_hd__fill_1
X_08022_ count_instr\[15\] _02236_ count_cycle\[47\] _02237_ VGND VGND VPWR VPWR _02420_
+ sky130_fd_sc_hd__a22o_1
XFILLER_0_97_31 VGND VGND VPWR VPWR sky130_fd_sc_hd__fill_2
Xhold701 cpuregs\[18\]\[16\] VGND VGND VPWR VPWR net1059 sky130_fd_sc_hd__dlygate4sd3_1
Xhold712 cpuregs\[4\]\[17\] VGND VGND VPWR VPWR net1070 sky130_fd_sc_hd__dlygate4sd3_1
XFILLER_0_4_576 VGND VGND VPWR VPWR sky130_fd_sc_hd__fill_2
Xhold723 cpuregs\[8\]\[26\] VGND VGND VPWR VPWR net1081 sky130_fd_sc_hd__dlygate4sd3_1
Xhold745 cpuregs\[6\]\[24\] VGND VGND VPWR VPWR net1103 sky130_fd_sc_hd__dlygate4sd3_1
Xhold734 decoded_imm_j\[8\] VGND VGND VPWR VPWR net1092 sky130_fd_sc_hd__dlygate4sd3_1
XFILLER_0_4_587 VGND VGND VPWR VPWR sky130_fd_sc_hd__fill_1
Xhold756 cpuregs\[11\]\[27\] VGND VGND VPWR VPWR net1114 sky130_fd_sc_hd__dlygate4sd3_1
Xhold778 cpuregs\[10\]\[19\] VGND VGND VPWR VPWR net1136 sky130_fd_sc_hd__dlygate4sd3_1
X_09973_ _03670_ _04195_ _04197_ VGND VGND VPWR VPWR _04198_ sky130_fd_sc_hd__a21o_1
Xhold767 cpuregs\[14\]\[6\] VGND VGND VPWR VPWR net1125 sky130_fd_sc_hd__dlygate4sd3_1
X_08924_ _02340_ _03239_ _03227_ VGND VGND VPWR VPWR _03240_ sky130_fd_sc_hd__mux2_1
Xhold789 cpuregs\[2\]\[12\] VGND VGND VPWR VPWR net1147 sky130_fd_sc_hd__dlygate4sd3_1
XFILLER_0_0_793 VGND VGND VPWR VPWR sky130_fd_sc_hd__decap_4
X_08855_ _02447_ _02216_ VGND VGND VPWR VPWR _03203_ sky130_fd_sc_hd__or2_1
XFILLER_0_137_81 VPWR VGND VPWR VGND sky130_ef_sc_hd__decap_12
X_08786_ _02726_ _03136_ _03141_ _03020_ VGND VGND VPWR VPWR alu_out\[25\] sky130_fd_sc_hd__a22o_1
X_07806_ _02218_ VGND VGND VPWR VPWR _02219_ sky130_fd_sc_hd__buf_4
X_07737_ _02156_ _02157_ VGND VGND VPWR VPWR _02158_ sky130_fd_sc_hd__nor2_1
Xclkbuf_leaf_64_clk clknet_4_13_0_clk VGND VGND VPWR VPWR clknet_leaf_64_clk sky130_fd_sc_hd__clkbuf_16
XFILLER_0_95_814 VGND VGND VPWR VPWR sky130_fd_sc_hd__fill_2
XFILLER_0_67_516 VGND VGND VPWR VPWR sky130_fd_sc_hd__fill_2
X_07668_ mem_do_wdata cpu_state\[5\] VGND VGND VPWR VPWR _02098_ sky130_fd_sc_hd__nand2_1
X_09407_ reg_pc\[31\] _03638_ VGND VGND VPWR VPWR _03644_ sky130_fd_sc_hd__xnor2_1
XFILLER_0_48_741 VGND VGND VPWR VPWR sky130_fd_sc_hd__fill_1
X_09338_ net970 _03584_ _03578_ VGND VGND VPWR VPWR _03585_ sky130_fd_sc_hd__mux2_1
XFILLER_0_35_413 VGND VGND VPWR VPWR sky130_fd_sc_hd__decap_4
XFILLER_0_118_684 VGND VGND VPWR VPWR sky130_fd_sc_hd__decap_4
XFILLER_0_132_120 VGND VGND VPWR VPWR sky130_fd_sc_hd__fill_1
X_11300_ _05256_ VGND VGND VPWR VPWR _00348_ sky130_fd_sc_hd__clkbuf_1
X_09269_ _03524_ VGND VGND VPWR VPWR _03525_ sky130_fd_sc_hd__clkbuf_4
X_12280_ _05773_ _05894_ VGND VGND VPWR VPWR _05897_ sky130_fd_sc_hd__nor2_1
X_11231_ _03621_ VGND VGND VPWR VPWR _05217_ sky130_fd_sc_hd__clkbuf_4
X_11162_ _05170_ VGND VGND VPWR VPWR _00296_ sky130_fd_sc_hd__clkbuf_1
XFILLER_0_101_573 VPWR VGND VPWR VGND sky130_ef_sc_hd__decap_12
X_10113_ _04119_ _04333_ _04121_ VGND VGND VPWR VPWR _04334_ sky130_fd_sc_hd__a21o_1
XFILLER_0_30_195 VGND VGND VPWR VPWR sky130_fd_sc_hd__fill_1
X_11093_ _05131_ VGND VGND VPWR VPWR _00266_ sky130_fd_sc_hd__clkbuf_1
X_15970_ clknet_leaf_148_clk _00620_ VGND VGND VPWR VPWR count_instr\[39\] sky130_fd_sc_hd__dfxtp_1
X_10044_ _04119_ _04266_ _04121_ VGND VGND VPWR VPWR _04267_ sky130_fd_sc_hd__a21o_1
Xhold50 instr_lb VGND VGND VPWR VPWR net408 sky130_fd_sc_hd__dlygate4sd3_1
X_14921_ _03491_ net1449 _01829_ VGND VGND VPWR VPWR _01837_ sky130_fd_sc_hd__mux2_1
Xhold61 reg_next_pc\[25\] VGND VGND VPWR VPWR net419 sky130_fd_sc_hd__dlygate4sd3_1
X_14852_ _01800_ VGND VGND VPWR VPWR _01291_ sky130_fd_sc_hd__clkbuf_1
Xhold83 count_cycle\[22\] VGND VGND VPWR VPWR net441 sky130_fd_sc_hd__dlygate4sd3_1
Xhold72 instr_srai VGND VGND VPWR VPWR net430 sky130_fd_sc_hd__dlygate4sd3_1
X_13803_ _03318_ _07270_ VGND VGND VPWR VPWR _07271_ sky130_fd_sc_hd__or2_1
Xhold94 count_instr\[6\] VGND VGND VPWR VPWR net452 sky130_fd_sc_hd__dlygate4sd3_1
Xclkbuf_leaf_55_clk clknet_4_12_0_clk VGND VGND VPWR VPWR clknet_leaf_55_clk sky130_fd_sc_hd__clkbuf_16
X_11995_ _05664_ _05661_ _05665_ VGND VGND VPWR VPWR _05666_ sky130_fd_sc_hd__and3b_1
X_14783_ _01763_ VGND VGND VPWR VPWR _01259_ sky130_fd_sc_hd__clkbuf_1
X_13734_ cpuregs\[10\]\[29\] cpuregs\[11\]\[29\] _03347_ VGND VGND VPWR VPWR _07204_
+ sky130_fd_sc_hd__mux2_1
X_10946_ _04987_ net781 _05052_ VGND VGND VPWR VPWR _05054_ sky130_fd_sc_hd__mux2_1
X_16522_ clknet_leaf_2_clk _01099_ VGND VGND VPWR VPWR mem_rdata_q\[6\] sky130_fd_sc_hd__dfxtp_1
XFILLER_0_128_437 VGND VGND VPWR VPWR sky130_fd_sc_hd__fill_2
XFILLER_0_128_415 VGND VGND VPWR VPWR sky130_fd_sc_hd__decap_4
X_13665_ _06387_ _07137_ VGND VGND VPWR VPWR _07138_ sky130_fd_sc_hd__and2_1
X_10877_ _05007_ VGND VGND VPWR VPWR _00174_ sky130_fd_sc_hd__clkbuf_1
X_16453_ clknet_leaf_145_clk _01035_ VGND VGND VPWR VPWR cpuregs\[18\]\[6\] sky130_fd_sc_hd__dfxtp_1
XFILLER_0_128_448 VGND VGND VPWR VPWR sky130_fd_sc_hd__decap_6
X_15404_ clknet_leaf_78_clk _00059_ VGND VGND VPWR VPWR cpuregs\[11\]\[22\] sky130_fd_sc_hd__dfxtp_1
X_12616_ count_cycle\[34\] _06175_ VGND VGND VPWR VPWR _06180_ sky130_fd_sc_hd__or2_1
XFILLER_0_38_251 VGND VGND VPWR VPWR sky130_fd_sc_hd__fill_1
X_16384_ clknet_leaf_6_clk _00966_ VGND VGND VPWR VPWR net137 sky130_fd_sc_hd__dfxtp_1
XFILLER_0_108_150 VGND VGND VPWR VPWR sky130_fd_sc_hd__fill_1
X_13596_ cpuregs\[16\]\[24\] cpuregs\[17\]\[24\] cpuregs\[18\]\[24\] cpuregs\[19\]\[24\]
+ _06945_ _06979_ VGND VGND VPWR VPWR _07071_ sky130_fd_sc_hd__mux4_1
X_15335_ _02054_ VGND VGND VPWR VPWR _01520_ sky130_fd_sc_hd__clkbuf_1
XFILLER_0_124_643 VGND VGND VPWR VPWR sky130_fd_sc_hd__fill_1
XFILLER_0_108_183 VPWR VGND VPWR VGND sky130_ef_sc_hd__decap_12
X_12547_ count_cycle\[14\] _06127_ _05640_ VGND VGND VPWR VPWR _06131_ sky130_fd_sc_hd__a21oi_1
X_12478_ _02153_ _06078_ VGND VGND VPWR VPWR _06079_ sky130_fd_sc_hd__nor2_1
XANTENNA_3 _02453_ VGND VGND VPWR VPWR sky130_fd_sc_hd__diode_2
XFILLER_0_13_129 VGND VGND VPWR VPWR sky130_fd_sc_hd__fill_1
X_15266_ _02018_ VGND VGND VPWR VPWR _01487_ sky130_fd_sc_hd__clkbuf_1
X_14217_ _07533_ VGND VGND VPWR VPWR _00967_ sky130_fd_sc_hd__clkbuf_1
X_11429_ _05325_ VGND VGND VPWR VPWR _00408_ sky130_fd_sc_hd__clkbuf_1
X_15197_ _03504_ net1233 _01973_ VGND VGND VPWR VPWR _01983_ sky130_fd_sc_hd__mux2_1
XFILLER_0_111_337 VGND VGND VPWR VPWR sky130_fd_sc_hd__fill_1
X_14148_ _07494_ VGND VGND VPWR VPWR _00937_ sky130_fd_sc_hd__clkbuf_1
XTAP_313 VGND VPWR sky130_fd_sc_hd__tapvpwrvgnd_1
XTAP_302 VGND VPWR sky130_fd_sc_hd__tapvpwrvgnd_1
XTAP_324 VGND VPWR sky130_fd_sc_hd__tapvpwrvgnd_1
XTAP_357 VGND VPWR sky130_fd_sc_hd__tapvpwrvgnd_1
XTAP_346 VGND VPWR sky130_fd_sc_hd__tapvpwrvgnd_1
XTAP_335 VGND VPWR sky130_fd_sc_hd__tapvpwrvgnd_1
X_14079_ decoded_imm_j\[1\] _01114_ _03295_ VGND VGND VPWR VPWR _07456_ sky130_fd_sc_hd__mux2_1
XTAP_379 VGND VPWR sky130_fd_sc_hd__tapvpwrvgnd_1
XTAP_368 VGND VPWR sky130_fd_sc_hd__tapvpwrvgnd_1
X_08640_ _03004_ _03006_ VGND VGND VPWR VPWR _03007_ sky130_fd_sc_hd__xnor2_1
Xrebuffer26 decoder_trigger VGND VGND VPWR VPWR net384 sky130_fd_sc_hd__clkbuf_2
Xrebuffer15 net374 VGND VGND VPWR VPWR net373 sky130_fd_sc_hd__clkbuf_1
Xclkbuf_leaf_46_clk clknet_4_7_0_clk VGND VGND VPWR VPWR clknet_leaf_46_clk sky130_fd_sc_hd__clkbuf_16
X_08571_ _02352_ net248 _02942_ _02841_ VGND VGND VPWR VPWR _02943_ sky130_fd_sc_hd__a31o_1
XFILLER_0_49_516 VGND VGND VPWR VPWR sky130_fd_sc_hd__fill_1
XFILLER_0_49_505 VGND VGND VPWR VPWR sky130_fd_sc_hd__fill_2
XPHY_19 VGND VGND VPWR VPWR sky130_fd_sc_hd__decap_3
XFILLER_0_88_184 VPWR VGND VPWR VGND sky130_ef_sc_hd__decap_12
XFILLER_0_76_302 VGND VGND VPWR VPWR sky130_fd_sc_hd__decap_3
XFILLER_0_119_459 VGND VGND VPWR VPWR sky130_fd_sc_hd__fill_1
XFILLER_0_91_349 VGND VGND VPWR VPWR sky130_fd_sc_hd__fill_1
X_09123_ _03321_ _03401_ VGND VGND VPWR VPWR _03402_ sky130_fd_sc_hd__or2_1
XFILLER_0_96_3 VGND VGND VPWR VPWR sky130_fd_sc_hd__fill_2
XFILLER_0_114_120 VGND VGND VPWR VPWR sky130_fd_sc_hd__decap_8
X_09054_ _00010_ VGND VGND VPWR VPWR _03335_ sky130_fd_sc_hd__clkbuf_8
X_08005_ _02336_ _02404_ _02338_ VGND VGND VPWR VPWR _02405_ sky130_fd_sc_hd__a21o_1
Xhold520 cpuregs\[13\]\[12\] VGND VGND VPWR VPWR net878 sky130_fd_sc_hd__dlygate4sd3_1
XFILLER_0_25_490 VGND VGND VPWR VPWR sky130_fd_sc_hd__decap_8
Xhold542 cpuregs\[21\]\[26\] VGND VGND VPWR VPWR net900 sky130_fd_sc_hd__dlygate4sd3_1
XFILLER_0_114_197 VGND VGND VPWR VPWR sky130_fd_sc_hd__decap_8
Xhold531 cpuregs\[26\]\[12\] VGND VGND VPWR VPWR net889 sky130_fd_sc_hd__dlygate4sd3_1
Xhold553 cpuregs\[6\]\[9\] VGND VGND VPWR VPWR net911 sky130_fd_sc_hd__dlygate4sd3_1
Xhold597 cpuregs\[31\]\[18\] VGND VGND VPWR VPWR net955 sky130_fd_sc_hd__dlygate4sd3_1
Xhold575 cpuregs\[6\]\[14\] VGND VGND VPWR VPWR net933 sky130_fd_sc_hd__dlygate4sd3_1
Xhold564 cpuregs\[17\]\[12\] VGND VGND VPWR VPWR net922 sky130_fd_sc_hd__dlygate4sd3_1
XFILLER_0_4_9 VPWR VGND VPWR VGND sky130_ef_sc_hd__decap_12
Xhold586 cpuregs\[2\]\[9\] VGND VGND VPWR VPWR net944 sky130_fd_sc_hd__dlygate4sd3_1
X_09956_ _03690_ _04181_ _03657_ VGND VGND VPWR VPWR _04182_ sky130_fd_sc_hd__o21a_1
X_09887_ _04111_ _04112_ VGND VGND VPWR VPWR _04114_ sky130_fd_sc_hd__or2_1
X_08907_ _03228_ VGND VGND VPWR VPWR net86 sky130_fd_sc_hd__clkbuf_4
XTAP_880 VGND VPWR sky130_fd_sc_hd__tapvpwrvgnd_1
X_08838_ net226 _03188_ VGND VGND VPWR VPWR _03189_ sky130_fd_sc_hd__xnor2_1
Xhold1242 net169 VGND VGND VPWR VPWR net1600 sky130_fd_sc_hd__dlygate4sd3_1
Xhold1220 cpuregs\[5\]\[11\] VGND VGND VPWR VPWR net1578 sky130_fd_sc_hd__dlygate4sd3_1
Xhold1231 cpuregs\[21\]\[6\] VGND VGND VPWR VPWR net1589 sky130_fd_sc_hd__dlygate4sd3_1
XTAP_891 VGND VPWR sky130_fd_sc_hd__tapvpwrvgnd_1
Xhold1264 cpuregs\[15\]\[27\] VGND VGND VPWR VPWR net1622 sky130_fd_sc_hd__dlygate4sd3_1
Xhold1253 cpuregs\[9\]\[14\] VGND VGND VPWR VPWR net1611 sky130_fd_sc_hd__dlygate4sd3_1
Xhold1275 cpuregs\[13\]\[7\] VGND VGND VPWR VPWR net1633 sky130_fd_sc_hd__dlygate4sd3_1
Xclkbuf_leaf_37_clk clknet_4_5_0_clk VGND VGND VPWR VPWR clknet_leaf_37_clk sky130_fd_sc_hd__clkbuf_16
X_08769_ _03069_ _03121_ _03125_ VGND VGND VPWR VPWR _03126_ sky130_fd_sc_hd__a21boi_2
Xhold1297 reg_next_pc\[14\] VGND VGND VPWR VPWR net1655 sky130_fd_sc_hd__dlygate4sd3_1
Xhold1286 cpuregs\[25\]\[4\] VGND VGND VPWR VPWR net1644 sky130_fd_sc_hd__dlygate4sd3_1
X_11780_ _05511_ VGND VGND VPWR VPWR _00573_ sky130_fd_sc_hd__clkbuf_1
X_10800_ _04960_ VGND VGND VPWR VPWR _00144_ sky130_fd_sc_hd__clkbuf_1
XFILLER_0_67_346 VGND VGND VPWR VPWR sky130_fd_sc_hd__fill_1
X_10731_ _04922_ VGND VGND VPWR VPWR _00113_ sky130_fd_sc_hd__clkbuf_1
XFILLER_0_137_223 VGND VGND VPWR VPWR sky130_fd_sc_hd__fill_1
X_13450_ _06929_ net213 _06629_ VGND VGND VPWR VPWR _06930_ sky130_fd_sc_hd__mux2_1
X_10662_ _04868_ VGND VGND VPWR VPWR _00098_ sky130_fd_sc_hd__clkbuf_1
X_12401_ _05743_ _06000_ VGND VGND VPWR VPWR _06009_ sky130_fd_sc_hd__nor2_1
XFILLER_0_82_338 VGND VGND VPWR VPWR sky130_fd_sc_hd__fill_2
XFILLER_0_12_29 VGND VGND VPWR VPWR sky130_fd_sc_hd__fill_2
XFILLER_0_35_221 VGND VGND VPWR VPWR sky130_fd_sc_hd__decap_3
X_10593_ cpuregs\[14\]\[28\] cpuregs\[15\]\[28\] _03835_ VGND VGND VPWR VPWR _04801_
+ sky130_fd_sc_hd__mux2_1
XFILLER_0_118_470 VGND VGND VPWR VPWR sky130_fd_sc_hd__decap_6
X_13381_ _06780_ _06851_ _06855_ _06862_ _06800_ VGND VGND VPWR VPWR _06863_ sky130_fd_sc_hd__a311o_1
X_12332_ _05924_ _05936_ _05937_ VGND VGND VPWR VPWR _05945_ sky130_fd_sc_hd__nand3_1
XFILLER_0_50_202 VGND VGND VPWR VPWR sky130_fd_sc_hd__fill_1
X_15120_ _01942_ VGND VGND VPWR VPWR _01417_ sky130_fd_sc_hd__clkbuf_1
XFILLER_0_35_276 VGND VGND VPWR VPWR sky130_fd_sc_hd__decap_4
XFILLER_0_121_613 VGND VGND VPWR VPWR sky130_fd_sc_hd__decap_3
X_12263_ _05879_ _05880_ _05769_ VGND VGND VPWR VPWR _05882_ sky130_fd_sc_hd__o21a_1
X_15051_ net881 _05169_ _01901_ VGND VGND VPWR VPWR _01906_ sky130_fd_sc_hd__mux2_1
XFILLER_0_120_134 VGND VGND VPWR VPWR sky130_fd_sc_hd__decap_6
X_11214_ net851 _05205_ _05203_ VGND VGND VPWR VPWR _05206_ sky130_fd_sc_hd__mux2_1
X_14002_ mem_rdata_q\[27\] mem_rdata_q\[26\] _07414_ _07416_ VGND VGND VPWR VPWR _07417_
+ sky130_fd_sc_hd__and4bb_1
X_12194_ _05704_ _05812_ VGND VGND VPWR VPWR _05818_ sky130_fd_sc_hd__and2_1
Xoutput40 net40 VGND VGND VPWR VPWR mem_addr[15] sky130_fd_sc_hd__clkbuf_4
Xoutput51 net51 VGND VGND VPWR VPWR mem_addr[26] sky130_fd_sc_hd__clkbuf_4
Xoutput84 net84 VGND VGND VPWR VPWR mem_la_addr[28] sky130_fd_sc_hd__clkbuf_4
Xoutput73 net73 VGND VGND VPWR VPWR mem_la_addr[17] sky130_fd_sc_hd__clkbuf_4
Xoutput62 net62 VGND VGND VPWR VPWR mem_addr[7] sky130_fd_sc_hd__buf_2
X_11145_ _05158_ VGND VGND VPWR VPWR _00291_ sky130_fd_sc_hd__clkbuf_1
X_11076_ net740 _03646_ _05087_ VGND VGND VPWR VPWR _05122_ sky130_fd_sc_hd__mux2_1
X_15953_ clknet_leaf_153_clk _00603_ VGND VGND VPWR VPWR count_instr\[22\] sky130_fd_sc_hd__dfxtp_1
Xoutput95 net95 VGND VGND VPWR VPWR mem_la_addr[9] sky130_fd_sc_hd__clkbuf_4
X_14904_ _01827_ VGND VGND VPWR VPWR _01316_ sky130_fd_sc_hd__clkbuf_1
X_10027_ cpuregs\[16\]\[12\] cpuregs\[17\]\[12\] cpuregs\[18\]\[12\] cpuregs\[19\]\[12\]
+ _03941_ _04028_ VGND VGND VPWR VPWR _04251_ sky130_fd_sc_hd__mux4_1
X_15884_ clknet_leaf_56_clk _00534_ VGND VGND VPWR VPWR cpuregs\[20\]\[18\] sky130_fd_sc_hd__dfxtp_1
Xclkbuf_leaf_28_clk clknet_4_4_0_clk VGND VGND VPWR VPWR clknet_leaf_28_clk sky130_fd_sc_hd__clkbuf_16
X_14835_ _01790_ VGND VGND VPWR VPWR _01284_ sky130_fd_sc_hd__clkbuf_1
XFILLER_0_85_110 VGND VGND VPWR VPWR sky130_fd_sc_hd__fill_2
X_14766_ _05049_ net1230 _01719_ VGND VGND VPWR VPWR _01754_ sky130_fd_sc_hd__mux2_1
X_11978_ net1664 _05648_ net451 VGND VGND VPWR VPWR _05653_ sky130_fd_sc_hd__a21oi_1
X_10929_ _05042_ VGND VGND VPWR VPWR _00191_ sky130_fd_sc_hd__clkbuf_1
X_13717_ _06382_ _07187_ VGND VGND VPWR VPWR _07188_ sky130_fd_sc_hd__or2_1
X_16505_ clknet_leaf_46_clk _01087_ VGND VGND VPWR VPWR cpuregs\[19\]\[26\] sky130_fd_sc_hd__dfxtp_1
XFILLER_0_128_245 VGND VGND VPWR VPWR sky130_fd_sc_hd__decap_3
X_14697_ _01717_ VGND VGND VPWR VPWR _01219_ sky130_fd_sc_hd__clkbuf_1
XFILLER_0_85_154 VGND VGND VPWR VPWR sky130_fd_sc_hd__decap_4
X_13648_ cpuregs\[4\]\[26\] cpuregs\[5\]\[26\] _06906_ VGND VGND VPWR VPWR _07121_
+ sky130_fd_sc_hd__mux2_1
XFILLER_0_54_530 VGND VGND VPWR VPWR sky130_fd_sc_hd__fill_2
X_16436_ clknet_leaf_13_clk net755 VGND VGND VPWR VPWR decoded_imm\[11\] sky130_fd_sc_hd__dfxtp_2
XFILLER_0_6_627 VGND VGND VPWR VPWR sky130_fd_sc_hd__fill_1
XFILLER_0_116_429 VGND VGND VPWR VPWR sky130_fd_sc_hd__fill_2
X_13579_ _06762_ _07041_ _07054_ _06802_ decoded_imm\[23\] VGND VGND VPWR VPWR _07055_
+ sky130_fd_sc_hd__a32o_1
XPHY_190 VGND VGND VPWR VPWR sky130_fd_sc_hd__decap_3
XFILLER_0_14_405 VGND VGND VPWR VPWR sky130_fd_sc_hd__fill_1
X_16367_ clknet_leaf_2_clk _00949_ VGND VGND VPWR VPWR is_alu_reg_imm sky130_fd_sc_hd__dfxtp_2
X_15318_ _02045_ VGND VGND VPWR VPWR _01512_ sky130_fd_sc_hd__clkbuf_1
X_16298_ clknet_leaf_3_clk _00883_ VGND VGND VPWR VPWR instr_rdinstr sky130_fd_sc_hd__dfxtp_2
XFILLER_0_2_822 VGND VGND VPWR VPWR sky130_fd_sc_hd__fill_1
XFILLER_0_2_811 VGND VGND VPWR VPWR sky130_fd_sc_hd__fill_1
X_15249_ net455 VGND VGND VPWR VPWR _02010_ sky130_fd_sc_hd__clkbuf_1
XFILLER_0_1_387 VGND VGND VPWR VPWR sky130_fd_sc_hd__fill_1
X_09810_ cpuregs\[12\]\[7\] cpuregs\[13\]\[7\] _03664_ VGND VGND VPWR VPWR _04039_
+ sky130_fd_sc_hd__mux2_1
X_09741_ _03676_ _03966_ _03970_ _03971_ VGND VGND VPWR VPWR _03972_ sky130_fd_sc_hd__o211a_1
XFILLER_0_118_61 VGND VGND VPWR VPWR sky130_fd_sc_hd__fill_2
X_09672_ _03897_ _03899_ _03904_ VGND VGND VPWR VPWR _03905_ sky130_fd_sc_hd__a21o_1
XFILLER_0_27_70 VGND VGND VPWR VPWR sky130_fd_sc_hd__fill_2
X_08623_ _02685_ _02935_ _02971_ _02934_ VGND VGND VPWR VPWR _02991_ sky130_fd_sc_hd__o31a_1
Xclkbuf_leaf_19_clk clknet_4_6_0_clk VGND VGND VPWR VPWR clknet_leaf_19_clk sky130_fd_sc_hd__clkbuf_16
X_08554_ _02921_ _02927_ VGND VGND VPWR VPWR _02928_ sky130_fd_sc_hd__xor2_1
XTAP_1309 VGND VPWR sky130_fd_sc_hd__tapvpwrvgnd_1
XFILLER_0_11_3 VPWR VGND VPWR VGND sky130_ef_sc_hd__decap_12
X_08485_ _02862_ _02863_ VGND VGND VPWR VPWR _02864_ sky130_fd_sc_hd__nor2_1
XFILLER_0_37_519 VGND VGND VPWR VPWR sky130_fd_sc_hd__decap_6
XFILLER_0_43_80 VGND VGND VPWR VPWR sky130_fd_sc_hd__fill_2
XFILLER_0_91_113 VGND VGND VPWR VPWR sky130_fd_sc_hd__decap_6
XFILLER_0_134_226 VPWR VGND VPWR VGND sky130_ef_sc_hd__decap_12
X_09106_ cpuregs\[18\]\[3\] cpuregs\[19\]\[3\] _03312_ VGND VGND VPWR VPWR _03386_
+ sky130_fd_sc_hd__mux2_1
XFILLER_0_103_613 VGND VGND VPWR VPWR sky130_fd_sc_hd__decap_3
X_09037_ _03317_ VGND VGND VPWR VPWR _03318_ sky130_fd_sc_hd__buf_4
XFILLER_0_102_112 VGND VGND VPWR VPWR sky130_fd_sc_hd__fill_2
XFILLER_0_20_408 VGND VGND VPWR VPWR sky130_fd_sc_hd__decap_3
Xhold361 cpuregs\[20\]\[20\] VGND VGND VPWR VPWR net719 sky130_fd_sc_hd__dlygate4sd3_1
Xhold350 cpuregs\[31\]\[4\] VGND VGND VPWR VPWR net708 sky130_fd_sc_hd__dlygate4sd3_1
Xhold383 cpuregs\[22\]\[13\] VGND VGND VPWR VPWR net741 sky130_fd_sc_hd__dlygate4sd3_1
Xhold394 cpuregs\[7\]\[10\] VGND VGND VPWR VPWR net752 sky130_fd_sc_hd__dlygate4sd3_1
Xhold372 cpuregs\[25\]\[7\] VGND VGND VPWR VPWR net730 sky130_fd_sc_hd__dlygate4sd3_1
Xclkbuf_4_13_0_clk clknet_0_clk VGND VGND VPWR VPWR clknet_4_13_0_clk sky130_fd_sc_hd__clkbuf_8
X_09939_ cpuregs\[14\]\[10\] cpuregs\[15\]\[10\] _03898_ VGND VGND VPWR VPWR _04165_
+ sky130_fd_sc_hd__mux2_1
Xhold1050 cpuregs\[21\]\[28\] VGND VGND VPWR VPWR net1408 sky130_fd_sc_hd__dlygate4sd3_1
X_12950_ _03330_ VGND VGND VPWR VPWR _06444_ sky130_fd_sc_hd__clkbuf_8
Xhold1072 cpuregs\[8\]\[30\] VGND VGND VPWR VPWR net1430 sky130_fd_sc_hd__dlygate4sd3_1
Xhold1094 cpuregs\[10\]\[31\] VGND VGND VPWR VPWR net1452 sky130_fd_sc_hd__dlygate4sd3_1
Xhold1083 cpuregs\[6\]\[13\] VGND VGND VPWR VPWR net1441 sky130_fd_sc_hd__dlygate4sd3_1
X_11901_ count_instr\[28\] _05594_ VGND VGND VPWR VPWR _05597_ sky130_fd_sc_hd__and2_1
Xhold1061 cpuregs\[23\]\[4\] VGND VGND VPWR VPWR net1419 sky130_fd_sc_hd__dlygate4sd3_1
X_12881_ _06343_ _06378_ VGND VGND VPWR VPWR _06379_ sky130_fd_sc_hd__or2_1
X_14620_ _05039_ net1497 _01670_ VGND VGND VPWR VPWR _01677_ sky130_fd_sc_hd__mux2_1
X_11832_ count_instr\[7\] count_instr\[6\] _05536_ _05546_ VGND VGND VPWR VPWR _05547_
+ sky130_fd_sc_hd__and4_1
X_14551_ _01640_ VGND VGND VPWR VPWR _01150_ sky130_fd_sc_hd__clkbuf_1
XTAP_1832 VGND VPWR sky130_fd_sc_hd__tapvpwrvgnd_1
XTAP_1843 VGND VPWR sky130_fd_sc_hd__tapvpwrvgnd_1
XTAP_1821 VGND VPWR sky130_fd_sc_hd__tapvpwrvgnd_1
XTAP_1810 VGND VPWR sky130_fd_sc_hd__tapvpwrvgnd_1
XFILLER_0_95_441 VGND VGND VPWR VPWR sky130_fd_sc_hd__fill_2
XFILLER_0_67_143 VGND VGND VPWR VPWR sky130_fd_sc_hd__decap_8
XFILLER_0_138_521 VGND VGND VPWR VPWR sky130_fd_sc_hd__fill_2
XTAP_1876 VGND VPWR sky130_fd_sc_hd__tapvpwrvgnd_1
XTAP_1865 VGND VPWR sky130_fd_sc_hd__tapvpwrvgnd_1
XTAP_1854 VGND VPWR sky130_fd_sc_hd__tapvpwrvgnd_1
X_11763_ _05502_ VGND VGND VPWR VPWR _00565_ sky130_fd_sc_hd__clkbuf_1
X_14482_ net1038 _05213_ _01598_ VGND VGND VPWR VPWR _01604_ sky130_fd_sc_hd__mux2_1
X_13502_ cpuregs\[16\]\[21\] cpuregs\[17\]\[21\] cpuregs\[18\]\[21\] cpuregs\[19\]\[21\]
+ _06945_ _06979_ VGND VGND VPWR VPWR _06980_ sky130_fd_sc_hd__mux4_1
XTAP_1898 VGND VPWR sky130_fd_sc_hd__tapvpwrvgnd_1
XTAP_1887 VGND VPWR sky130_fd_sc_hd__tapvpwrvgnd_1
X_11694_ net577 _05196_ _05458_ VGND VGND VPWR VPWR _05466_ sky130_fd_sc_hd__mux2_1
XFILLER_0_48_390 VGND VGND VPWR VPWR sky130_fd_sc_hd__decap_3
X_10714_ _04913_ VGND VGND VPWR VPWR _00105_ sky130_fd_sc_hd__clkbuf_1
X_10645_ cpuregs\[16\]\[29\] cpuregs\[17\]\[29\] cpuregs\[18\]\[29\] cpuregs\[19\]\[29\]
+ _03819_ _03799_ VGND VGND VPWR VPWR _04852_ sky130_fd_sc_hd__mux4_2
XFILLER_0_125_237 VGND VGND VPWR VPWR sky130_fd_sc_hd__fill_1
X_13433_ _06911_ _06912_ VGND VGND VPWR VPWR _06913_ sky130_fd_sc_hd__or2_1
X_16221_ clknet_leaf_5_clk _00838_ VGND VGND VPWR VPWR latched_store sky130_fd_sc_hd__dfxtp_4
X_16152_ clknet_leaf_37_clk _07641_ VGND VGND VPWR VPWR reg_out\[30\] sky130_fd_sc_hd__dfxtp_1
XFILLER_0_130_29 VPWR VGND VPWR VGND sky130_ef_sc_hd__decap_12
X_13364_ _06580_ _06845_ VGND VGND VPWR VPWR _06846_ sky130_fd_sc_hd__or2_1
XFILLER_0_23_202 VGND VGND VPWR VPWR sky130_fd_sc_hd__fill_1
X_10576_ _02083_ _04754_ _04755_ _04784_ VGND VGND VPWR VPWR _04785_ sky130_fd_sc_hd__a31o_1
X_15103_ net1192 _05221_ _01923_ VGND VGND VPWR VPWR _01933_ sky130_fd_sc_hd__mux2_1
X_12315_ _05723_ _05920_ VGND VGND VPWR VPWR _05930_ sky130_fd_sc_hd__nand2_1
Xrebuffer6 net365 VGND VGND VPWR VPWR net364 sky130_fd_sc_hd__clkbuf_1
XFILLER_0_133_281 VGND VGND VPWR VPWR sky130_fd_sc_hd__fill_2
X_13295_ _06631_ _06770_ _06778_ VGND VGND VPWR VPWR _06779_ sky130_fd_sc_hd__or3_2
XFILLER_0_51_588 VGND VGND VPWR VPWR sky130_fd_sc_hd__fill_1
X_16083_ clknet_leaf_1_clk _00733_ VGND VGND VPWR VPWR count_cycle\[26\] sky130_fd_sc_hd__dfxtp_1
X_15034_ _01896_ VGND VGND VPWR VPWR _01377_ sky130_fd_sc_hd__clkbuf_1
X_12246_ _05712_ _05863_ VGND VGND VPWR VPWR _05866_ sky130_fd_sc_hd__or2b_1
XFILLER_0_32_791 VGND VGND VPWR VPWR sky130_fd_sc_hd__fill_1
X_12177_ _05790_ _05701_ _05801_ _05802_ VGND VGND VPWR VPWR _05803_ sky130_fd_sc_hd__a22o_1
X_11128_ net1587 _03597_ _05146_ VGND VGND VPWR VPWR _05150_ sky130_fd_sc_hd__mux2_1
XFILLER_0_3_27 VPWR VGND VPWR VGND sky130_ef_sc_hd__decap_12
X_11059_ _05113_ VGND VGND VPWR VPWR _00250_ sky130_fd_sc_hd__clkbuf_1
X_15936_ clknet_leaf_141_clk _00586_ VGND VGND VPWR VPWR count_instr\[5\] sky130_fd_sc_hd__dfxtp_1
X_15867_ clknet_leaf_144_clk _00517_ VGND VGND VPWR VPWR cpuregs\[20\]\[1\] sky130_fd_sc_hd__dfxtp_1
X_14818_ net873 _05209_ _01778_ VGND VGND VPWR VPWR _01782_ sky130_fd_sc_hd__mux2_1
X_15798_ clknet_leaf_64_clk _00448_ VGND VGND VPWR VPWR cpuregs\[26\]\[28\] sky130_fd_sc_hd__dfxtp_1
XFILLER_0_129_521 VGND VGND VPWR VPWR sky130_fd_sc_hd__decap_8
X_14749_ _01745_ VGND VGND VPWR VPWR _01243_ sky130_fd_sc_hd__clkbuf_1
X_08270_ _02639_ _02644_ _02650_ _02170_ VGND VGND VPWR VPWR _02652_ sky130_fd_sc_hd__a31o_1
XFILLER_0_73_113 VGND VGND VPWR VPWR sky130_fd_sc_hd__fill_2
XFILLER_0_116_204 VGND VGND VPWR VPWR sky130_fd_sc_hd__fill_2
XFILLER_0_104_85 VGND VGND VPWR VPWR sky130_fd_sc_hd__fill_2
X_16419_ clknet_leaf_25_clk _01001_ VGND VGND VPWR VPWR decoded_imm\[28\] sky130_fd_sc_hd__dfxtp_2
XFILLER_0_13_72 VGND VGND VPWR VPWR sky130_fd_sc_hd__decap_4
XFILLER_0_70_831 VGND VGND VPWR VPWR sky130_fd_sc_hd__fill_1
Xclkbuf_leaf_8_clk clknet_4_1_0_clk VGND VGND VPWR VPWR clknet_leaf_8_clk sky130_fd_sc_hd__clkbuf_16
XFILLER_0_140_785 VGND VGND VPWR VPWR sky130_fd_sc_hd__fill_2
XFILLER_0_23_791 VGND VGND VPWR VPWR sky130_fd_sc_hd__fill_1
X_07985_ reg_pc\[12\] decoded_imm\[12\] VGND VGND VPWR VPWR _02386_ sky130_fd_sc_hd__nand2_1
X_09724_ decoded_imm\[5\] net198 VGND VGND VPWR VPWR _03955_ sky130_fd_sc_hd__or2_1
X_09655_ cpuregs\[16\]\[3\] cpuregs\[17\]\[3\] cpuregs\[18\]\[3\] cpuregs\[19\]\[3\]
+ _03865_ _03727_ VGND VGND VPWR VPWR _03888_ sky130_fd_sc_hd__mux4_1
X_08606_ _02973_ _02974_ _02391_ VGND VGND VPWR VPWR _02975_ sky130_fd_sc_hd__o21ai_1
XFILLER_0_139_329 VGND VGND VPWR VPWR sky130_fd_sc_hd__fill_1
X_09586_ _00013_ VGND VGND VPWR VPWR _03820_ sky130_fd_sc_hd__buf_6
XTAP_1128 VGND VPWR sky130_fd_sc_hd__tapvpwrvgnd_1
XTAP_1117 VGND VPWR sky130_fd_sc_hd__tapvpwrvgnd_1
XTAP_1106 VGND VPWR sky130_fd_sc_hd__tapvpwrvgnd_1
XFILLER_0_77_463 VGND VGND VPWR VPWR sky130_fd_sc_hd__fill_2
X_08537_ _02910_ _02911_ VGND VGND VPWR VPWR _02912_ sky130_fd_sc_hd__and2_1
XFILLER_0_65_614 VGND VGND VPWR VPWR sky130_fd_sc_hd__fill_2
XTAP_1139 VGND VPWR sky130_fd_sc_hd__tapvpwrvgnd_1
XFILLER_0_64_124 VGND VGND VPWR VPWR sky130_fd_sc_hd__decap_4
X_08468_ net439 _02836_ _02843_ _02848_ VGND VGND VPWR VPWR alu_out\[0\] sky130_fd_sc_hd__a211o_1
XFILLER_0_37_349 VGND VGND VPWR VPWR sky130_fd_sc_hd__decap_3
XFILLER_0_65_669 VGND VGND VPWR VPWR sky130_fd_sc_hd__decap_3
XFILLER_0_18_530 VGND VGND VPWR VPWR sky130_fd_sc_hd__fill_2
X_10430_ _03794_ _04629_ _04642_ _03775_ reg_pc\[23\] VGND VGND VPWR VPWR _04643_
+ sky130_fd_sc_hd__a32o_1
X_08399_ net205 VGND VGND VPWR VPWR _02780_ sky130_fd_sc_hd__inv_2
XFILLER_0_61_831 VGND VGND VPWR VPWR sky130_fd_sc_hd__fill_1
XFILLER_0_45_393 VGND VGND VPWR VPWR sky130_fd_sc_hd__fill_2
X_10361_ _02083_ _04545_ _04546_ _04575_ VGND VGND VPWR VPWR _04576_ sky130_fd_sc_hd__a31o_1
XFILLER_0_115_281 VGND VGND VPWR VPWR sky130_fd_sc_hd__fill_2
XFILLER_0_130_251 VGND VGND VPWR VPWR sky130_fd_sc_hd__fill_1
X_12100_ _05737_ reg_pc\[21\] VGND VGND VPWR VPWR _05740_ sky130_fd_sc_hd__or2_1
X_10292_ _03714_ VGND VGND VPWR VPWR _04509_ sky130_fd_sc_hd__clkbuf_4
X_13080_ cpuregs\[8\]\[9\] cpuregs\[9\]\[9\] _06422_ VGND VGND VPWR VPWR _06570_ sky130_fd_sc_hd__mux2_1
XFILLER_0_103_487 VGND VGND VPWR VPWR sky130_fd_sc_hd__fill_1
X_12031_ _05690_ reg_pc\[1\] VGND VGND VPWR VPWR _05691_ sky130_fd_sc_hd__or2_1
Xhold180 count_cycle\[29\] VGND VGND VPWR VPWR net538 sky130_fd_sc_hd__dlygate4sd3_1
XFILLER_0_0_3 VGND VGND VPWR VPWR sky130_fd_sc_hd__fill_2
Xhold191 count_cycle\[30\] VGND VGND VPWR VPWR net549 sky130_fd_sc_hd__dlygate4sd3_1
X_16770_ clknet_leaf_89_clk _01334_ VGND VGND VPWR VPWR cpuregs\[5\]\[17\] sky130_fd_sc_hd__dfxtp_1
X_13982_ is_alu_reg_reg _07343_ net241 _07325_ instr_sra VGND VGND VPWR VPWR _07401_
+ sky130_fd_sc_hd__a32o_1
X_15721_ clknet_leaf_56_clk _00371_ VGND VGND VPWR VPWR cpuregs\[21\]\[15\] sky130_fd_sc_hd__dfxtp_1
X_12933_ _06421_ _06423_ _06426_ VGND VGND VPWR VPWR _06427_ sky130_fd_sc_hd__a21o_1
XFILLER_0_87_205 VGND VGND VPWR VPWR sky130_fd_sc_hd__decap_6
XFILLER_0_34_27 VGND VGND VPWR VPWR sky130_fd_sc_hd__fill_1
XTAP_2352 VGND VPWR sky130_fd_sc_hd__tapvpwrvgnd_1
XTAP_2341 VGND VPWR sky130_fd_sc_hd__tapvpwrvgnd_1
XTAP_2330 VGND VPWR sky130_fd_sc_hd__tapvpwrvgnd_1
X_15652_ clknet_leaf_102_clk _00302_ VGND VGND VPWR VPWR cpuregs\[14\]\[10\] sky130_fd_sc_hd__dfxtp_1
X_12864_ _03318_ _06362_ VGND VGND VPWR VPWR _06363_ sky130_fd_sc_hd__or2_1
X_12795_ net546 net74 _06302_ VGND VGND VPWR VPWR _06312_ sky130_fd_sc_hd__mux2_1
XTAP_1640 VGND VPWR sky130_fd_sc_hd__tapvpwrvgnd_1
XTAP_1651 VGND VPWR sky130_fd_sc_hd__tapvpwrvgnd_1
X_14603_ _05022_ net1221 _01659_ VGND VGND VPWR VPWR _01668_ sky130_fd_sc_hd__mux2_1
XFILLER_0_56_614 VGND VGND VPWR VPWR sky130_fd_sc_hd__fill_2
X_11815_ net433 _05529_ _05534_ VGND VGND VPWR VPWR _00585_ sky130_fd_sc_hd__a21oi_1
X_15583_ clknet_leaf_130_clk _00233_ VGND VGND VPWR VPWR cpuregs\[28\]\[5\] sky130_fd_sc_hd__dfxtp_1
XTAP_1684 VGND VPWR sky130_fd_sc_hd__tapvpwrvgnd_1
XTAP_1673 VGND VPWR sky130_fd_sc_hd__tapvpwrvgnd_1
XTAP_1662 VGND VPWR sky130_fd_sc_hd__tapvpwrvgnd_1
X_14534_ _01631_ VGND VGND VPWR VPWR _01142_ sky130_fd_sc_hd__clkbuf_1
XFILLER_0_56_625 VGND VGND VPWR VPWR sky130_fd_sc_hd__fill_1
X_11746_ _05493_ VGND VGND VPWR VPWR _00557_ sky130_fd_sc_hd__clkbuf_1
XTAP_1695 VGND VPWR sky130_fd_sc_hd__tapvpwrvgnd_1
XFILLER_0_83_477 VGND VGND VPWR VPWR sky130_fd_sc_hd__fill_1
XFILLER_0_71_617 VGND VGND VPWR VPWR sky130_fd_sc_hd__fill_2
X_16204_ clknet_leaf_54_clk _00821_ VGND VGND VPWR VPWR net209 sky130_fd_sc_hd__dfxtp_4
X_14465_ net672 _05196_ _01587_ VGND VGND VPWR VPWR _01595_ sky130_fd_sc_hd__mux2_1
X_11677_ net751 _05179_ _05447_ VGND VGND VPWR VPWR _05457_ sky130_fd_sc_hd__mux2_1
X_10628_ _04830_ _04833_ VGND VGND VPWR VPWR _04835_ sky130_fd_sc_hd__or2_1
X_13416_ _06780_ _06884_ _06888_ _06896_ _06800_ VGND VGND VPWR VPWR _06897_ sky130_fd_sc_hd__a311o_1
X_14396_ _01558_ VGND VGND VPWR VPWR _01045_ sky130_fd_sc_hd__clkbuf_1
XFILLER_0_24_533 VGND VGND VPWR VPWR sky130_fd_sc_hd__decap_8
Xpicorv32_327 VGND VGND VPWR VPWR picorv32_327/HI trace_data[5] sky130_fd_sc_hd__conb_1
Xpicorv32_316 VGND VGND VPWR VPWR picorv32_316/HI pcpi_insn[27] sky130_fd_sc_hd__conb_1
X_10559_ _04125_ _04763_ _04767_ _03829_ VGND VGND VPWR VPWR _04768_ sky130_fd_sc_hd__o211a_1
X_16135_ clknet_leaf_23_clk _07622_ VGND VGND VPWR VPWR reg_out\[13\] sky130_fd_sc_hd__dfxtp_1
X_13347_ _06751_ _06825_ _06829_ _06798_ VGND VGND VPWR VPWR _06830_ sky130_fd_sc_hd__o211a_1
Xpicorv32_305 VGND VGND VPWR VPWR picorv32_305/HI pcpi_insn[16] sky130_fd_sc_hd__conb_1
Xpicorv32_349 VGND VGND VPWR VPWR picorv32_349/HI trace_data[27] sky130_fd_sc_hd__conb_1
X_13278_ _06415_ VGND VGND VPWR VPWR _06762_ sky130_fd_sc_hd__clkbuf_4
X_16066_ clknet_leaf_147_clk _00716_ VGND VGND VPWR VPWR count_cycle\[9\] sky130_fd_sc_hd__dfxtp_1
Xpicorv32_338 VGND VGND VPWR VPWR picorv32_338/HI trace_data[16] sky130_fd_sc_hd__conb_1
X_15017_ _03577_ net1200 _01887_ VGND VGND VPWR VPWR _01888_ sky130_fd_sc_hd__mux2_1
X_12229_ _05790_ _05709_ _05850_ _05802_ VGND VGND VPWR VPWR _05851_ sky130_fd_sc_hd__a22o_1
XFILLER_0_20_750 VGND VGND VPWR VPWR sky130_fd_sc_hd__decap_6
X_16968_ clknet_leaf_77_clk _01532_ VGND VGND VPWR VPWR cpuregs\[10\]\[23\] sky130_fd_sc_hd__dfxtp_1
X_07770_ _02133_ VGND VGND VPWR VPWR _02187_ sky130_fd_sc_hd__clkbuf_4
X_15919_ clknet_leaf_44_clk _00569_ VGND VGND VPWR VPWR cpuregs\[17\]\[21\] sky130_fd_sc_hd__dfxtp_1
X_16899_ clknet_leaf_84_clk _01463_ VGND VGND VPWR VPWR cpuregs\[8\]\[18\] sky130_fd_sc_hd__dfxtp_1
X_09440_ _03675_ VGND VGND VPWR VPWR _03676_ sky130_fd_sc_hd__buf_6
XFILLER_0_78_249 VGND VGND VPWR VPWR sky130_fd_sc_hd__decap_3
X_09371_ reg_pc\[26\] _03607_ _03460_ VGND VGND VPWR VPWR _03613_ sky130_fd_sc_hd__o21ai_1
XFILLER_0_91_77 VGND VGND VPWR VPWR sky130_fd_sc_hd__fill_1
XFILLER_0_87_783 VGND VGND VPWR VPWR sky130_fd_sc_hd__fill_1
XFILLER_0_74_400 VGND VGND VPWR VPWR sky130_fd_sc_hd__fill_1
XFILLER_0_19_305 VGND VGND VPWR VPWR sky130_fd_sc_hd__fill_2
X_08322_ _02699_ _02700_ _02701_ _02702_ VGND VGND VPWR VPWR _02703_ sky130_fd_sc_hd__a22o_1
XFILLER_0_115_84 VGND VGND VPWR VPWR sky130_fd_sc_hd__fill_1
X_08253_ count_instr\[62\] _02203_ VGND VGND VPWR VPWR _02636_ sky130_fd_sc_hd__and2_1
XFILLER_0_6_232 VGND VGND VPWR VPWR sky130_fd_sc_hd__decap_3
XFILLER_0_43_820 VGND VGND VPWR VPWR sky130_fd_sc_hd__fill_1
X_08184_ count_cycle\[25\] _02454_ _02570_ _02571_ VGND VGND VPWR VPWR _02572_ sky130_fd_sc_hd__a211o_2
XFILLER_0_43_831 VGND VGND VPWR VPWR sky130_fd_sc_hd__fill_1
XFILLER_0_113_741 VGND VGND VPWR VPWR sky130_fd_sc_hd__fill_2
XFILLER_0_112_262 VGND VGND VPWR VPWR sky130_fd_sc_hd__decap_8
Xoutput230 net230 VGND VGND VPWR VPWR pcpi_rs2[5] sky130_fd_sc_hd__buf_2
X_07968_ count_instr\[11\] _02236_ count_cycle\[43\] _02204_ VGND VGND VPWR VPWR _02370_
+ sky130_fd_sc_hd__a22o_1
X_09707_ _03832_ VGND VGND VPWR VPWR _03939_ sky130_fd_sc_hd__clkbuf_8
X_07899_ reg_pc\[6\] decoded_imm\[6\] VGND VGND VPWR VPWR _02306_ sky130_fd_sc_hd__and2_1
XFILLER_0_97_558 VGND VGND VPWR VPWR sky130_fd_sc_hd__fill_2
X_09638_ _03868_ _03869_ _03870_ VGND VGND VPWR VPWR _03871_ sky130_fd_sc_hd__a21o_1
XFILLER_0_139_137 VPWR VGND VPWR VGND sky130_ef_sc_hd__decap_12
XFILLER_0_78_750 VGND VGND VPWR VPWR sky130_fd_sc_hd__fill_1
X_09569_ cpuregs\[10\]\[2\] cpuregs\[11\]\[2\] _03767_ VGND VGND VPWR VPWR _03803_
+ sky130_fd_sc_hd__mux2_1
XFILLER_0_136_800 VGND VGND VPWR VPWR sky130_fd_sc_hd__decap_8
X_11600_ _05416_ VGND VGND VPWR VPWR _00488_ sky130_fd_sc_hd__clkbuf_1
X_12580_ _06154_ VGND VGND VPWR VPWR _00730_ sky130_fd_sc_hd__clkbuf_1
XFILLER_0_37_113 VGND VGND VPWR VPWR sky130_fd_sc_hd__decap_8
X_11531_ _04993_ net1572 _05375_ VGND VGND VPWR VPWR _05380_ sky130_fd_sc_hd__mux2_1
X_14250_ _07550_ VGND VGND VPWR VPWR _00983_ sky130_fd_sc_hd__clkbuf_1
X_11462_ net605 _05169_ _05338_ VGND VGND VPWR VPWR _05343_ sky130_fd_sc_hd__mux2_1
XFILLER_0_20_29 VGND VGND VPWR VPWR sky130_fd_sc_hd__fill_1
X_10413_ _03823_ _04625_ _03730_ VGND VGND VPWR VPWR _04626_ sky130_fd_sc_hd__a21o_1
XFILLER_0_104_730 VGND VGND VPWR VPWR sky130_fd_sc_hd__fill_1
X_13201_ cpuregs\[28\]\[12\] cpuregs\[29\]\[12\] _06687_ VGND VGND VPWR VPWR _06688_
+ sky130_fd_sc_hd__mux2_1
X_14181_ mem_do_rdata _02111_ _07508_ _07511_ VGND VGND VPWR VPWR _07512_ sky130_fd_sc_hd__o31a_1
X_11393_ _05306_ VGND VGND VPWR VPWR _00391_ sky130_fd_sc_hd__clkbuf_1
XFILLER_0_33_352 VGND VGND VPWR VPWR sky130_fd_sc_hd__fill_1
X_10344_ _04125_ _04554_ _04558_ _03971_ VGND VGND VPWR VPWR _04559_ sky130_fd_sc_hd__o211a_1
XFILLER_0_60_160 VGND VGND VPWR VPWR sky130_fd_sc_hd__fill_2
X_13132_ cpuregs\[24\]\[10\] cpuregs\[25\]\[10\] cpuregs\[26\]\[10\] cpuregs\[27\]\[10\]
+ _06525_ _06558_ VGND VGND VPWR VPWR _06621_ sky130_fd_sc_hd__mux4_1
X_10275_ _03863_ _04485_ _04491_ VGND VGND VPWR VPWR _04492_ sky130_fd_sc_hd__or3_2
X_13063_ cpuregs\[20\]\[8\] cpuregs\[21\]\[8\] _06448_ VGND VGND VPWR VPWR _06554_
+ sky130_fd_sc_hd__mux2_1
XTAP_709 VGND VPWR sky130_fd_sc_hd__tapvpwrvgnd_1
XFILLER_0_29_38 VGND VGND VPWR VPWR sky130_fd_sc_hd__fill_2
X_12014_ net398 _05674_ _05678_ VGND VGND VPWR VPWR _00640_ sky130_fd_sc_hd__o21a_1
X_16822_ clknet_leaf_122_clk _01386_ VGND VGND VPWR VPWR cpuregs\[7\]\[5\] sky130_fd_sc_hd__dfxtp_1
X_16753_ clknet_leaf_118_clk _01317_ VGND VGND VPWR VPWR cpuregs\[5\]\[0\] sky130_fd_sc_hd__dfxtp_1
X_13965_ _07377_ _07389_ VGND VGND VPWR VPWR _07390_ sky130_fd_sc_hd__and2_1
X_15704_ clknet_leaf_57_clk _00354_ VGND VGND VPWR VPWR cpuregs\[27\]\[30\] sky130_fd_sc_hd__dfxtp_1
X_16684_ clknet_leaf_59_clk _01251_ VGND VGND VPWR VPWR cpuregs\[29\]\[30\] sky130_fd_sc_hd__dfxtp_1
X_12916_ _06411_ VGND VGND VPWR VPWR _00809_ sky130_fd_sc_hd__clkbuf_1
X_13896_ _07332_ _07344_ VGND VGND VPWR VPWR _07345_ sky130_fd_sc_hd__and2_1
X_15635_ clknet_leaf_68_clk _00285_ VGND VGND VPWR VPWR cpuregs\[31\]\[25\] sky130_fd_sc_hd__dfxtp_1
XTAP_2171 VGND VPWR sky130_fd_sc_hd__tapvpwrvgnd_1
XTAP_2160 VGND VPWR sky130_fd_sc_hd__tapvpwrvgnd_1
X_12847_ cpuregs\[20\]\[0\] cpuregs\[21\]\[0\] cpuregs\[22\]\[0\] cpuregs\[23\]\[0\]
+ _06344_ _06345_ VGND VGND VPWR VPWR _06346_ sky130_fd_sc_hd__mux4_1
XTAP_2193 VGND VPWR sky130_fd_sc_hd__tapvpwrvgnd_1
XTAP_2182 VGND VPWR sky130_fd_sc_hd__tapvpwrvgnd_1
XFILLER_0_69_783 VGND VGND VPWR VPWR sky130_fd_sc_hd__fill_1
XFILLER_0_68_260 VGND VGND VPWR VPWR sky130_fd_sc_hd__fill_1
XFILLER_0_139_671 VGND VGND VPWR VPWR sky130_fd_sc_hd__fill_1
X_12778_ _06303_ VGND VGND VPWR VPWR _00779_ sky130_fd_sc_hd__clkbuf_1
X_15566_ clknet_leaf_83_clk _00216_ VGND VGND VPWR VPWR cpuregs\[2\]\[20\] sky130_fd_sc_hd__dfxtp_1
XTAP_1492 VGND VPWR sky130_fd_sc_hd__tapvpwrvgnd_1
XTAP_1481 VGND VPWR sky130_fd_sc_hd__tapvpwrvgnd_1
XTAP_1470 VGND VPWR sky130_fd_sc_hd__tapvpwrvgnd_1
XFILLER_0_44_606 VGND VGND VPWR VPWR sky130_fd_sc_hd__fill_1
XFILLER_0_17_809 VGND VGND VPWR VPWR sky130_fd_sc_hd__decap_3
XFILLER_0_29_669 VGND VGND VPWR VPWR sky130_fd_sc_hd__decap_3
XFILLER_0_126_343 VGND VGND VPWR VPWR sky130_fd_sc_hd__decap_4
X_15497_ clknet_leaf_93_clk _00147_ VGND VGND VPWR VPWR cpuregs\[30\]\[15\] sky130_fd_sc_hd__dfxtp_1
XFILLER_0_44_628 VGND VGND VPWR VPWR sky130_fd_sc_hd__fill_1
X_11729_ _04987_ net1612 _05483_ VGND VGND VPWR VPWR _05485_ sky130_fd_sc_hd__mux2_1
X_14517_ _01622_ VGND VGND VPWR VPWR _01134_ sky130_fd_sc_hd__clkbuf_1
XFILLER_0_126_365 VGND VGND VPWR VPWR sky130_fd_sc_hd__fill_2
XFILLER_0_114_527 VGND VGND VPWR VPWR sky130_fd_sc_hd__decap_4
XFILLER_0_4_725 VPWR VGND VPWR VGND sky130_ef_sc_hd__decap_12
X_14448_ net625 _05179_ _01576_ VGND VGND VPWR VPWR _01586_ sky130_fd_sc_hd__mux2_1
Xhold905 cpuregs\[3\]\[22\] VGND VGND VPWR VPWR net1263 sky130_fd_sc_hd__dlygate4sd3_1
Xhold927 cpuregs\[8\]\[14\] VGND VGND VPWR VPWR net1285 sky130_fd_sc_hd__dlygate4sd3_1
Xhold916 cpuregs\[23\]\[10\] VGND VGND VPWR VPWR net1274 sky130_fd_sc_hd__dlygate4sd3_1
XFILLER_0_4_769 VPWR VGND VPWR VGND sky130_ef_sc_hd__decap_12
X_16118_ clknet_leaf_0_clk _00768_ VGND VGND VPWR VPWR count_cycle\[61\] sky130_fd_sc_hd__dfxtp_1
X_14379_ _01549_ VGND VGND VPWR VPWR _01037_ sky130_fd_sc_hd__clkbuf_1
Xhold938 cpuregs\[16\]\[24\] VGND VGND VPWR VPWR net1296 sky130_fd_sc_hd__dlygate4sd3_1
Xhold949 cpuregs\[16\]\[18\] VGND VGND VPWR VPWR net1307 sky130_fd_sc_hd__dlygate4sd3_1
XFILLER_0_51_193 VGND VGND VPWR VPWR sky130_fd_sc_hd__decap_4
X_16049_ clknet_leaf_34_clk _00699_ VGND VGND VPWR VPWR reg_next_pc\[24\] sky130_fd_sc_hd__dfxtp_1
XFILLER_0_110_755 VGND VGND VPWR VPWR sky130_fd_sc_hd__fill_1
X_08940_ reg_out\[13\] reg_next_pc\[13\] _03248_ VGND VGND VPWR VPWR _03251_ sky130_fd_sc_hd__mux2_1
X_08871_ _02143_ _02664_ _02688_ _02133_ VGND VGND VPWR VPWR _03211_ sky130_fd_sc_hd__a22o_1
X_07822_ cpu_state\[3\] cpu_state\[6\] cpu_state\[4\] VGND VGND VPWR VPWR _02234_
+ sky130_fd_sc_hd__or3_1
X_07753_ is_lb_lh_lw_lbu_lhu VGND VGND VPWR VPWR _02172_ sky130_fd_sc_hd__buf_2
XFILLER_0_126_61 VGND VGND VPWR VPWR sky130_fd_sc_hd__fill_1
XFILLER_0_126_50 VGND VGND VPWR VPWR sky130_fd_sc_hd__decap_3
X_07684_ mem_do_rdata _02111_ _02112_ VGND VGND VPWR VPWR _02113_ sky130_fd_sc_hd__o21ai_4
X_09423_ _03658_ VGND VGND VPWR VPWR _03659_ sky130_fd_sc_hd__buf_4
X_09354_ _03598_ VGND VGND VPWR VPWR _00060_ sky130_fd_sc_hd__clkbuf_1
XFILLER_0_19_113 VGND VGND VPWR VPWR sky130_fd_sc_hd__fill_1
X_08305_ net174 _02685_ VGND VGND VPWR VPWR _02686_ sky130_fd_sc_hd__or2_1
XFILLER_0_90_701 VGND VGND VPWR VPWR sky130_fd_sc_hd__fill_1
X_09285_ net885 _03538_ _03512_ VGND VGND VPWR VPWR _03539_ sky130_fd_sc_hd__mux2_1
XFILLER_0_35_617 VGND VGND VPWR VPWR sky130_fd_sc_hd__fill_1
X_08236_ net191 VGND VGND VPWR VPWR _02621_ sky130_fd_sc_hd__clkbuf_4
XFILLER_0_90_767 VGND VGND VPWR VPWR sky130_fd_sc_hd__fill_1
X_08167_ _02531_ _02543_ VGND VGND VPWR VPWR _02556_ sky130_fd_sc_hd__or2_1
X_08098_ net11 _02466_ _02428_ VGND VGND VPWR VPWR _02492_ sky130_fd_sc_hd__a21o_1
XFILLER_0_100_243 VGND VGND VPWR VPWR sky130_fd_sc_hd__fill_1
X_10060_ cpuregs\[24\]\[13\] cpuregs\[25\]\[13\] cpuregs\[26\]\[13\] cpuregs\[27\]\[13\]
+ _03831_ _03832_ VGND VGND VPWR VPWR _04283_ sky130_fd_sc_hd__mux4_1
X_13750_ _07013_ _07219_ VGND VGND VPWR VPWR _07220_ sky130_fd_sc_hd__and2_1
X_10962_ _05003_ net944 _05052_ VGND VGND VPWR VPWR _05062_ sky130_fd_sc_hd__mux2_1
X_12701_ count_cycle\[55\] count_cycle\[56\] count_cycle\[57\] count_cycle\[58\] VGND
+ VGND VPWR VPWR _06241_ sky130_fd_sc_hd__and4_1
X_13681_ _06457_ _07152_ VGND VGND VPWR VPWR _07153_ sky130_fd_sc_hd__and2_1
XFILLER_0_128_608 VGND VGND VPWR VPWR sky130_fd_sc_hd__decap_6
X_10893_ _03551_ VGND VGND VPWR VPWR _05018_ sky130_fd_sc_hd__clkbuf_4
X_15420_ clknet_leaf_15_clk _00070_ VGND VGND VPWR VPWR net182 sky130_fd_sc_hd__dfxtp_4
XFILLER_0_66_753 VGND VGND VPWR VPWR sky130_fd_sc_hd__decap_3
XFILLER_0_65_241 VGND VGND VPWR VPWR sky130_fd_sc_hd__decap_6
X_12632_ net435 VGND VGND VPWR VPWR _06191_ sky130_fd_sc_hd__inv_2
XFILLER_0_93_561 VGND VGND VPWR VPWR sky130_fd_sc_hd__fill_1
X_15351_ _02062_ VGND VGND VPWR VPWR _01528_ sky130_fd_sc_hd__clkbuf_1
XFILLER_0_53_425 VGND VGND VPWR VPWR sky130_fd_sc_hd__decap_4
X_12563_ count_cycle\[17\] count_cycle\[18\] count_cycle\[19\] _06135_ VGND VGND VPWR
+ VPWR _06142_ sky130_fd_sc_hd__and4_1
XFILLER_0_135_162 VGND VGND VPWR VPWR sky130_fd_sc_hd__decap_6
XFILLER_0_135_140 VGND VGND VPWR VPWR sky130_fd_sc_hd__fill_1
X_12494_ _05763_ net425 _05526_ _06093_ VGND VGND VPWR VPWR _00705_ sky130_fd_sc_hd__o211a_1
X_11514_ net1204 _05221_ _05360_ VGND VGND VPWR VPWR _05370_ sky130_fd_sc_hd__mux2_1
X_15282_ _02026_ VGND VGND VPWR VPWR _01495_ sky130_fd_sc_hd__clkbuf_1
X_14302_ _07569_ _07573_ _07581_ _07575_ net1199 VGND VGND VPWR VPWR _01004_ sky130_fd_sc_hd__o32a_1
XFILLER_0_53_447 VGND VGND VPWR VPWR sky130_fd_sc_hd__fill_1
X_11445_ _05333_ VGND VGND VPWR VPWR _00416_ sky130_fd_sc_hd__clkbuf_1
X_14233_ net601 net109 _07541_ VGND VGND VPWR VPWR _07542_ sky130_fd_sc_hd__mux2_1
XFILLER_0_33_182 VGND VGND VPWR VPWR sky130_fd_sc_hd__decap_8
X_14164_ _07502_ VGND VGND VPWR VPWR _00945_ sky130_fd_sc_hd__clkbuf_1
X_11376_ _05043_ net1408 _05288_ VGND VGND VPWR VPWR _05297_ sky130_fd_sc_hd__mux2_1
X_10327_ decoded_imm\[21\] net184 VGND VGND VPWR VPWR _04542_ sky130_fd_sc_hd__nor2_1
X_13115_ _06537_ _06601_ _06603_ VGND VGND VPWR VPWR _06604_ sky130_fd_sc_hd__a21o_1
XTAP_506 VGND VPWR sky130_fd_sc_hd__tapvpwrvgnd_1
X_14095_ is_alu_reg_imm _07333_ _07382_ instr_jalr VGND VGND VPWR VPWR _07466_ sky130_fd_sc_hd__a211o_1
X_10258_ _04473_ _04474_ VGND VGND VPWR VPWR _04475_ sky130_fd_sc_hd__or2b_1
X_13046_ _03346_ VGND VGND VPWR VPWR _06537_ sky130_fd_sc_hd__clkbuf_4
XTAP_517 VGND VPWR sky130_fd_sc_hd__tapvpwrvgnd_1
XTAP_528 VGND VPWR sky130_fd_sc_hd__tapvpwrvgnd_1
XTAP_539 VGND VPWR sky130_fd_sc_hd__tapvpwrvgnd_1
X_10189_ _02403_ _02445_ _02522_ _02480_ _03364_ _03651_ VGND VGND VPWR VPWR _04408_
+ sky130_fd_sc_hd__mux4_1
XFILLER_0_56_58 VGND VGND VPWR VPWR sky130_fd_sc_hd__fill_1
X_16805_ clknet_leaf_82_clk _01369_ VGND VGND VPWR VPWR cpuregs\[6\]\[20\] sky130_fd_sc_hd__dfxtp_1
X_14997_ _01877_ VGND VGND VPWR VPWR _01359_ sky130_fd_sc_hd__clkbuf_1
X_16736_ clknet_leaf_87_clk _01300_ VGND VGND VPWR VPWR cpuregs\[4\]\[15\] sky130_fd_sc_hd__dfxtp_1
X_13948_ instr_andi _07367_ _07350_ _07364_ VGND VGND VPWR VPWR _07378_ sky130_fd_sc_hd__a22o_1
XFILLER_0_76_539 VGND VGND VPWR VPWR sky130_fd_sc_hd__fill_1
XFILLER_0_72_79 VGND VGND VPWR VPWR sky130_fd_sc_hd__decap_4
X_16667_ clknet_leaf_100_clk _01234_ VGND VGND VPWR VPWR cpuregs\[29\]\[13\] sky130_fd_sc_hd__dfxtp_1
XFILLER_0_9_817 VGND VGND VPWR VPWR sky130_fd_sc_hd__fill_2
X_13879_ _02185_ _07330_ VGND VGND VPWR VPWR _07331_ sky130_fd_sc_hd__and2_1
XFILLER_0_29_422 VGND VGND VPWR VPWR sky130_fd_sc_hd__fill_1
X_15618_ clknet_leaf_142_clk _00268_ VGND VGND VPWR VPWR cpuregs\[31\]\[8\] sky130_fd_sc_hd__dfxtp_1
X_16598_ clknet_leaf_114_clk _01165_ VGND VGND VPWR VPWR cpuregs\[9\]\[8\] sky130_fd_sc_hd__dfxtp_1
XFILLER_0_72_701 VGND VGND VPWR VPWR sky130_fd_sc_hd__fill_1
X_15549_ clknet_leaf_121_clk _00199_ VGND VGND VPWR VPWR cpuregs\[2\]\[3\] sky130_fd_sc_hd__dfxtp_1
XFILLER_0_71_233 VGND VGND VPWR VPWR sky130_fd_sc_hd__fill_1
XFILLER_0_71_222 VGND VGND VPWR VPWR sky130_fd_sc_hd__fill_2
XFILLER_0_56_296 VPWR VGND VPWR VGND sky130_ef_sc_hd__decap_12
X_09070_ cpuregs\[20\]\[2\] cpuregs\[21\]\[2\] cpuregs\[22\]\[2\] cpuregs\[23\]\[2\]
+ _03313_ _03314_ VGND VGND VPWR VPWR _03351_ sky130_fd_sc_hd__mux4_1
XFILLER_0_16_149 VGND VGND VPWR VPWR sky130_fd_sc_hd__decap_3
XFILLER_0_126_195 VGND VGND VPWR VPWR sky130_fd_sc_hd__fill_1
X_08021_ _02197_ _02413_ _02415_ _02222_ _02419_ VGND VGND VPWR VPWR _07623_ sky130_fd_sc_hd__a221o_1
XFILLER_0_71_277 VGND VGND VPWR VPWR sky130_fd_sc_hd__decap_3
Xhold702 cpuregs\[24\]\[18\] VGND VGND VPWR VPWR net1060 sky130_fd_sc_hd__dlygate4sd3_1
XFILLER_0_12_300 VGND VGND VPWR VPWR sky130_fd_sc_hd__decap_4
Xhold724 cpuregs\[23\]\[28\] VGND VGND VPWR VPWR net1082 sky130_fd_sc_hd__dlygate4sd3_1
Xhold746 cpuregs\[21\]\[22\] VGND VGND VPWR VPWR net1104 sky130_fd_sc_hd__dlygate4sd3_1
XFILLER_0_97_65 VGND VGND VPWR VPWR sky130_fd_sc_hd__decap_8
Xhold735 _07603_ VGND VGND VPWR VPWR net1093 sky130_fd_sc_hd__dlygate4sd3_1
Xhold713 cpuregs\[23\]\[14\] VGND VGND VPWR VPWR net1071 sky130_fd_sc_hd__dlygate4sd3_1
XFILLER_0_24_193 VGND VGND VPWR VPWR sky130_fd_sc_hd__decap_3
Xhold768 cpuregs\[22\]\[22\] VGND VGND VPWR VPWR net1126 sky130_fd_sc_hd__dlygate4sd3_1
Xhold757 cpuregs\[23\]\[13\] VGND VGND VPWR VPWR net1115 sky130_fd_sc_hd__dlygate4sd3_1
X_09972_ _03723_ _04196_ _03675_ VGND VGND VPWR VPWR _04197_ sky130_fd_sc_hd__a21o_1
Xhold779 cpuregs\[24\]\[0\] VGND VGND VPWR VPWR net1137 sky130_fd_sc_hd__dlygate4sd3_1
X_08923_ reg_out\[8\] reg_next_pc\[8\] _03225_ VGND VGND VPWR VPWR _03239_ sky130_fd_sc_hd__mux2_1
XFILLER_0_0_783 VGND VGND VPWR VPWR sky130_fd_sc_hd__fill_1
XFILLER_0_41_3 VGND VGND VPWR VPWR sky130_fd_sc_hd__fill_2
X_08854_ _02224_ _03202_ _02219_ VGND VGND VPWR VPWR net131 sky130_fd_sc_hd__o21ai_4
X_08785_ _03139_ _03140_ VGND VGND VPWR VPWR _03141_ sky130_fd_sc_hd__xnor2_1
X_07805_ mem_wordsize\[2\] _02143_ VGND VGND VPWR VPWR _02218_ sky130_fd_sc_hd__or2_1
XFILLER_0_137_93 VPWR VGND VPWR VGND sky130_ef_sc_hd__decap_12
X_07736_ reg_sh\[1\] reg_sh\[0\] VGND VGND VPWR VPWR _02157_ sky130_fd_sc_hd__or2_2
XFILLER_0_39_208 VGND VGND VPWR VPWR sky130_fd_sc_hd__decap_6
X_07667_ _02095_ instr_lw _02096_ VGND VGND VPWR VPWR _02097_ sky130_fd_sc_hd__or3b_1
X_09406_ reg_out\[31\] alu_out_q\[31\] _03437_ VGND VGND VPWR VPWR _03643_ sky130_fd_sc_hd__mux2_1
X_09337_ _03583_ VGND VGND VPWR VPWR _03584_ sky130_fd_sc_hd__clkbuf_4
XFILLER_0_75_572 VGND VGND VPWR VPWR sky130_fd_sc_hd__fill_1
X_09268_ _03434_ _03521_ _03522_ _03523_ VGND VGND VPWR VPWR _03524_ sky130_fd_sc_hd__a22o_2
X_08219_ net190 VGND VGND VPWR VPWR _02605_ sky130_fd_sc_hd__clkbuf_4
X_09199_ _03463_ VGND VGND VPWR VPWR _03464_ sky130_fd_sc_hd__buf_2
XFILLER_0_120_316 VGND VGND VPWR VPWR sky130_fd_sc_hd__decap_4
X_11230_ _05216_ VGND VGND VPWR VPWR _00318_ sky130_fd_sc_hd__clkbuf_1
X_11161_ net817 _05169_ _05161_ VGND VGND VPWR VPWR _05170_ sky130_fd_sc_hd__mux2_1
XFILLER_0_30_141 VGND VGND VPWR VPWR sky130_fd_sc_hd__fill_1
XFILLER_0_101_552 VGND VGND VPWR VPWR sky130_fd_sc_hd__fill_2
X_10112_ cpuregs\[12\]\[15\] cpuregs\[13\]\[15\] _03749_ VGND VGND VPWR VPWR _04333_
+ sky130_fd_sc_hd__mux2_1
XFILLER_0_101_585 VGND VGND VPWR VPWR sky130_fd_sc_hd__decap_4
X_11092_ net1289 _03484_ _05124_ VGND VGND VPWR VPWR _05131_ sky130_fd_sc_hd__mux2_1
X_10043_ cpuregs\[12\]\[13\] cpuregs\[13\]\[13\] _03767_ VGND VGND VPWR VPWR _04266_
+ sky130_fd_sc_hd__mux2_1
X_14920_ _01836_ VGND VGND VPWR VPWR _01323_ sky130_fd_sc_hd__clkbuf_1
Xhold40 count_instr\[59\] VGND VGND VPWR VPWR net398 sky130_fd_sc_hd__dlygate4sd3_1
Xhold62 reg_next_pc\[17\] VGND VGND VPWR VPWR net420 sky130_fd_sc_hd__dlygate4sd3_1
Xhold73 reg_next_pc\[4\] VGND VGND VPWR VPWR net431 sky130_fd_sc_hd__dlygate4sd3_1
Xhold51 count_cycle\[60\] VGND VGND VPWR VPWR net409 sky130_fd_sc_hd__dlygate4sd3_1
X_14851_ _03484_ net1054 _01793_ VGND VGND VPWR VPWR _01800_ sky130_fd_sc_hd__mux2_1
Xhold84 reg_next_pc\[31\] VGND VGND VPWR VPWR net442 sky130_fd_sc_hd__dlygate4sd3_1
X_13802_ cpuregs\[0\]\[31\] cpuregs\[1\]\[31\] cpuregs\[2\]\[31\] cpuregs\[3\]\[31\]
+ _06344_ _06345_ VGND VGND VPWR VPWR _07270_ sky130_fd_sc_hd__mux4_1
Xhold95 count_cycle\[27\] VGND VGND VPWR VPWR net453 sky130_fd_sc_hd__dlygate4sd3_1
X_11994_ count_instr\[53\] _05660_ VGND VGND VPWR VPWR _05665_ sky130_fd_sc_hd__or2_1
X_14782_ net1004 _05173_ _01756_ VGND VGND VPWR VPWR _01763_ sky130_fd_sc_hd__mux2_1
X_16521_ clknet_leaf_2_clk _01098_ VGND VGND VPWR VPWR mem_rdata_q\[5\] sky130_fd_sc_hd__dfxtp_1
XFILLER_0_133_18 VGND VGND VPWR VPWR sky130_fd_sc_hd__fill_1
X_13733_ cpuregs\[8\]\[29\] cpuregs\[9\]\[29\] _03343_ VGND VGND VPWR VPWR _07203_
+ sky130_fd_sc_hd__mux2_1
XFILLER_0_58_528 VGND VGND VPWR VPWR sky130_fd_sc_hd__decap_4
X_10945_ _05053_ VGND VGND VPWR VPWR _00196_ sky130_fd_sc_hd__clkbuf_1
X_13664_ cpuregs\[30\]\[26\] cpuregs\[31\]\[26\] _06510_ VGND VGND VPWR VPWR _07137_
+ sky130_fd_sc_hd__mux2_1
X_10876_ _05005_ net764 _05006_ VGND VGND VPWR VPWR _05007_ sky130_fd_sc_hd__mux2_1
X_16452_ clknet_leaf_142_clk _01034_ VGND VGND VPWR VPWR cpuregs\[18\]\[5\] sky130_fd_sc_hd__dfxtp_1
XFILLER_0_42_38 VGND VGND VPWR VPWR sky130_fd_sc_hd__fill_1
X_16383_ clknet_leaf_43_clk _00965_ VGND VGND VPWR VPWR net136 sky130_fd_sc_hd__dfxtp_1
X_15403_ clknet_leaf_78_clk _00058_ VGND VGND VPWR VPWR cpuregs\[11\]\[21\] sky130_fd_sc_hd__dfxtp_1
XFILLER_0_6_809 VGND VGND VPWR VPWR sky130_fd_sc_hd__decap_3
X_12615_ net34 VGND VGND VPWR VPWR _06179_ sky130_fd_sc_hd__clkbuf_4
X_13595_ _06962_ _07062_ _07069_ VGND VGND VPWR VPWR _07070_ sky130_fd_sc_hd__or3_2
X_15334_ _03519_ net681 _02052_ VGND VGND VPWR VPWR _02054_ sky130_fd_sc_hd__mux2_1
X_12546_ _06130_ VGND VGND VPWR VPWR _00720_ sky130_fd_sc_hd__clkbuf_1
X_12477_ _06075_ _06076_ _06077_ VGND VGND VPWR VPWR _06078_ sky130_fd_sc_hd__o21a_1
XFILLER_0_123_121 VPWR VGND VPWR VGND sky130_ef_sc_hd__decap_12
XFILLER_0_108_195 VGND VGND VPWR VPWR sky130_fd_sc_hd__fill_1
X_15265_ net532 VGND VGND VPWR VPWR _02018_ sky130_fd_sc_hd__buf_1
X_14216_ net525 net100 _07530_ VGND VGND VPWR VPWR _07533_ sky130_fd_sc_hd__mux2_1
X_11428_ net1326 _05202_ _05324_ VGND VGND VPWR VPWR _05325_ sky130_fd_sc_hd__mux2_1
XANTENNA_4 _02458_ VGND VGND VPWR VPWR sky130_fd_sc_hd__diode_2
X_15196_ _01982_ VGND VGND VPWR VPWR _01453_ sky130_fd_sc_hd__clkbuf_1
X_14147_ _05026_ net1201 _07493_ VGND VGND VPWR VPWR _07494_ sky130_fd_sc_hd__mux2_1
X_11359_ _05265_ VGND VGND VPWR VPWR _05288_ sky130_fd_sc_hd__buf_4
XFILLER_0_6_38 VGND VGND VPWR VPWR sky130_fd_sc_hd__fill_2
XFILLER_0_22_697 VGND VGND VPWR VPWR sky130_fd_sc_hd__decap_3
XFILLER_0_67_46 VGND VGND VPWR VPWR sky130_fd_sc_hd__fill_1
XTAP_314 VGND VPWR sky130_fd_sc_hd__tapvpwrvgnd_1
XTAP_303 VGND VPWR sky130_fd_sc_hd__tapvpwrvgnd_1
XFILLER_0_21_196 VGND VGND VPWR VPWR sky130_fd_sc_hd__fill_1
X_14078_ _07455_ VGND VGND VPWR VPWR _00906_ sky130_fd_sc_hd__clkbuf_1
XFILLER_0_67_68 VGND VGND VPWR VPWR sky130_fd_sc_hd__fill_2
XTAP_358 VGND VPWR sky130_fd_sc_hd__tapvpwrvgnd_1
XTAP_347 VGND VPWR sky130_fd_sc_hd__tapvpwrvgnd_1
XTAP_336 VGND VPWR sky130_fd_sc_hd__tapvpwrvgnd_1
XTAP_325 VGND VPWR sky130_fd_sc_hd__tapvpwrvgnd_1
XTAP_369 VGND VPWR sky130_fd_sc_hd__tapvpwrvgnd_1
X_13029_ cpuregs\[20\]\[7\] cpuregs\[21\]\[7\] _06448_ VGND VGND VPWR VPWR _06521_
+ sky130_fd_sc_hd__mux2_1
X_08570_ _02838_ VGND VGND VPWR VPWR _02942_ sky130_fd_sc_hd__clkbuf_4
Xrebuffer16 net375 VGND VGND VPWR VPWR net374 sky130_fd_sc_hd__clkbuf_1
XFILLER_0_107_74 VGND VGND VPWR VPWR sky130_fd_sc_hd__decap_4
XFILLER_0_13_7 VGND VGND VPWR VPWR sky130_fd_sc_hd__fill_1
XFILLER_0_88_174 VGND VGND VPWR VPWR sky130_fd_sc_hd__fill_2
X_16719_ clknet_leaf_13_clk _00025_ VGND VGND VPWR VPWR mem_wordsize\[1\] sky130_fd_sc_hd__dfxtp_1
XFILLER_0_119_416 VGND VGND VPWR VPWR sky130_fd_sc_hd__decap_4
XFILLER_0_119_405 VGND VGND VPWR VPWR sky130_fd_sc_hd__decap_8
XFILLER_0_91_306 VGND VGND VPWR VPWR sky130_fd_sc_hd__fill_2
XFILLER_0_8_179 VGND VGND VPWR VPWR sky130_fd_sc_hd__decap_3
X_09122_ cpuregs\[8\]\[4\] cpuregs\[9\]\[4\] cpuregs\[10\]\[4\] cpuregs\[11\]\[4\]
+ _03323_ _03400_ VGND VGND VPWR VPWR _03401_ sky130_fd_sc_hd__mux4_1
XFILLER_0_29_274 VGND VGND VPWR VPWR sky130_fd_sc_hd__decap_6
XFILLER_0_25_480 VGND VGND VPWR VPWR sky130_fd_sc_hd__fill_1
X_09053_ _03309_ _03316_ _03320_ _03327_ _03333_ VGND VGND VPWR VPWR _03334_ sky130_fd_sc_hd__a32o_1
X_08004_ _02213_ _02133_ net22 _02210_ net5 VGND VGND VPWR VPWR _02404_ sky130_fd_sc_hd__a32o_1
Xhold510 cpuregs\[10\]\[17\] VGND VGND VPWR VPWR net868 sky130_fd_sc_hd__dlygate4sd3_1
XFILLER_0_4_385 VGND VGND VPWR VPWR sky130_fd_sc_hd__fill_1
XFILLER_0_130_658 VGND VGND VPWR VPWR sky130_fd_sc_hd__fill_2
Xhold554 cpuregs\[19\]\[19\] VGND VGND VPWR VPWR net912 sky130_fd_sc_hd__dlygate4sd3_1
Xhold521 decoded_imm\[26\] VGND VGND VPWR VPWR net879 sky130_fd_sc_hd__dlygate4sd3_1
Xhold543 cpuregs\[16\]\[17\] VGND VGND VPWR VPWR net901 sky130_fd_sc_hd__dlygate4sd3_1
XFILLER_0_12_141 VGND VGND VPWR VPWR sky130_fd_sc_hd__fill_1
Xhold532 cpuregs\[11\]\[8\] VGND VGND VPWR VPWR net890 sky130_fd_sc_hd__dlygate4sd3_1
Xhold576 reg_pc\[28\] VGND VGND VPWR VPWR net934 sky130_fd_sc_hd__dlygate4sd3_1
Xhold587 cpuregs\[10\]\[25\] VGND VGND VPWR VPWR net945 sky130_fd_sc_hd__dlygate4sd3_1
Xhold565 cpuregs\[7\]\[0\] VGND VGND VPWR VPWR net923 sky130_fd_sc_hd__dlygate4sd3_1
XFILLER_0_110_371 VGND VGND VPWR VPWR sky130_fd_sc_hd__fill_1
X_09955_ _04177_ _04178_ _04179_ _04180_ _04030_ _04103_ VGND VGND VPWR VPWR _04181_
+ sky130_fd_sc_hd__mux4_1
Xhold598 cpuregs\[23\]\[7\] VGND VGND VPWR VPWR net956 sky130_fd_sc_hd__dlygate4sd3_1
X_09886_ _04111_ _04112_ VGND VGND VPWR VPWR _04113_ sky130_fd_sc_hd__nand2_1
X_08906_ _02243_ _03226_ _03227_ VGND VGND VPWR VPWR _03228_ sky130_fd_sc_hd__mux2_1
XTAP_870 VGND VPWR sky130_fd_sc_hd__tapvpwrvgnd_1
Xhold1221 cpuregs\[17\]\[27\] VGND VGND VPWR VPWR net1579 sky130_fd_sc_hd__dlygate4sd3_1
X_08837_ net224 net223 _03169_ _02934_ VGND VGND VPWR VPWR _03188_ sky130_fd_sc_hd__o31a_1
Xhold1232 decoded_imm\[13\] VGND VGND VPWR VPWR net1590 sky130_fd_sc_hd__dlygate4sd3_1
Xhold1210 decoded_imm\[27\] VGND VGND VPWR VPWR net1568 sky130_fd_sc_hd__dlygate4sd3_1
Xhold1243 cpuregs\[1\]\[4\] VGND VGND VPWR VPWR net1601 sky130_fd_sc_hd__dlygate4sd3_1
XTAP_881 VGND VPWR sky130_fd_sc_hd__tapvpwrvgnd_1
XTAP_892 VGND VPWR sky130_fd_sc_hd__tapvpwrvgnd_1
Xhold1276 cpuregs\[9\]\[15\] VGND VGND VPWR VPWR net1634 sky130_fd_sc_hd__dlygate4sd3_1
Xhold1265 reg_pc\[8\] VGND VGND VPWR VPWR net1623 sky130_fd_sc_hd__dlygate4sd3_1
Xhold1254 cpuregs\[17\]\[1\] VGND VGND VPWR VPWR net1612 sky130_fd_sc_hd__dlygate4sd3_1
X_08768_ _03094_ _03119_ _03120_ _03122_ _03124_ VGND VGND VPWR VPWR _03125_ sky130_fd_sc_hd__o221a_1
Xhold1298 decoded_imm\[29\] VGND VGND VPWR VPWR net1656 sky130_fd_sc_hd__dlygate4sd3_1
Xhold1287 count_cycle\[35\] VGND VGND VPWR VPWR net1645 sky130_fd_sc_hd__dlygate4sd3_1
X_08699_ _02712_ _03054_ _03060_ _03020_ VGND VGND VPWR VPWR alu_out\[19\] sky130_fd_sc_hd__a22o_1
XFILLER_0_67_325 VGND VGND VPWR VPWR sky130_fd_sc_hd__decap_6
X_07719_ _02096_ _02094_ _02099_ instr_sb VGND VGND VPWR VPWR _02144_ sky130_fd_sc_hd__a22o_1
X_10730_ net804 _03532_ _04918_ VGND VGND VPWR VPWR _04922_ sky130_fd_sc_hd__mux2_1
X_10661_ _04867_ _02632_ _03714_ VGND VGND VPWR VPWR _04868_ sky130_fd_sc_hd__mux2_1
XFILLER_0_94_177 VGND VGND VPWR VPWR sky130_fd_sc_hd__fill_1
X_12400_ _05743_ _06000_ VGND VGND VPWR VPWR _06008_ sky130_fd_sc_hd__nand2_1
X_10592_ cpuregs\[8\]\[28\] cpuregs\[9\]\[28\] cpuregs\[10\]\[28\] cpuregs\[11\]\[28\]
+ _03831_ _03726_ VGND VGND VPWR VPWR _04800_ sky130_fd_sc_hd__mux4_1
X_13380_ _06751_ _06857_ _06861_ _06798_ VGND VGND VPWR VPWR _06862_ sky130_fd_sc_hd__o211a_1
XFILLER_0_35_244 VGND VGND VPWR VPWR sky130_fd_sc_hd__decap_4
XFILLER_0_133_452 VGND VGND VPWR VPWR sky130_fd_sc_hd__fill_1
X_12331_ _05802_ _05935_ _05728_ VGND VGND VPWR VPWR _05944_ sky130_fd_sc_hd__a21oi_1
XFILLER_0_51_737 VGND VGND VPWR VPWR sky130_fd_sc_hd__fill_1
XFILLER_0_121_603 VGND VGND VPWR VPWR sky130_fd_sc_hd__fill_2
XFILLER_0_105_165 VGND VGND VPWR VPWR sky130_fd_sc_hd__decap_3
X_12262_ _05879_ _05880_ VGND VGND VPWR VPWR _05881_ sky130_fd_sc_hd__and2_1
X_15050_ _01905_ VGND VGND VPWR VPWR _01384_ sky130_fd_sc_hd__clkbuf_1
XFILLER_0_121_636 VGND VGND VPWR VPWR sky130_fd_sc_hd__fill_1
X_11213_ _03583_ VGND VGND VPWR VPWR _05205_ sky130_fd_sc_hd__buf_4
X_14001_ mem_rdata_q\[4\] mem_rdata_q\[5\] mem_rdata_q\[6\] _07415_ VGND VGND VPWR
+ VPWR _07416_ sky130_fd_sc_hd__and4_1
Xoutput52 net52 VGND VGND VPWR VPWR mem_addr[27] sky130_fd_sc_hd__clkbuf_4
X_12193_ _05704_ _05813_ VGND VGND VPWR VPWR _05817_ sky130_fd_sc_hd__and2b_1
Xoutput41 net41 VGND VGND VPWR VPWR mem_addr[16] sky130_fd_sc_hd__clkbuf_4
Xoutput85 net85 VGND VGND VPWR VPWR mem_la_addr[29] sky130_fd_sc_hd__clkbuf_4
X_11144_ net1382 _03646_ _05123_ VGND VGND VPWR VPWR _05158_ sky130_fd_sc_hd__mux2_1
Xoutput74 net74 VGND VGND VPWR VPWR mem_la_addr[18] sky130_fd_sc_hd__clkbuf_4
Xoutput63 net63 VGND VGND VPWR VPWR mem_addr[8] sky130_fd_sc_hd__clkbuf_4
X_11075_ _05121_ VGND VGND VPWR VPWR _00258_ sky130_fd_sc_hd__clkbuf_1
X_15952_ clknet_leaf_153_clk _00602_ VGND VGND VPWR VPWR count_instr\[21\] sky130_fd_sc_hd__dfxtp_1
Xoutput96 net96 VGND VGND VPWR VPWR mem_la_read sky130_fd_sc_hd__clkbuf_4
X_14903_ _03646_ net1242 _01792_ VGND VGND VPWR VPWR _01827_ sky130_fd_sc_hd__mux2_1
X_10026_ cpuregs\[20\]\[12\] cpuregs\[21\]\[12\] cpuregs\[22\]\[12\] cpuregs\[23\]\[12\]
+ _04100_ _03939_ VGND VGND VPWR VPWR _04250_ sky130_fd_sc_hd__mux4_1
X_15883_ clknet_leaf_96_clk _00533_ VGND VGND VPWR VPWR cpuregs\[20\]\[17\] sky130_fd_sc_hd__dfxtp_1
X_14834_ net1251 _05225_ net237 VGND VGND VPWR VPWR _01790_ sky130_fd_sc_hd__mux2_1
X_14765_ _01753_ VGND VGND VPWR VPWR _01251_ sky130_fd_sc_hd__clkbuf_1
X_11977_ count_instr\[49\] count_instr\[48\] VGND VGND VPWR VPWR _05652_ sky130_fd_sc_hd__and2_1
X_16504_ clknet_leaf_64_clk _01086_ VGND VGND VPWR VPWR cpuregs\[19\]\[25\] sky130_fd_sc_hd__dfxtp_1
X_13716_ cpuregs\[16\]\[28\] cpuregs\[17\]\[28\] cpuregs\[18\]\[28\] cpuregs\[19\]\[28\]
+ _06945_ _06979_ VGND VGND VPWR VPWR _07187_ sky130_fd_sc_hd__mux4_1
X_10928_ _05041_ net1604 _05027_ VGND VGND VPWR VPWR _05042_ sky130_fd_sc_hd__mux2_1
X_14696_ net971 _05223_ _01683_ VGND VGND VPWR VPWR _01717_ sky130_fd_sc_hd__mux2_1
XFILLER_0_85_177 VGND VGND VPWR VPWR sky130_fd_sc_hd__decap_3
XFILLER_0_85_166 VGND VGND VPWR VPWR sky130_fd_sc_hd__fill_2
X_16435_ clknet_leaf_25_clk _01017_ VGND VGND VPWR VPWR decoded_imm\[12\] sky130_fd_sc_hd__dfxtp_2
XFILLER_0_116_419 VGND VGND VPWR VPWR sky130_fd_sc_hd__fill_1
X_13647_ _06866_ _07115_ _07119_ _06873_ VGND VGND VPWR VPWR _07120_ sky130_fd_sc_hd__o211a_1
X_10859_ _03477_ VGND VGND VPWR VPWR _04995_ sky130_fd_sc_hd__clkbuf_4
X_13578_ _06780_ _07043_ _07047_ _07053_ _06800_ VGND VGND VPWR VPWR _07054_ sky130_fd_sc_hd__a311o_1
XPHY_191 VGND VGND VPWR VPWR sky130_fd_sc_hd__decap_3
XPHY_180 VGND VGND VPWR VPWR sky130_fd_sc_hd__decap_3
X_16366_ clknet_leaf_99_clk _00948_ VGND VGND VPWR VPWR cpuregs\[1\]\[31\] sky130_fd_sc_hd__dfxtp_1
XFILLER_0_54_586 VGND VGND VPWR VPWR sky130_fd_sc_hd__fill_2
X_12529_ net411 _06114_ _06117_ VGND VGND VPWR VPWR _00716_ sky130_fd_sc_hd__a21oi_1
X_15317_ _03464_ net648 _02041_ VGND VGND VPWR VPWR _02045_ sky130_fd_sc_hd__mux2_1
X_16297_ clknet_leaf_3_clk _00882_ VGND VGND VPWR VPWR instr_rdcycleh sky130_fd_sc_hd__dfxtp_2
X_15248_ _02009_ VGND VGND VPWR VPWR _01478_ sky130_fd_sc_hd__clkbuf_1
XFILLER_0_111_124 VGND VGND VPWR VPWR sky130_fd_sc_hd__decap_4
X_15179_ _03440_ net610 _01973_ VGND VGND VPWR VPWR _01974_ sky130_fd_sc_hd__mux2_1
X_09740_ _03658_ VGND VGND VPWR VPWR _03971_ sky130_fd_sc_hd__clkbuf_8
.ends
